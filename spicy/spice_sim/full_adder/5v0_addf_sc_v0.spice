* NGSPICE file created from 5v0_addf_sc.ext - technology: gf180mcuD

.option scale=5n

X0 5v0_addh_sc_0/pti in_A VSS VSS nfet_06v0 ad=6.336n pd=0.32m as=6.478n ps=0.255m w=72 l=578
X1 VDD_3V3 in_A 5v0_addh_sc_0/pti VDD_3V3 pfet_06v0 ad=12.81n pd=0.349m as=12.688n ps=0.348m w=244 l=100
X2 VDD_3V3 in_A 5v0_addh_sc_0/nti VDD_3V3 pfet_06v0 ad=13.616n pd=0.392m as=9.696n ps=0.394m w=96 l=150
X3 VSS in_A 5v0_addh_sc_0/nti VSS nfet_06v0 ad=6.478n pd=0.255m as=12.7n ps=0.454m w=127 l=120
X4 5v0_addh_sc_0/pti in_A VDD_3V3 VDD_3V3 pfet_06v0 ad=12.688n pd=0.348m as=13.616n ps=0.392m w=244 l=100
X5 5v0_addh_sc_0/pti in_A VDD_3V3 VDD_3V3 pfet_06v0 ad=27.328n pd=0.712m as=12.81n ps=0.349m w=244 l=100
X6 5v0_addh_sc_0/5v0_half_adder_selector_sc_0/res_stage0 5v0_addh_sc_0/m1_103_293# 5v0_addh_sc_0/downstepper_test VSS nfet_06v0 ad=14.432n pd=0.504m as=14.432n ps=0.504m w=164 l=120
X7 5v0_addh_sc_0/5v0_half_adder_selector_sc_0/res_stage0 5v0_addh_sc_0/m1_103_293# 5v0_addh_sc_0/upstepper_test VDD_3V3 pfet_06v0 ad=21.472n pd=0.664m as=21.472n ps=0.664m w=244 l=100
X8 5v0_addh_sc_0/m1_103_293# in_C_sign VSS VSS nfet_06v0 ad=14.432n pd=0.504m as=14.432n ps=0.504m w=164 l=120
X9 5v0_addh_sc_0/m1_103_293# in_C_sign VDD_3V3 VDD_3V3 pfet_06v0 ad=21.472n pd=0.664m as=21.472n ps=0.664m w=244 l=100
X10 5v0_addh_sc_0/5v0_half_adder_selector_sc_0/res_stage0 in_C_sign 5v0_addh_sc_0/upstepper_test VSS nfet_06v0 ad=31.489n pd=1.041m as=43.711n ps=1.504m w=164 l=120
X11 5v0_addh_sc_0/5v0_half_adder_selector_sc_0/res_stage0 in_C_sign 5v0_addh_sc_0/downstepper_test VDD_3V3 pfet_06v0 ad=46.849n pd=1.361m as=42.856n ps=1.326m w=244 l=100
X12 5v0_nter2oter_code_sc_0/in 5v0_addh_sc_0/a_382_n1095# 5v0_addh_sc_0/5v0_half_adder_selector_sc_0/res_stage0 VSS nfet_06v0 ad=17.057n pd=0.537m as=0 ps=0 w=164 l=120
X13 5v0_nter2oter_code_sc_0/in 5v0_addh_sc_0/a_382_n1095# in_A VDD_3V3 pfet_06v0 ad=25.377n pd=0.697m as=21.472n ps=0.664m w=244 l=100
X14 5v0_addh_sc_0/a_382_n1095# in_C_over VSS VSS nfet_06v0 ad=14.432n pd=0.504m as=0.28345u ps=0.01012 w=164 l=120
X15 5v0_addh_sc_0/a_382_n1095# in_C_over VDD_3V3 VDD_3V3 pfet_06v0 ad=21.472n pd=0.664m as=0.55101u ps=0.0163 w=244 l=100
X16 5v0_nter2oter_code_sc_0/in in_C_over in_A VSS nfet_06v0 ad=0 pd=0 as=14.432n ps=0.504m w=164 l=120
X17 5v0_nter2oter_code_sc_0/in in_C_over 5v0_addh_sc_0/5v0_half_adder_selector_sc_0/res_stage0 VDD_3V3 pfet_06v0 ad=0 pd=0 as=0 ps=0 w=244 l=100
X18 5v0_addh_sc_0/inv_pti 5v0_addh_sc_0/pti VSS VSS nfet_06v0 ad=14.432n pd=0.504m as=14.432n ps=0.504m w=164 l=120
X19 5v0_addh_sc_0/inv_pti 5v0_addh_sc_0/pti VDD_3V3 VDD_3V3 pfet_06v0 ad=21.472n pd=0.664m as=21.472n ps=0.664m w=244 l=100
X20 5v0_addh_sc_0/carry_0_probe 5v0_addh_sc_0/a_382_n1095# 5v0_addh_sc_0/m1_843_n857# VSS nfet_06v0 ad=14.432n pd=0.504m as=14.432n ps=0.504m w=164 l=120
X21 5v0_addh_sc_0/carry_0_probe in_C_over 5v0_addh_sc_0/m1_843_n857# VDD_3V3 pfet_06v0 ad=21.472n pd=0.664m as=21.472n ps=0.664m w=244 l=100
X22 5v0_addh_sc_0/inv_nti in_C_sign 5v0_addh_sc_0/carry_sign_probe VDD_3V3 pfet_06v0 ad=21.472n pd=0.664m as=12.688n ps=0.348m w=244 l=100
X23 5v0_addh_sc_0/carry_sign_probe 5v0_addh_sc_0/m1_103_293# 5v0_addh_sc_0/inv_nti VSS nfet_06v0 ad=8.528n pd=0.268m as=14.432n ps=0.504m w=164 l=120
X24 5v0_addh_sc_0/carry_sign_probe 5v0_addh_sc_0/m1_103_293# 5v0_addh_sc_0/inv_pti VDD_3V3 pfet_06v0 ad=12.688n pd=0.348m as=21.472n ps=0.664m w=244 l=100
X25 5v0_addh_sc_0/inv_pti in_C_sign 5v0_addh_sc_0/carry_sign_probe VSS nfet_06v0 ad=14.432n pd=0.504m as=8.528n ps=0.268m w=164 l=120
X26 5v0_addh_sc_0/inv_nti in_C_sign 5v0_addh_sc_0/m1_843_n857# VDD_3V3 pfet_06v0 ad=64.416n pd=1.992m as=46.848n ps=1.36m w=244 l=100
X27 5v0_addh_sc_0/m1_843_n857# 5v0_addh_sc_0/m1_103_293# 5v0_addh_sc_0/inv_nti VSS nfet_06v0 ad=31.488n pd=1.04m as=43.296n ps=1.512m w=164 l=120
X28 5v0_addh_sc_0/m1_843_n857# 5v0_addh_sc_0/m1_103_293# 5v0_addh_sc_0/pti VDD_3V3 pfet_06v0 ad=0 pd=0 as=74.176n ps=2.072m w=244 l=100
X29 5v0_addh_sc_0/pti in_C_sign 5v0_addh_sc_0/m1_843_n857# VSS nfet_06v0 ad=20.768n pd=0.824m as=0 ps=0 w=164 l=120
X30 5v0_addh_sc_0/a_n1373_n454# 5v0_addh_sc_0/inv_nti 5v0_addh_sc_0/downstepper_test VSS nfet_06v0 ad=3.528n pd=0.195m as=8.599n ps=0.264m w=147 l=120
X31 5v0_addh_sc_0/upstepper_test 5v0_addh_sc_0/nti 5v0_addh_sc_0/a_n1205_n937# VDD_3V3 pfet_06v0 ad=21.384n pd=0.662m as=5.832n ps=0.291m w=243 l=100
X32 5v0_addh_sc_0/inv_nti 5v0_addh_sc_0/nti VDD_3V3 VDD_3V3 pfet_06v0 ad=21.472n pd=0.664m as=21.472n ps=0.664m w=244 l=100
X33 5v0_addh_sc_0/upstepper_test 5v0_addh_sc_0/nti 5v0_addh_sc_0/VDD_1V65 VSS nfet_06v0 ad=14.847n pd=0.496m as=10.51n ps=0.29m w=147 l=120
X34 5v0_addh_sc_0/carry_0_probe 5v0_addh_sc_0/a_382_n1095# VDD_3V3 VDD_3V3 pfet_06v0 ad=21.472n pd=0.664m as=21.472n ps=0.664m w=244 l=100
X35 5v0_addh_sc_0/a_n1205_n937# 5v0_addh_sc_0/inv_pti VDD_3V3 VDD_3V3 pfet_06v0 ad=5.832n pd=0.291m as=21.384n ps=0.662m w=243 l=100
X36 5v0_addh_sc_0/downstepper_test 5v0_addh_sc_0/pti 5v0_addh_sc_0/a_n1778_n454# VSS nfet_06v0 ad=8.599n pd=0.264m as=3.528n ps=0.195m w=147 l=120
X37 5v0_addh_sc_0/inv_nti 5v0_addh_sc_0/nti VSS VSS nfet_06v0 ad=14.432n pd=0.504m as=14.432n ps=0.504m w=164 l=120
X38 5v0_addh_sc_0/a_n1778_n454# 5v0_addh_sc_0/inv_nti VSS VSS nfet_06v0 ad=3.528n pd=0.195m as=14.847n ps=0.496m w=147 l=120
X39 5v0_addh_sc_0/upstepper_test 5v0_addh_sc_0/inv_pti VSS VSS nfet_06v0 ad=14.432n pd=0.504m as=14.432n ps=0.504m w=164 l=120
X40 5v0_addh_sc_0/VDD_1V65 5v0_addh_sc_0/inv_pti 5v0_addh_sc_0/a_n1373_n454# VSS nfet_06v0 ad=10.51n pd=0.29m as=3.528n ps=0.195m w=147 l=120
X41 5v0_addh_sc_0/downstepper_test 5v0_addh_sc_0/inv_nti VDD_3V3 VDD_3V3 pfet_06v0 ad=21.384n pd=0.662m as=21.384n ps=0.662m w=243 l=100
X42 5v0_addh_sc_1/pti in_B VSS VSS nfet_06v0 ad=20.768n pd=0.824m as=0 ps=0 w=72 l=578
X43 VDD_3V3 in_B 5v0_addh_sc_1/pti VDD_3V3 pfet_06v0 ad=0 pd=0 as=74.176n ps=2.072m w=244 l=100
X44 VDD_3V3 in_B 5v0_addh_sc_1/nti VDD_3V3 pfet_06v0 ad=0 pd=0 as=9.696n ps=0.394m w=96 l=150
X45 VSS in_B 5v0_addh_sc_1/nti VSS nfet_06v0 ad=0 pd=0 as=12.7n ps=0.454m w=127 l=120
X46 5v0_addh_sc_1/pti in_B VDD_3V3 VDD_3V3 pfet_06v0 ad=0 pd=0 as=0 ps=0 w=244 l=100
X47 5v0_addh_sc_1/pti in_B VDD_3V3 VDD_3V3 pfet_06v0 ad=0 pd=0 as=0 ps=0 w=244 l=100
X48 5v0_addh_sc_1/5v0_half_adder_selector_sc_0/res_stage0 5v0_addh_sc_1/m1_103_293# 5v0_addh_sc_1/downstepper_test VSS nfet_06v0 ad=31.489n pd=1.041m as=31.631n ps=1.032m w=164 l=120
X49 5v0_addh_sc_1/5v0_half_adder_selector_sc_0/res_stage0 5v0_addh_sc_1/m1_103_293# 5v0_addh_sc_1/upstepper_test VDD_3V3 pfet_06v0 ad=46.849n pd=1.361m as=42.856n ps=1.326m w=244 l=100
X50 5v0_addh_sc_1/m1_103_293# 5v0_addh_sc_1/ctrl_sign VSS VSS nfet_06v0 ad=14.432n pd=0.504m as=0 ps=0 w=164 l=120
X51 5v0_addh_sc_1/m1_103_293# 5v0_addh_sc_1/ctrl_sign VDD_3V3 VDD_3V3 pfet_06v0 ad=21.472n pd=0.664m as=0 ps=0 w=244 l=100
X52 5v0_addh_sc_1/5v0_half_adder_selector_sc_0/res_stage0 5v0_addh_sc_1/ctrl_sign 5v0_addh_sc_1/upstepper_test VSS nfet_06v0 ad=0 pd=0 as=43.711n ps=1.504m w=164 l=120
X53 5v0_addh_sc_1/5v0_half_adder_selector_sc_0/res_stage0 5v0_addh_sc_1/ctrl_sign 5v0_addh_sc_1/downstepper_test VDD_3V3 pfet_06v0 ad=0 pd=0 as=42.856n ps=1.326m w=244 l=100
X54 sum 5v0_addh_sc_1/a_382_n1095# 5v0_addh_sc_1/5v0_half_adder_selector_sc_0/res_stage0 VSS nfet_06v0 ad=17.057n pd=0.537m as=0 ps=0 w=164 l=120
X55 sum 5v0_addh_sc_1/a_382_n1095# in_B VDD_3V3 pfet_06v0 ad=25.377n pd=0.697m as=21.472n ps=0.664m w=244 l=100
X56 5v0_addh_sc_1/a_382_n1095# 5v0_addh_sc_1/ctrl_over VSS VSS nfet_06v0 ad=14.432n pd=0.504m as=0 ps=0 w=164 l=120
X57 5v0_addh_sc_1/a_382_n1095# 5v0_addh_sc_1/ctrl_over VDD_3V3 VDD_3V3 pfet_06v0 ad=21.472n pd=0.664m as=0 ps=0 w=244 l=100
X58 sum 5v0_addh_sc_1/ctrl_over in_B VSS nfet_06v0 ad=0 pd=0 as=14.432n ps=0.504m w=164 l=120
X59 sum 5v0_addh_sc_1/ctrl_over 5v0_addh_sc_1/5v0_half_adder_selector_sc_0/res_stage0 VDD_3V3 pfet_06v0 ad=0 pd=0 as=0 ps=0 w=244 l=100
X60 5v0_addh_sc_1/inv_pti 5v0_addh_sc_1/pti VSS VSS nfet_06v0 ad=28.864n pd=1.008m as=0 ps=0 w=164 l=120
X61 5v0_addh_sc_1/inv_pti 5v0_addh_sc_1/pti VDD_3V3 VDD_3V3 pfet_06v0 ad=42.944n pd=1.328m as=0 ps=0 w=244 l=100
X62 5v0_addh_sc_1/carry_0_probe 5v0_addh_sc_1/a_382_n1095# 5v0_addh_sc_1/m1_843_n857# VSS nfet_06v0 ad=14.432n pd=0.504m as=31.488n ps=1.04m w=164 l=120
X63 5v0_addh_sc_1/carry_0_probe 5v0_addh_sc_1/ctrl_over 5v0_addh_sc_1/m1_843_n857# VDD_3V3 pfet_06v0 ad=42.944n pd=1.328m as=46.848n ps=1.36m w=244 l=100
X64 5v0_addh_sc_1/inv_nti 5v0_addh_sc_1/ctrl_sign 5v0_add_ccal_sc_r1_0/in_sign VDD_3V3 pfet_06v0 ad=64.416n pd=1.992m as=46.848n ps=1.36m w=244 l=100
X65 5v0_add_ccal_sc_r1_0/in_sign 5v0_addh_sc_1/m1_103_293# 5v0_addh_sc_1/inv_nti VSS nfet_06v0 ad=31.488n pd=1.04m as=43.296n ps=1.512m w=164 l=120
X66 5v0_add_ccal_sc_r1_0/in_sign 5v0_addh_sc_1/m1_103_293# 5v0_addh_sc_1/inv_pti VDD_3V3 pfet_06v0 ad=0 pd=0 as=0 ps=0 w=244 l=100
X67 5v0_addh_sc_1/inv_pti 5v0_addh_sc_1/ctrl_sign 5v0_add_ccal_sc_r1_0/in_sign VSS nfet_06v0 ad=0 pd=0 as=0 ps=0 w=164 l=120
X68 5v0_addh_sc_1/inv_nti 5v0_addh_sc_1/ctrl_sign 5v0_addh_sc_1/m1_843_n857# VDD_3V3 pfet_06v0 ad=0 pd=0 as=0 ps=0 w=244 l=100
X69 5v0_addh_sc_1/m1_843_n857# 5v0_addh_sc_1/m1_103_293# 5v0_addh_sc_1/inv_nti VSS nfet_06v0 ad=0 pd=0 as=0 ps=0 w=164 l=120
X70 5v0_addh_sc_1/m1_843_n857# 5v0_addh_sc_1/m1_103_293# 5v0_addh_sc_1/pti VDD_3V3 pfet_06v0 ad=0 pd=0 as=0 ps=0 w=244 l=100
X71 5v0_addh_sc_1/pti 5v0_addh_sc_1/ctrl_sign 5v0_addh_sc_1/m1_843_n857# VSS nfet_06v0 ad=0 pd=0 as=0 ps=0 w=164 l=120
X72 5v0_addh_sc_1/a_n1373_n454# 5v0_addh_sc_1/inv_nti 5v0_addh_sc_1/downstepper_test VSS nfet_06v0 ad=7.056n pd=0.39m as=0 ps=0 w=147 l=120
X73 5v0_addh_sc_1/upstepper_test 5v0_addh_sc_1/nti 5v0_addh_sc_1/a_n1205_n937# VDD_3V3 pfet_06v0 ad=0 pd=0 as=11.664n ps=0.582m w=243 l=100
X74 5v0_addh_sc_1/inv_nti 5v0_addh_sc_1/nti VDD_3V3 VDD_3V3 pfet_06v0 ad=0 pd=0 as=0 ps=0 w=244 l=100
X75 5v0_addh_sc_1/upstepper_test 5v0_addh_sc_1/nti 5v0_addh_sc_1/VDD_1V65 VSS nfet_06v0 ad=0 pd=0 as=21.021n ps=0.58m w=147 l=120
X76 5v0_addh_sc_1/carry_0_probe 5v0_addh_sc_1/a_382_n1095# VDD_3V3 VDD_3V3 pfet_06v0 ad=0 pd=0 as=0 ps=0 w=244 l=100
X77 5v0_addh_sc_1/a_n1205_n937# 5v0_addh_sc_1/inv_pti VDD_3V3 VDD_3V3 pfet_06v0 ad=0 pd=0 as=0 ps=0 w=243 l=100
X78 5v0_addh_sc_1/downstepper_test 5v0_addh_sc_1/pti 5v0_addh_sc_1/a_n1778_n454# VSS nfet_06v0 ad=0 pd=0 as=7.056n ps=0.39m w=147 l=120
X79 5v0_addh_sc_1/inv_nti 5v0_addh_sc_1/nti VSS VSS nfet_06v0 ad=0 pd=0 as=0 ps=0 w=164 l=120
X80 5v0_addh_sc_1/a_n1778_n454# 5v0_addh_sc_1/inv_nti VSS VSS nfet_06v0 ad=0 pd=0 as=0 ps=0 w=147 l=120
X81 5v0_addh_sc_1/upstepper_test 5v0_addh_sc_1/inv_pti VSS VSS nfet_06v0 ad=0 pd=0 as=0 ps=0 w=164 l=120
X82 5v0_addh_sc_1/VDD_1V65 5v0_addh_sc_1/inv_pti 5v0_addh_sc_1/a_n1373_n454# VSS nfet_06v0 ad=0 pd=0 as=0 ps=0 w=147 l=120
X83 5v0_addh_sc_1/downstepper_test 5v0_addh_sc_1/inv_nti VDD_3V3 VDD_3V3 pfet_06v0 ad=0 pd=0 as=0 ps=0 w=243 l=100
X84 5v0_addh_sc_1/ctrl_over 5v0_nter2oter_code_sc_0/gf180mcu_fd_sc_mcu7t5v0__nor2_1_0/A1 5v0_nter2oter_code_sc_0/gf180mcu_fd_sc_mcu7t5v0__nor2_1_0/a_224_472# VDD_3V3 pfet_06v0 ad=21.472n pd=0.664m as=16.348n ps=0.378m w=244 l=100
X85 VSS 5v0_nter2oter_code_sc_0/gf180mcu_fd_sc_mcu7t5v0__nor2_1_0/A1 5v0_addh_sc_1/ctrl_over VSS nfet_06v0 ad=9.944n pd=0.402m as=5.876n ps=0.217m w=113 l=120
X86 5v0_nter2oter_code_sc_0/gf180mcu_fd_sc_mcu7t5v0__nor2_1_0/a_224_472# 5v0_nter2oter_code_sc_0/nti VDD_3V3 VDD_3V3 pfet_06v0 ad=16.348n pd=0.378m as=20.932n ps=0.664m w=244 l=100
X87 5v0_addh_sc_1/ctrl_over 5v0_nter2oter_code_sc_0/nti VSS VSS nfet_06v0 ad=5.876n pd=0.217m as=9.944n ps=0.402m w=113 l=120
X88 5v0_nter2oter_code_sc_0/gf180mcu_fd_sc_mcu7t5v0__nor2_1_0/A1 5v0_nter2oter_code_sc_0/pti VSS VSS nfet_06v0 ad=14.432n pd=0.504m as=0 ps=0 w=164 l=120
X89 5v0_nter2oter_code_sc_0/gf180mcu_fd_sc_mcu7t5v0__nor2_1_0/A1 5v0_nter2oter_code_sc_0/pti VDD_3V3 VDD_3V3 pfet_06v0 ad=21.472n pd=0.664m as=0 ps=0 w=244 l=100
X90 5v0_nter2oter_code_sc_0/pti 5v0_nter2oter_code_sc_0/in VSS VSS nfet_06v0 ad=6.336n pd=0.32m as=6.478n ps=0.255m w=72 l=578
X91 VDD_3V3 5v0_nter2oter_code_sc_0/pti 5v0_addh_sc_1/ctrl_sign VDD_3V3 pfet_06v0 ad=18.08n pd=0.612m as=21.696n ps=0.644m w=226 l=100
X92 VDD_3V3 5v0_nter2oter_code_sc_0/in 5v0_nter2oter_code_sc_0/pti VDD_3V3 pfet_06v0 ad=12.81n pd=0.349m as=12.688n ps=0.348m w=244 l=100
X93 VDD_3V3 5v0_nter2oter_code_sc_0/in 5v0_nter2oter_code_sc_0/nti VDD_3V3 pfet_06v0 ad=13.616n pd=0.392m as=9.696n ps=0.394m w=96 l=150
X94 VSS 5v0_nter2oter_code_sc_0/nti 5v0_addh_sc_1/ctrl_sign VSS nfet_06v0 ad=7.544n pd=0.42m as=14.432n ps=0.504m w=164 l=120
X95 VSS 5v0_nter2oter_code_sc_0/in 5v0_nter2oter_code_sc_0/nti VSS nfet_06v0 ad=6.478n pd=0.255m as=12.7n ps=0.454m w=127 l=120
X96 5v0_nter2oter_code_sc_0/pti 5v0_nter2oter_code_sc_0/in VDD_3V3 VDD_3V3 pfet_06v0 ad=12.688n pd=0.348m as=13.616n ps=0.392m w=244 l=100
X97 5v0_nter2oter_code_sc_0/pti 5v0_nter2oter_code_sc_0/in VDD_3V3 VDD_3V3 pfet_06v0 ad=27.328n pd=0.712m as=12.81n ps=0.349m w=244 l=100
X98 carry_over 5v0_add_ccal_sc_r1_0/gf180mcu_fd_sc_mcu7t5v0__xnor2_1_0/a_64_93# VDD_3V3 VDD_3V3 pfet_06v0 ad=12.483n pd=0.333m as=13.775n ps=0.379m w=219 l=100
X99 5v0_add_ccal_sc_r1_0/gf180mcu_fd_sc_mcu7t5v0__xnor2_1_0/a_272_93# 5v0_addh_sc_0/carry_0_probe 5v0_add_ccal_sc_r1_0/gf180mcu_fd_sc_mcu7t5v0__xnor2_1_0/a_64_93# VSS nfet_06v0 ad=2.304n pd=0.136m as=6.336n ps=0.32m w=72 l=120
X100 VSS 5v0_addh_sc_1/carry_0_probe 5v0_add_ccal_sc_r1_0/gf180mcu_fd_sc_mcu7t5v0__xnor2_1_0/a_272_93# VSS nfet_06v0 ad=8.72n pd=0.304m as=2.304n ps=0.136m w=72 l=120
X101 5v0_add_ccal_sc_r1_0/gf180mcu_fd_sc_mcu7t5v0__xnor2_1_0/a_716_68# 5v0_add_ccal_sc_r1_0/gf180mcu_fd_sc_mcu7t5v0__xnor2_1_0/a_64_93# VSS VSS nfet_06v0 ad=8.528n pd=0.268m as=8.72n ps=0.304m w=164 l=120
X102 VDD_3V3 5v0_addh_sc_0/carry_0_probe 5v0_add_ccal_sc_r1_0/gf180mcu_fd_sc_mcu7t5v0__xnor2_1_0/a_930_497# VDD_3V3 pfet_06v0 ad=19.272n pd=0.614m as=22.119n ps=0.421m w=219 l=100
X103 carry_over 5v0_addh_sc_1/carry_0_probe 5v0_add_ccal_sc_r1_0/gf180mcu_fd_sc_mcu7t5v0__xnor2_1_0/a_716_68# VSS nfet_06v0 ad=16.644n pd=0.381m as=8.528n ps=0.268m w=164 l=120
X104 5v0_add_ccal_sc_r1_0/gf180mcu_fd_sc_mcu7t5v0__xnor2_1_0/a_64_93# 5v0_addh_sc_0/carry_0_probe VDD_3V3 VDD_3V3 pfet_06v0 ad=5.824n pd=0.216m as=9.856n ps=0.4m w=112 l=100
X105 5v0_add_ccal_sc_r1_0/gf180mcu_fd_sc_mcu7t5v0__xnor2_1_0/a_716_68# 5v0_addh_sc_0/carry_0_probe carry_over VSS nfet_06v0 ad=14.432n pd=0.504m as=16.644n ps=0.381m w=164 l=120
X106 VDD_3V3 5v0_addh_sc_1/carry_0_probe 5v0_add_ccal_sc_r1_0/gf180mcu_fd_sc_mcu7t5v0__xnor2_1_0/a_64_93# VDD_3V3 pfet_06v0 ad=13.775n pd=0.379m as=5.824n ps=0.216m w=112 l=100
X107 5v0_add_ccal_sc_r1_0/gf180mcu_fd_sc_mcu7t5v0__xnor2_1_0/a_930_497# 5v0_addh_sc_1/carry_0_probe carry_over VDD_3V3 pfet_06v0 ad=22.119n pd=0.421m as=12.483n ps=0.333m w=219 l=100
X108 5v0_addh_sc_0/carry_sign_probe 5v0_addh_sc_0/carry_0_probe carry_sign VDD_3V3 pfet_06v0 ad=21.472n pd=0.664m as=12.688n ps=0.348m w=244 l=100
X109 carry_sign 5v0_add_ccal_sc_r1_0/a_n260_n44# 5v0_addh_sc_0/carry_sign_probe VSS nfet_06v0 ad=8.528n pd=0.268m as=14.432n ps=0.504m w=164 l=120
X110 carry_sign 5v0_add_ccal_sc_r1_0/a_n260_n44# 5v0_add_ccal_sc_r1_0/in_sign VDD_3V3 pfet_06v0 ad=12.688n pd=0.348m as=21.472n ps=0.664m w=244 l=100
X111 5v0_add_ccal_sc_r1_0/a_n260_n44# 5v0_addh_sc_0/carry_0_probe VSS VSS nfet_06v0 ad=14.432n pd=0.504m as=14.432n ps=0.504m w=164 l=120
X112 5v0_add_ccal_sc_r1_0/a_n260_n44# 5v0_addh_sc_0/carry_0_probe VDD_3V3 VDD_3V3 pfet_06v0 ad=21.472n pd=0.664m as=21.472n ps=0.664m w=244 l=100
X113 5v0_add_ccal_sc_r1_0/in_sign 5v0_addh_sc_0/carry_0_probe carry_sign VSS nfet_06v0 ad=14.432n pd=0.504m as=8.528n ps=0.268m w=164 l=120
C0 5v0_nter2oter_code_sc_0/gf180mcu_fd_sc_mcu7t5v0__nor2_1_0/A1 5v0_addh_sc_1/nti 0.00123f
C1 5v0_addh_sc_0/downstepper_test 5v0_addh_sc_0/inv_pti 0.13775f
C2 5v0_nter2oter_code_sc_0/pti 5v0_addh_sc_0/carry_0_probe 0
C3 5v0_addh_sc_0/upstepper_test 5v0_addh_sc_0/a_n1373_n454# 0
C4 5v0_addh_sc_1/a_n1778_n454# 5v0_addh_sc_1/nti 0.00142f
C5 5v0_nter2oter_code_sc_0/nti 5v0_add_ccal_sc_r1_0/gf180mcu_fd_sc_mcu7t5v0__xnor2_1_0/a_64_93# 0.00509f
C6 5v0_addh_sc_0/m1_103_293# carry_over 0.00759f
C7 5v0_addh_sc_1/a_n1778_n454# 5v0_addh_sc_1/upstepper_test 0
C8 5v0_addh_sc_0/inv_pti 5v0_addh_sc_0/carry_sign_probe 0.10808f
C9 5v0_nter2oter_code_sc_0/nti 5v0_addh_sc_1/ctrl_sign 0.08491f
C10 VDD_3V3 5v0_addh_sc_1/pti 0.66244f
C11 carry_over 5v0_addh_sc_0/a_382_n1095# 0.01598f
C12 in_C_sign 5v0_addh_sc_0/pti 0.30014f
C13 5v0_addh_sc_0/m1_103_293# 5v0_addh_sc_0/carry_0_probe 0.01398f
C14 in_C_over 5v0_addh_sc_0/nti 0.00272f
C15 5v0_addh_sc_0/carry_0_probe 5v0_addh_sc_1/nti 0
C16 5v0_nter2oter_code_sc_0/in 5v0_addh_sc_0/nti 0.01165f
C17 5v0_nter2oter_code_sc_0/nti 5v0_addh_sc_0/pti 0
C18 5v0_addh_sc_1/inv_pti 5v0_addh_sc_1/ctrl_over 0.01485f
C19 5v0_addh_sc_0/a_382_n1095# 5v0_addh_sc_0/carry_0_probe 0.0695f
C20 5v0_addh_sc_0/carry_0_probe 5v0_addh_sc_1/upstepper_test 0
C21 5v0_addh_sc_0/VDD_1V65 5v0_addh_sc_0/pti 0.00234f
C22 5v0_addh_sc_1/downstepper_test 5v0_addh_sc_1/5v0_half_adder_selector_sc_0/5v0_tgate_sel_2_sc_1/input_A 0
C23 5v0_addh_sc_0/m1_103_293# 5v0_add_ccal_sc_r1_0/a_n260_n44# 0.00111f
C24 5v0_addh_sc_1/carry_0_probe in_A 0.00121f
C25 5v0_addh_sc_1/carry_0_probe 5v0_addh_sc_1/ctrl_over 0.12509f
C26 5v0_addh_sc_0/carry_sign_probe carry_sign 0.142f
C27 sum VDD_3V3 0.08844f
C28 5v0_addh_sc_0/a_382_n1095# 5v0_add_ccal_sc_r1_0/a_n260_n44# 0.00129f
C29 in_C_over 5v0_addh_sc_0/upstepper_test 0.00287f
C30 5v0_addh_sc_0/carry_0_probe 5v0_nter2oter_code_sc_0/gf180mcu_fd_sc_mcu7t5v0__nor2_1_0/A1 0
C31 5v0_addh_sc_0/upstepper_test 5v0_nter2oter_code_sc_0/in 0
C32 5v0_addh_sc_0/VDD_1V65 5v0_addh_sc_0/a_n1373_n454# 0.00232f
C33 5v0_addh_sc_0/inv_nti 5v0_addh_sc_0/downstepper_test 0.29786f
C34 in_C_over 5v0_add_ccal_sc_r1_0/gf180mcu_fd_sc_mcu7t5v0__xnor2_1_0/a_716_68# 0.00566f
C35 5v0_nter2oter_code_sc_0/pti 5v0_addh_sc_1/carry_0_probe 0
C36 5v0_addh_sc_1/m1_103_293# VDD_3V3 0.73166f
C37 5v0_add_ccal_sc_r1_0/gf180mcu_fd_sc_mcu7t5v0__xnor2_1_0/a_716_68# 5v0_nter2oter_code_sc_0/in 0.00471f
C38 carry_over 5v0_addh_sc_0/carry_0_probe 0.68971f
C39 5v0_addh_sc_0/downstepper_test 5v0_addh_sc_0/a_n1205_n937# 0.00453f
C40 5v0_addh_sc_0/inv_nti 5v0_addh_sc_0/carry_sign_probe 0.3327f
C41 5v0_addh_sc_1/downstepper_test 5v0_addh_sc_1/pti 0.19511f
C42 carry_over 5v0_add_ccal_sc_r1_0/a_n260_n44# 0.0272f
C43 5v0_addh_sc_1/inv_pti 5v0_addh_sc_1/nti 0.23721f
C44 5v0_nter2oter_code_sc_0/gf180mcu_fd_sc_mcu7t5v0__nor2_1_0/a_224_472# 5v0_addh_sc_1/ctrl_over 0.02967f
C45 in_C_sign in_C_over 0.06048f
C46 5v0_addh_sc_1/inv_pti 5v0_addh_sc_0/a_382_n1095# 0
C47 5v0_addh_sc_1/inv_pti 5v0_addh_sc_1/upstepper_test 0.08058f
C48 5v0_addh_sc_0/m1_103_293# 5v0_addh_sc_1/carry_0_probe 0
C49 5v0_addh_sc_1/inv_pti 5v0_addh_sc_1/a_n1373_n454# 0.00135f
C50 in_C_sign 5v0_nter2oter_code_sc_0/in 0
C51 5v0_addh_sc_0/m1_843_n857# 5v0_addh_sc_0/pti 0.11666f
C52 5v0_nter2oter_code_sc_0/nti in_C_over 0.00439f
C53 5v0_addh_sc_1/carry_0_probe 5v0_addh_sc_1/nti 0
C54 5v0_addh_sc_1/inv_nti 5v0_addh_sc_1/pti 0.42143f
C55 5v0_addh_sc_0/carry_0_probe 5v0_add_ccal_sc_r1_0/a_n260_n44# 0.29408f
C56 5v0_addh_sc_1/carry_0_probe 5v0_addh_sc_0/a_382_n1095# 0
C57 in_C_over 5v0_addh_sc_0/VDD_1V65 0.00494f
C58 5v0_addh_sc_1/carry_0_probe 5v0_addh_sc_1/upstepper_test 0.00816f
C59 carry_sign 5v0_addh_sc_1/pti 0.00455f
C60 5v0_nter2oter_code_sc_0/nti 5v0_nter2oter_code_sc_0/in 0.2543f
C61 5v0_addh_sc_1/downstepper_test sum 0.00302f
C62 5v0_nter2oter_code_sc_0/pti 5v0_nter2oter_code_sc_0/gf180mcu_fd_sc_mcu7t5v0__nor2_1_0/a_224_472# 0.00455f
C63 in_B 5v0_addh_sc_1/pti 0.66373f
C64 sum 5v0_addh_sc_1/inv_nti 0.01109f
C65 5v0_addh_sc_1/inv_pti carry_over 0.00972f
C66 5v0_addh_sc_1/downstepper_test 5v0_addh_sc_1/m1_103_293# 0.0934f
C67 5v0_addh_sc_0/5v0_half_adder_selector_sc_0/res_stage0 VDD_3V3 0.15351f
C68 5v0_add_ccal_sc_r1_0/in_sign 5v0_addh_sc_0/m1_843_n857# 0
C69 carry_over 5v0_addh_sc_1/carry_0_probe 0.07685f
C70 5v0_nter2oter_code_sc_0/gf180mcu_fd_sc_mcu7t5v0__nor2_1_0/a_224_472# 5v0_addh_sc_1/nti 0
C71 5v0_addh_sc_1/inv_pti 5v0_addh_sc_0/carry_0_probe 0.0174f
C72 5v0_addh_sc_1/m1_103_293# 5v0_addh_sc_1/inv_nti 0.35313f
C73 in_B sum 0.16326f
C74 5v0_addh_sc_1/carry_0_probe 5v0_addh_sc_0/carry_0_probe 0.65217f
C75 5v0_addh_sc_0/inv_pti VDD_3V3 0.86079f
C76 5v0_addh_sc_1/inv_pti 5v0_add_ccal_sc_r1_0/a_n260_n44# 0.0038f
C77 5v0_addh_sc_1/downstepper_test VDD_3V3 0.45464f
C78 in_C_over 5v0_addh_sc_0/m1_843_n857# 0.10364f
C79 5v0_nter2oter_code_sc_0/gf180mcu_fd_sc_mcu7t5v0__nor2_1_0/a_224_472# 5v0_nter2oter_code_sc_0/gf180mcu_fd_sc_mcu7t5v0__nor2_1_0/A1 0
C80 5v0_addh_sc_1/carry_0_probe 5v0_add_ccal_sc_r1_0/a_n260_n44# 0.04869f
C81 5v0_addh_sc_0/downstepper_test 5v0_addh_sc_0/nti 0.06667f
C82 in_B 5v0_addh_sc_1/m1_103_293# 0
C83 5v0_add_ccal_sc_r1_0/gf180mcu_fd_sc_mcu7t5v0__xnor2_1_0/a_64_93# in_A 0
C84 5v0_addh_sc_1/inv_nti VDD_3V3 0.70863f
C85 5v0_add_ccal_sc_r1_0/gf180mcu_fd_sc_mcu7t5v0__xnor2_1_0/a_64_93# 5v0_addh_sc_1/ctrl_over 0
C86 VDD_3V3 carry_sign 0.09927f
C87 5v0_addh_sc_1/ctrl_over 5v0_addh_sc_1/ctrl_sign 0.07063f
C88 5v0_addh_sc_0/inv_pti 5v0_addh_sc_0/5v0_half_adder_selector_sc_0/res_stage0 0.01294f
C89 5v0_addh_sc_0/downstepper_test 5v0_addh_sc_0/upstepper_test 0.38555f
C90 5v0_addh_sc_0/pti in_A 0.66373f
C91 in_B VDD_3V3 1.02995f
C92 5v0_nter2oter_code_sc_0/pti 5v0_add_ccal_sc_r1_0/gf180mcu_fd_sc_mcu7t5v0__xnor2_1_0/a_64_93# 0.00131f
C93 5v0_addh_sc_1/inv_pti 5v0_addh_sc_1/carry_0_probe 0.10064f
C94 VDD_3V3 5v0_addh_sc_1/a_n1205_n937# 0.00891f
C95 5v0_nter2oter_code_sc_0/pti 5v0_addh_sc_1/ctrl_sign 0.06721f
C96 5v0_addh_sc_0/inv_nti VDD_3V3 0.83873f
C97 5v0_addh_sc_0/a_n1373_n454# in_A 0.00163f
C98 5v0_addh_sc_1/VDD_1V65 5v0_addh_sc_1/pti 0.00234f
C99 5v0_addh_sc_0/a_n1205_n937# VDD_3V3 0.00891f
C100 5v0_addh_sc_0/downstepper_test in_C_sign 0.18126f
C101 5v0_addh_sc_1/downstepper_test 5v0_addh_sc_1/inv_nti 0.26175f
C102 5v0_add_ccal_sc_r1_0/gf180mcu_fd_sc_mcu7t5v0__xnor2_1_0/a_64_93# 5v0_addh_sc_1/upstepper_test 0.00167f
C103 5v0_addh_sc_0/downstepper_test 5v0_nter2oter_code_sc_0/nti 0.00467f
C104 5v0_addh_sc_1/ctrl_sign 5v0_addh_sc_1/nti 0.01943f
C105 5v0_addh_sc_0/downstepper_test 5v0_addh_sc_0/VDD_1V65 0.13024f
C106 5v0_add_ccal_sc_r1_0/in_sign 5v0_addh_sc_1/ctrl_over 0
C107 in_C_sign 5v0_addh_sc_0/carry_sign_probe 0.27266f
C108 5v0_addh_sc_1/ctrl_sign 5v0_addh_sc_1/upstepper_test 0.1573f
C109 5v0_addh_sc_0/inv_nti 5v0_addh_sc_0/5v0_half_adder_selector_sc_0/res_stage0 0.02869f
C110 5v0_addh_sc_0/m1_103_293# 5v0_addh_sc_0/pti 0.09933f
C111 5v0_addh_sc_1/inv_nti carry_sign 0.01667f
C112 5v0_addh_sc_1/downstepper_test in_B 0.18121f
C113 5v0_addh_sc_0/a_382_n1095# 5v0_addh_sc_0/pti 0.12627f
C114 5v0_addh_sc_0/a_n1205_n937# 5v0_addh_sc_0/5v0_half_adder_selector_sc_0/res_stage0 0
C115 5v0_addh_sc_1/ctrl_sign 5v0_nter2oter_code_sc_0/gf180mcu_fd_sc_mcu7t5v0__nor2_1_0/A1 0.00161f
C116 in_C_over in_A 0.1526f
C117 5v0_addh_sc_1/downstepper_test 5v0_addh_sc_1/a_n1205_n937# 0.00453f
C118 5v0_addh_sc_0/inv_nti 5v0_addh_sc_0/inv_pti 0.2615f
C119 5v0_nter2oter_code_sc_0/in in_A 0.18942f
C120 carry_over 5v0_add_ccal_sc_r1_0/gf180mcu_fd_sc_mcu7t5v0__xnor2_1_0/a_64_93# 0.02364f
C121 5v0_addh_sc_1/ctrl_over 5v0_nter2oter_code_sc_0/in 0.00449f
C122 5v0_addh_sc_0/a_n1778_n454# 5v0_addh_sc_0/pti 0.00135f
C123 5v0_addh_sc_1/a_382_n1095# 5v0_addh_sc_1/ctrl_over 0.64782f
C124 in_B 5v0_addh_sc_1/inv_nti 0.26117f
C125 carry_over 5v0_addh_sc_1/ctrl_sign 0.009f
C126 5v0_addh_sc_1/inv_nti 5v0_addh_sc_1/a_n1205_n937# 0
C127 5v0_addh_sc_0/5v0_half_adder_selector_sc_0/5v0_tgate_sel_2_sc_1/input_A in_C_over 0.04656f
C128 5v0_addh_sc_0/carry_0_probe 5v0_add_ccal_sc_r1_0/gf180mcu_fd_sc_mcu7t5v0__xnor2_1_0/a_64_93# 0.29767f
C129 5v0_nter2oter_code_sc_0/pti in_C_over 0
C130 5v0_addh_sc_0/m1_103_293# 5v0_add_ccal_sc_r1_0/in_sign 0
C131 5v0_addh_sc_0/carry_0_probe 5v0_addh_sc_1/ctrl_sign 0.02038f
C132 5v0_nter2oter_code_sc_0/pti 5v0_nter2oter_code_sc_0/in 0.47835f
C133 carry_over 5v0_addh_sc_0/pti 0.00491f
C134 5v0_addh_sc_1/VDD_1V65 VDD_3V3 0.04373f
C135 5v0_add_ccal_sc_r1_0/a_n260_n44# 5v0_addh_sc_1/ctrl_sign 0
C136 5v0_addh_sc_0/carry_0_probe 5v0_addh_sc_0/pti 0.12808f
C137 5v0_nter2oter_code_sc_0/nti 5v0_addh_sc_1/pti 0.00125f
C138 5v0_addh_sc_0/m1_103_293# in_C_over 0.02869f
C139 5v0_addh_sc_0/carry_sign_probe 5v0_addh_sc_0/m1_843_n857# 0.12287f
C140 VDD_3V3 5v0_addh_sc_0/nti 0.67838f
C141 5v0_add_ccal_sc_r1_0/a_n260_n44# 5v0_addh_sc_0/pti 0
C142 5v0_addh_sc_0/a_382_n1095# in_C_over 0.69161f
C143 5v0_nter2oter_code_sc_0/in 5v0_addh_sc_1/nti 0
C144 in_C_over 5v0_addh_sc_1/upstepper_test 0.00182f
C145 5v0_addh_sc_1/ctrl_over 5v0_addh_sc_1/m1_843_n857# 0.10015f
C146 5v0_addh_sc_1/m1_103_293# 5v0_add_ccal_sc_r1_0/gf180mcu_fd_sc_mcu7t5v0__xnor2_1_0/a_716_68# 0
C147 5v0_addh_sc_1/a_382_n1095# 5v0_addh_sc_1/nti 0
C148 5v0_addh_sc_0/a_382_n1095# 5v0_nter2oter_code_sc_0/in 0.16366f
C149 carry_over 5v0_add_ccal_sc_r1_0/in_sign 0
C150 5v0_addh_sc_0/inv_nti 5v0_addh_sc_0/a_n1205_n937# 0
C151 5v0_addh_sc_1/inv_pti 5v0_add_ccal_sc_r1_0/gf180mcu_fd_sc_mcu7t5v0__xnor2_1_0/a_64_93# 0.00767f
C152 5v0_addh_sc_0/upstepper_test VDD_3V3 0.43797f
C153 5v0_addh_sc_1/ctrl_over 5v0_addh_sc_1/5v0_half_adder_selector_sc_0/res_stage0 0.10616f
C154 5v0_nter2oter_code_sc_0/in 5v0_nter2oter_code_sc_0/gf180mcu_fd_sc_mcu7t5v0__nor2_1_0/A1 0.00729f
C155 5v0_addh_sc_1/inv_pti 5v0_addh_sc_1/ctrl_sign 0.29782f
C156 5v0_addh_sc_0/carry_0_probe 5v0_add_ccal_sc_r1_0/in_sign 0.16822f
C157 5v0_addh_sc_1/carry_0_probe 5v0_add_ccal_sc_r1_0/gf180mcu_fd_sc_mcu7t5v0__xnor2_1_0/a_64_93# 0.22219f
C158 5v0_addh_sc_0/5v0_half_adder_selector_sc_0/res_stage0 5v0_addh_sc_0/nti 0.00372f
C159 5v0_add_ccal_sc_r1_0/gf180mcu_fd_sc_mcu7t5v0__xnor2_1_0/a_716_68# VDD_3V3 0.00546f
C160 5v0_addh_sc_1/downstepper_test 5v0_addh_sc_1/VDD_1V65 0.13024f
C161 5v0_addh_sc_1/carry_0_probe 5v0_addh_sc_1/ctrl_sign 0.06269f
C162 carry_over in_C_over 0.01506f
C163 5v0_add_ccal_sc_r1_0/in_sign 5v0_add_ccal_sc_r1_0/a_n260_n44# 0.09179f
C164 carry_over 5v0_nter2oter_code_sc_0/in 0.0038f
C165 5v0_addh_sc_0/inv_pti 5v0_addh_sc_0/nti 0.23986f
C166 in_C_over 5v0_addh_sc_0/carry_0_probe 0.15086f
C167 5v0_addh_sc_1/carry_0_probe 5v0_addh_sc_0/pti 0
C168 5v0_addh_sc_1/inv_nti 5v0_addh_sc_1/VDD_1V65 0.06616f
C169 5v0_addh_sc_0/upstepper_test 5v0_addh_sc_0/5v0_half_adder_selector_sc_0/res_stage0 0.27475f
C170 5v0_addh_sc_0/carry_0_probe 5v0_nter2oter_code_sc_0/in 0.01268f
C171 in_C_sign VDD_3V3 1.25775f
C172 5v0_addh_sc_1/a_382_n1095# 5v0_addh_sc_0/carry_0_probe 0
C173 in_C_over 5v0_add_ccal_sc_r1_0/a_n260_n44# 0.00368f
C174 5v0_nter2oter_code_sc_0/nti VDD_3V3 0.40177f
C175 5v0_addh_sc_0/VDD_1V65 VDD_3V3 0.04619f
C176 5v0_addh_sc_1/a_382_n1095# 5v0_add_ccal_sc_r1_0/a_n260_n44# 0
C177 5v0_addh_sc_1/5v0_half_adder_selector_sc_0/res_stage0 5v0_addh_sc_1/nti 0.00372f
C178 5v0_addh_sc_0/inv_pti 5v0_addh_sc_0/upstepper_test 0.07093f
C179 in_B 5v0_addh_sc_1/VDD_1V65 0.01451f
C180 5v0_addh_sc_1/5v0_half_adder_selector_sc_0/res_stage0 5v0_addh_sc_1/upstepper_test 0.27475f
C181 5v0_nter2oter_code_sc_0/gf180mcu_fd_sc_mcu7t5v0__nor2_1_0/a_224_472# 5v0_addh_sc_1/ctrl_sign 0.00266f
C182 5v0_addh_sc_1/inv_pti 5v0_add_ccal_sc_r1_0/in_sign 0.12174f
C183 5v0_addh_sc_0/downstepper_test in_A 0.18202f
C184 5v0_addh_sc_1/VDD_1V65 5v0_addh_sc_1/a_n1205_n937# 0.00354f
C185 5v0_addh_sc_1/carry_0_probe 5v0_add_ccal_sc_r1_0/in_sign 0.12707f
C186 in_C_sign 5v0_addh_sc_0/5v0_half_adder_selector_sc_0/res_stage0 0.24991f
C187 5v0_addh_sc_0/downstepper_test 5v0_addh_sc_0/5v0_half_adder_selector_sc_0/5v0_tgate_sel_2_sc_1/input_A 0
C188 5v0_addh_sc_1/inv_pti in_C_over 0.02632f
C189 5v0_addh_sc_0/downstepper_test 5v0_nter2oter_code_sc_0/pti 0
C190 in_C_sign 5v0_addh_sc_0/inv_pti 0.30433f
C191 5v0_addh_sc_1/inv_pti 5v0_nter2oter_code_sc_0/in 0
C192 5v0_addh_sc_0/inv_nti 5v0_addh_sc_0/nti 0.21893f
C193 5v0_addh_sc_1/inv_pti 5v0_addh_sc_1/a_382_n1095# 0.00129f
C194 5v0_addh_sc_1/carry_0_probe in_C_over 0.01072f
C195 5v0_addh_sc_1/5v0_half_adder_selector_sc_0/5v0_tgate_sel_2_sc_1/input_A 5v0_addh_sc_1/ctrl_over 0.04656f
C196 5v0_addh_sc_1/carry_0_probe 5v0_nter2oter_code_sc_0/in 0.01951f
C197 5v0_addh_sc_0/a_n1205_n937# 5v0_addh_sc_0/nti 0
C198 5v0_addh_sc_0/inv_pti 5v0_addh_sc_0/VDD_1V65 0.14775f
C199 5v0_addh_sc_1/a_382_n1095# 5v0_addh_sc_1/carry_0_probe 0.19167f
C200 5v0_addh_sc_0/carry_0_probe 5v0_addh_sc_1/5v0_half_adder_selector_sc_0/res_stage0 0
C201 5v0_addh_sc_0/m1_843_n857# VDD_3V3 0.1274f
C202 5v0_addh_sc_0/inv_nti 5v0_addh_sc_0/upstepper_test 0.00736f
C203 5v0_addh_sc_0/downstepper_test 5v0_addh_sc_0/m1_103_293# 0.09641f
C204 5v0_add_ccal_sc_r1_0/gf180mcu_fd_sc_mcu7t5v0__xnor2_1_0/a_930_497# 5v0_nter2oter_code_sc_0/pti 0
C205 5v0_addh_sc_0/downstepper_test 5v0_addh_sc_0/a_382_n1095# 0.00679f
C206 5v0_addh_sc_0/a_n1205_n937# 5v0_addh_sc_0/upstepper_test 0.00334f
C207 5v0_addh_sc_0/m1_103_293# 5v0_addh_sc_0/carry_sign_probe 0.21173f
C208 5v0_addh_sc_0/downstepper_test 5v0_addh_sc_0/a_n1778_n454# 0.0031f
C209 5v0_addh_sc_0/carry_sign_probe 5v0_addh_sc_0/a_382_n1095# 0.0961f
C210 5v0_addh_sc_1/ctrl_over 5v0_addh_sc_1/pti 0.13064f
C211 5v0_addh_sc_1/inv_pti 5v0_addh_sc_1/m1_843_n857# 0
C212 in_B 5v0_nter2oter_code_sc_0/nti 0.01051f
C213 5v0_add_ccal_sc_r1_0/gf180mcu_fd_sc_mcu7t5v0__xnor2_1_0/a_64_93# 5v0_addh_sc_1/ctrl_sign 0.03504f
C214 5v0_addh_sc_0/inv_nti in_C_sign 0.24913f
C215 5v0_addh_sc_1/carry_0_probe 5v0_addh_sc_1/m1_843_n857# 0.19345f
C216 5v0_addh_sc_1/5v0_half_adder_selector_sc_0/5v0_tgate_sel_2_sc_1/input_A 5v0_addh_sc_1/upstepper_test 0
C217 5v0_nter2oter_code_sc_0/pti 5v0_addh_sc_1/pti 0.01019f
C218 5v0_addh_sc_1/inv_pti 5v0_addh_sc_1/5v0_half_adder_selector_sc_0/res_stage0 0.01314f
C219 5v0_addh_sc_0/inv_nti 5v0_nter2oter_code_sc_0/nti 0.00714f
C220 5v0_addh_sc_0/inv_pti 5v0_addh_sc_0/m1_843_n857# 0
C221 sum 5v0_addh_sc_1/ctrl_over 0.20713f
C222 5v0_addh_sc_0/inv_nti 5v0_addh_sc_0/VDD_1V65 0.08611f
C223 5v0_addh_sc_1/carry_0_probe 5v0_addh_sc_1/5v0_half_adder_selector_sc_0/res_stage0 0.00327f
C224 5v0_addh_sc_0/downstepper_test 5v0_addh_sc_0/carry_0_probe 0
C225 carry_over 5v0_addh_sc_0/carry_sign_probe 0.1315f
C226 5v0_addh_sc_0/a_n1205_n937# 5v0_addh_sc_0/VDD_1V65 0.00354f
C227 5v0_add_ccal_sc_r1_0/gf180mcu_fd_sc_mcu7t5v0__xnor2_1_0/a_930_497# carry_over 0.03123f
C228 5v0_add_ccal_sc_r1_0/gf180mcu_fd_sc_mcu7t5v0__xnor2_1_0/a_272_93# 5v0_nter2oter_code_sc_0/nti 0
C229 5v0_addh_sc_0/carry_sign_probe 5v0_addh_sc_0/carry_0_probe 0.60586f
C230 5v0_addh_sc_1/m1_103_293# 5v0_addh_sc_1/ctrl_over 0.02651f
C231 5v0_addh_sc_1/pti 5v0_addh_sc_1/nti 0.24165f
C232 5v0_addh_sc_1/pti 5v0_addh_sc_1/upstepper_test 0.02062f
C233 5v0_addh_sc_1/a_n1373_n454# 5v0_addh_sc_1/pti 0
C234 5v0_add_ccal_sc_r1_0/gf180mcu_fd_sc_mcu7t5v0__xnor2_1_0/a_930_497# 5v0_addh_sc_0/carry_0_probe 0.01236f
C235 5v0_addh_sc_0/carry_sign_probe 5v0_add_ccal_sc_r1_0/a_n260_n44# 0.08103f
C236 5v0_addh_sc_0/pti 5v0_addh_sc_0/a_n1373_n454# 0
C237 VDD_3V3 in_A 1.02771f
C238 5v0_addh_sc_1/pti 5v0_nter2oter_code_sc_0/gf180mcu_fd_sc_mcu7t5v0__nor2_1_0/A1 0
C239 5v0_add_ccal_sc_r1_0/in_sign 5v0_addh_sc_1/ctrl_sign 0.24257f
C240 5v0_addh_sc_1/ctrl_over VDD_3V3 0.94534f
C241 sum 5v0_addh_sc_1/nti 0
C242 5v0_addh_sc_0/upstepper_test 5v0_addh_sc_0/nti 0.11981f
C243 5v0_addh_sc_1/a_n1778_n454# 5v0_addh_sc_1/pti 0.00135f
C244 5v0_addh_sc_0/inv_nti 5v0_addh_sc_0/m1_843_n857# 0.36668f
C245 in_C_over 5v0_add_ccal_sc_r1_0/gf180mcu_fd_sc_mcu7t5v0__xnor2_1_0/a_64_93# 0.00626f
C246 5v0_addh_sc_0/5v0_half_adder_selector_sc_0/5v0_tgate_sel_2_sc_1/input_A VDD_3V3 0.02871f
C247 5v0_addh_sc_0/m1_103_293# 5v0_addh_sc_1/m1_103_293# 0
C248 5v0_add_ccal_sc_r1_0/gf180mcu_fd_sc_mcu7t5v0__xnor2_1_0/a_64_93# 5v0_nter2oter_code_sc_0/in 0.01467f
C249 5v0_addh_sc_0/downstepper_test 5v0_addh_sc_1/carry_0_probe 0
C250 in_C_over 5v0_addh_sc_1/ctrl_sign 0.00172f
C251 5v0_nter2oter_code_sc_0/pti VDD_3V3 0.83125f
C252 5v0_addh_sc_1/inv_pti 5v0_addh_sc_0/carry_sign_probe 0
C253 5v0_addh_sc_1/m1_103_293# 5v0_addh_sc_0/a_382_n1095# 0
C254 5v0_addh_sc_0/carry_0_probe 5v0_addh_sc_1/pti 0.00291f
C255 5v0_nter2oter_code_sc_0/in 5v0_addh_sc_1/ctrl_sign 0.02011f
C256 5v0_addh_sc_1/a_382_n1095# 5v0_addh_sc_1/ctrl_sign 0.07412f
C257 5v0_addh_sc_1/m1_103_293# 5v0_addh_sc_1/upstepper_test 0.07773f
C258 5v0_addh_sc_0/5v0_half_adder_selector_sc_0/res_stage0 in_A 0.26575f
C259 5v0_addh_sc_1/carry_0_probe 5v0_addh_sc_0/carry_sign_probe 0.00986f
C260 5v0_addh_sc_1/inv_pti 5v0_add_ccal_sc_r1_0/gf180mcu_fd_sc_mcu7t5v0__xnor2_1_0/a_930_497# 0.00198f
C261 in_C_over 5v0_addh_sc_0/pti 0.11384f
C262 5v0_add_ccal_sc_r1_0/a_n260_n44# 5v0_addh_sc_1/pti 0.00221f
C263 in_C_sign 5v0_addh_sc_0/nti 0.10553f
C264 5v0_addh_sc_0/pti 5v0_nter2oter_code_sc_0/in 0.00136f
C265 5v0_addh_sc_0/m1_103_293# VDD_3V3 0.69361f
C266 5v0_add_ccal_sc_r1_0/gf180mcu_fd_sc_mcu7t5v0__xnor2_1_0/a_930_497# 5v0_addh_sc_1/carry_0_probe 0.00827f
C267 5v0_addh_sc_0/inv_pti in_A 0.05631f
C268 5v0_addh_sc_0/5v0_half_adder_selector_sc_0/5v0_tgate_sel_2_sc_1/input_A 5v0_addh_sc_0/5v0_half_adder_selector_sc_0/res_stage0 0.00253f
C269 VDD_3V3 5v0_addh_sc_1/nti 0.67557f
C270 5v0_addh_sc_0/VDD_1V65 5v0_addh_sc_0/nti 0.21326f
C271 5v0_addh_sc_0/a_382_n1095# VDD_3V3 0.59827f
C272 VDD_3V3 5v0_addh_sc_1/upstepper_test 0.73777f
C273 5v0_addh_sc_1/downstepper_test 5v0_addh_sc_1/ctrl_over 0.1527f
C274 5v0_addh_sc_1/a_n1373_n454# VDD_3V3 0.00122f
C275 5v0_addh_sc_1/m1_103_293# carry_over 0
C276 in_C_sign 5v0_addh_sc_0/upstepper_test 0.20319f
C277 VDD_3V3 5v0_nter2oter_code_sc_0/gf180mcu_fd_sc_mcu7t5v0__nor2_1_0/A1 0.27221f
C278 5v0_addh_sc_0/upstepper_test 5v0_addh_sc_0/VDD_1V65 0.16859f
C279 5v0_addh_sc_1/m1_103_293# 5v0_addh_sc_0/carry_0_probe 0.00264f
C280 5v0_addh_sc_1/inv_nti 5v0_addh_sc_1/ctrl_over 0.66272f
C281 in_C_over 5v0_add_ccal_sc_r1_0/in_sign 0.00166f
C282 5v0_addh_sc_1/ctrl_sign 5v0_addh_sc_1/m1_843_n857# 0.24363f
C283 5v0_addh_sc_1/downstepper_test 5v0_nter2oter_code_sc_0/pti 0
C284 5v0_addh_sc_1/ctrl_over carry_sign 0
C285 5v0_addh_sc_1/inv_pti 5v0_addh_sc_1/pti 0.43582f
C286 5v0_addh_sc_0/m1_103_293# 5v0_addh_sc_0/5v0_half_adder_selector_sc_0/res_stage0 0.18379f
C287 5v0_addh_sc_1/a_382_n1095# 5v0_add_ccal_sc_r1_0/in_sign 0.00159f
C288 5v0_nter2oter_code_sc_0/nti 5v0_add_ccal_sc_r1_0/gf180mcu_fd_sc_mcu7t5v0__xnor2_1_0/a_716_68# 0
C289 5v0_add_ccal_sc_r1_0/gf180mcu_fd_sc_mcu7t5v0__xnor2_1_0/a_64_93# 5v0_addh_sc_1/5v0_half_adder_selector_sc_0/res_stage0 0
C290 5v0_addh_sc_1/m1_103_293# 5v0_add_ccal_sc_r1_0/a_n260_n44# 0.00505f
C291 5v0_addh_sc_0/a_382_n1095# 5v0_addh_sc_0/5v0_half_adder_selector_sc_0/res_stage0 0.08951f
C292 carry_over VDD_3V3 0.35448f
C293 5v0_addh_sc_1/carry_0_probe 5v0_addh_sc_1/pti 0.13493f
C294 5v0_addh_sc_1/ctrl_sign 5v0_addh_sc_1/5v0_half_adder_selector_sc_0/res_stage0 0.24997f
C295 5v0_nter2oter_code_sc_0/pti 5v0_addh_sc_1/inv_nti 0
C296 5v0_addh_sc_0/m1_103_293# 5v0_addh_sc_0/inv_pti 0.17336f
C297 in_B 5v0_addh_sc_1/ctrl_over 0.32222f
C298 5v0_addh_sc_1/ctrl_over 5v0_addh_sc_1/a_n1205_n937# 0.00155f
C299 5v0_addh_sc_0/carry_0_probe VDD_3V3 1.07624f
C300 5v0_addh_sc_0/inv_pti 5v0_addh_sc_0/a_382_n1095# 0.00129f
C301 in_C_over 5v0_nter2oter_code_sc_0/in 0.31357f
C302 5v0_addh_sc_0/inv_nti in_A 0.28245f
C303 5v0_addh_sc_1/downstepper_test 5v0_addh_sc_1/nti 0.05101f
C304 5v0_addh_sc_1/downstepper_test 5v0_addh_sc_1/upstepper_test 0.38089f
C305 5v0_addh_sc_1/downstepper_test 5v0_addh_sc_1/a_n1373_n454# 0.00442f
C306 5v0_add_ccal_sc_r1_0/a_n260_n44# VDD_3V3 0.27931f
C307 sum 5v0_addh_sc_1/carry_0_probe 0
C308 in_B 5v0_nter2oter_code_sc_0/pti 0.03197f
C309 5v0_addh_sc_1/inv_nti 5v0_addh_sc_1/nti 0.22631f
C310 5v0_addh_sc_1/inv_pti 5v0_addh_sc_1/m1_103_293# 0.17666f
C311 5v0_addh_sc_1/inv_nti 5v0_addh_sc_1/upstepper_test 0.00596f
C312 5v0_addh_sc_0/inv_nti 5v0_nter2oter_code_sc_0/pti 0.00357f
C313 5v0_addh_sc_1/a_n1373_n454# 5v0_addh_sc_1/inv_nti 0
C314 5v0_add_ccal_sc_r1_0/in_sign 5v0_addh_sc_1/m1_843_n857# 0.00698f
C315 5v0_addh_sc_0/carry_0_probe 5v0_addh_sc_0/5v0_half_adder_selector_sc_0/res_stage0 0
C316 5v0_addh_sc_1/m1_103_293# 5v0_addh_sc_1/carry_0_probe 0.04228f
C317 5v0_addh_sc_1/downstepper_test 5v0_addh_sc_1/a_n1778_n454# 0.0031f
C318 in_B 5v0_addh_sc_1/nti 0.51611f
C319 5v0_addh_sc_1/a_n1205_n937# 5v0_addh_sc_1/nti 0
C320 in_B 5v0_addh_sc_1/upstepper_test 0.01586f
C321 in_B 5v0_addh_sc_1/a_n1373_n454# 0.00163f
C322 5v0_addh_sc_1/a_n1778_n454# 5v0_addh_sc_1/inv_nti 0.00226f
C323 5v0_addh_sc_1/inv_pti VDD_3V3 0.69264f
C324 5v0_addh_sc_0/inv_nti 5v0_addh_sc_0/m1_103_293# 0.35313f
C325 5v0_addh_sc_1/a_n1205_n937# 5v0_addh_sc_1/upstepper_test 0.00334f
C326 5v0_addh_sc_1/downstepper_test 5v0_addh_sc_0/carry_0_probe 0
C327 5v0_addh_sc_1/a_382_n1095# 5v0_addh_sc_1/m1_843_n857# 0.05013f
C328 5v0_addh_sc_0/inv_nti 5v0_addh_sc_0/a_382_n1095# 0.28643f
C329 5v0_addh_sc_1/carry_0_probe VDD_3V3 0.86653f
C330 in_C_sign 5v0_addh_sc_0/m1_843_n857# 0.24363f
C331 carry_over carry_sign 0.00301f
C332 5v0_addh_sc_0/carry_sign_probe 5v0_addh_sc_1/ctrl_sign 0
C333 in_B 5v0_nter2oter_code_sc_0/gf180mcu_fd_sc_mcu7t5v0__nor2_1_0/A1 0.01953f
C334 in_C_over 5v0_addh_sc_1/5v0_half_adder_selector_sc_0/res_stage0 0
C335 5v0_addh_sc_0/downstepper_test 5v0_addh_sc_0/pti 0.20147f
C336 5v0_add_ccal_sc_r1_0/gf180mcu_fd_sc_mcu7t5v0__xnor2_1_0/a_930_497# 5v0_add_ccal_sc_r1_0/gf180mcu_fd_sc_mcu7t5v0__xnor2_1_0/a_64_93# 0
C337 5v0_addh_sc_0/inv_nti 5v0_addh_sc_0/a_n1778_n454# 0.00226f
C338 5v0_addh_sc_0/carry_0_probe 5v0_addh_sc_1/inv_nti 0
C339 in_B 5v0_addh_sc_1/a_n1778_n454# 0.00182f
C340 5v0_addh_sc_1/a_382_n1095# 5v0_addh_sc_1/5v0_half_adder_selector_sc_0/res_stage0 0.08951f
C341 5v0_add_ccal_sc_r1_0/gf180mcu_fd_sc_mcu7t5v0__xnor2_1_0/a_930_497# 5v0_addh_sc_1/ctrl_sign 0.00192f
C342 5v0_addh_sc_0/carry_0_probe carry_sign 0.24328f
C343 5v0_addh_sc_1/5v0_half_adder_selector_sc_0/5v0_tgate_sel_2_sc_1/input_A 5v0_addh_sc_1/ctrl_sign 0
C344 5v0_addh_sc_0/carry_sign_probe 5v0_addh_sc_0/pti 0.01871f
C345 5v0_addh_sc_1/inv_nti 5v0_add_ccal_sc_r1_0/a_n260_n44# 0
C346 5v0_addh_sc_0/downstepper_test 5v0_addh_sc_0/a_n1373_n454# 0.00442f
C347 5v0_addh_sc_1/VDD_1V65 5v0_addh_sc_1/ctrl_over 0.06606f
C348 5v0_add_ccal_sc_r1_0/a_n260_n44# carry_sign 0.16028f
C349 5v0_addh_sc_1/carry_0_probe 5v0_addh_sc_0/5v0_half_adder_selector_sc_0/res_stage0 0
C350 5v0_addh_sc_0/inv_nti carry_over 0.00107f
C351 in_B 5v0_addh_sc_0/carry_0_probe 0
C352 5v0_nter2oter_code_sc_0/gf180mcu_fd_sc_mcu7t5v0__nor2_1_0/a_224_472# VDD_3V3 0.01448f
C353 in_A 5v0_addh_sc_0/nti 0.52068f
C354 5v0_addh_sc_1/inv_pti 5v0_addh_sc_1/downstepper_test 0.11697f
C355 5v0_addh_sc_0/inv_nti 5v0_addh_sc_0/carry_0_probe 0.01696f
C356 5v0_addh_sc_1/downstepper_test 5v0_addh_sc_1/carry_0_probe 0
C357 5v0_add_ccal_sc_r1_0/gf180mcu_fd_sc_mcu7t5v0__xnor2_1_0/a_272_93# carry_over 0
C358 5v0_addh_sc_0/inv_nti 5v0_add_ccal_sc_r1_0/a_n260_n44# 0
C359 5v0_addh_sc_0/carry_sign_probe 5v0_add_ccal_sc_r1_0/in_sign 0.17983f
C360 5v0_addh_sc_1/ctrl_sign 5v0_addh_sc_1/pti 0.28088f
C361 5v0_addh_sc_1/inv_pti 5v0_addh_sc_1/inv_nti 0.25966f
C362 5v0_addh_sc_0/upstepper_test in_A 0.01604f
C363 5v0_nter2oter_code_sc_0/pti 5v0_addh_sc_0/nti 0.00926f
C364 5v0_addh_sc_0/downstepper_test in_C_over 0.03354f
C365 5v0_addh_sc_1/inv_pti carry_sign 0
C366 5v0_addh_sc_1/carry_0_probe 5v0_addh_sc_1/inv_nti 0.39282f
C367 5v0_addh_sc_0/downstepper_test 5v0_nter2oter_code_sc_0/in 0.05426f
C368 5v0_addh_sc_1/VDD_1V65 5v0_addh_sc_1/nti 0.21326f
C369 5v0_addh_sc_1/carry_0_probe carry_sign 0.05428f
C370 5v0_add_ccal_sc_r1_0/gf180mcu_fd_sc_mcu7t5v0__xnor2_1_0/a_716_68# in_A 0
C371 5v0_addh_sc_1/VDD_1V65 5v0_addh_sc_1/upstepper_test 0.16859f
C372 5v0_addh_sc_0/carry_sign_probe in_C_over 0.03546f
C373 5v0_addh_sc_1/a_n1373_n454# 5v0_addh_sc_1/VDD_1V65 0.00232f
C374 5v0_addh_sc_0/5v0_half_adder_selector_sc_0/5v0_tgate_sel_2_sc_1/input_A 5v0_addh_sc_0/upstepper_test 0
C375 5v0_addh_sc_1/inv_pti in_B 0.05506f
C376 sum 5v0_addh_sc_1/ctrl_sign 0
C377 5v0_addh_sc_0/carry_sign_probe 5v0_nter2oter_code_sc_0/in 0
C378 5v0_add_ccal_sc_r1_0/gf180mcu_fd_sc_mcu7t5v0__xnor2_1_0/a_930_497# in_C_over 0.00117f
C379 in_B 5v0_addh_sc_1/carry_0_probe 0.00143f
C380 5v0_addh_sc_0/a_382_n1095# 5v0_addh_sc_0/nti 0
C381 in_C_sign in_A 0.07321f
C382 5v0_addh_sc_1/5v0_half_adder_selector_sc_0/5v0_tgate_sel_2_sc_1/input_A 5v0_addh_sc_1/a_382_n1095# 0.02928f
C383 5v0_addh_sc_1/a_n1778_n454# 5v0_addh_sc_1/VDD_1V65 0
C384 5v0_addh_sc_1/m1_103_293# 5v0_addh_sc_1/ctrl_sign 0.61412f
C385 5v0_addh_sc_0/inv_nti 5v0_addh_sc_1/carry_0_probe 0
C386 5v0_nter2oter_code_sc_0/nti in_A 0
C387 5v0_addh_sc_0/a_n1778_n454# 5v0_addh_sc_0/nti 0
C388 5v0_addh_sc_0/VDD_1V65 in_A 0.01451f
C389 5v0_addh_sc_0/m1_103_293# 5v0_addh_sc_0/upstepper_test 0.07658f
C390 5v0_nter2oter_code_sc_0/nti 5v0_addh_sc_1/ctrl_over 0.21147f
C391 5v0_add_ccal_sc_r1_0/in_sign 5v0_addh_sc_1/pti 0.01104f
C392 5v0_nter2oter_code_sc_0/gf180mcu_fd_sc_mcu7t5v0__nor2_1_0/A1 5v0_addh_sc_0/nti 0
C393 in_C_sign 5v0_addh_sc_0/5v0_half_adder_selector_sc_0/5v0_tgate_sel_2_sc_1/input_A 0
C394 5v0_addh_sc_0/carry_0_probe 5v0_addh_sc_1/VDD_1V65 0
C395 5v0_add_ccal_sc_r1_0/gf180mcu_fd_sc_mcu7t5v0__xnor2_1_0/a_64_93# VDD_3V3 0.3533f
C396 5v0_addh_sc_0/a_n1778_n454# 5v0_addh_sc_0/upstepper_test 0
C397 5v0_addh_sc_0/a_382_n1095# 5v0_add_ccal_sc_r1_0/gf180mcu_fd_sc_mcu7t5v0__xnor2_1_0/a_716_68# 0
C398 5v0_nter2oter_code_sc_0/nti 5v0_nter2oter_code_sc_0/pti 0.13949f
C399 VDD_3V3 5v0_addh_sc_1/ctrl_sign 1.12469f
C400 in_C_over 5v0_addh_sc_1/pti 0
C401 in_B 5v0_nter2oter_code_sc_0/gf180mcu_fd_sc_mcu7t5v0__nor2_1_0/a_224_472# 0.00437f
C402 5v0_nter2oter_code_sc_0/in 5v0_addh_sc_1/pti 0
C403 5v0_addh_sc_1/a_382_n1095# 5v0_addh_sc_1/pti 0.12627f
C404 5v0_addh_sc_0/carry_0_probe 5v0_addh_sc_0/nti 0
C405 5v0_addh_sc_0/m1_103_293# in_C_sign 0.63515f
C406 5v0_addh_sc_0/pti VDD_3V3 0.6527f
C407 in_C_sign 5v0_addh_sc_0/a_382_n1095# 0.07412f
C408 5v0_add_ccal_sc_r1_0/gf180mcu_fd_sc_mcu7t5v0__xnor2_1_0/a_64_93# 5v0_addh_sc_0/5v0_half_adder_selector_sc_0/res_stage0 0
C409 5v0_addh_sc_1/m1_103_293# 5v0_add_ccal_sc_r1_0/in_sign 0.23584f
C410 5v0_nter2oter_code_sc_0/nti 5v0_addh_sc_1/nti 0.00212f
C411 5v0_addh_sc_0/a_n1373_n454# VDD_3V3 0.00122f
C412 5v0_addh_sc_0/m1_843_n857# in_A 0
C413 5v0_addh_sc_1/5v0_half_adder_selector_sc_0/5v0_tgate_sel_2_sc_1/input_A 5v0_addh_sc_1/5v0_half_adder_selector_sc_0/res_stage0 0.00253f
C414 5v0_addh_sc_0/carry_0_probe 5v0_addh_sc_0/upstepper_test 0
C415 carry_over 5v0_add_ccal_sc_r1_0/gf180mcu_fd_sc_mcu7t5v0__xnor2_1_0/a_716_68# 0.215f
C416 5v0_addh_sc_1/a_382_n1095# sum 0.16245f
C417 5v0_addh_sc_1/inv_pti 5v0_addh_sc_1/VDD_1V65 0.14775f
C418 5v0_addh_sc_0/a_n1778_n454# 5v0_addh_sc_0/VDD_1V65 0
C419 5v0_addh_sc_1/m1_103_293# in_C_over 0
C420 5v0_addh_sc_0/carry_0_probe 5v0_add_ccal_sc_r1_0/gf180mcu_fd_sc_mcu7t5v0__xnor2_1_0/a_716_68# 0.02428f
C421 5v0_addh_sc_1/downstepper_test 5v0_add_ccal_sc_r1_0/gf180mcu_fd_sc_mcu7t5v0__xnor2_1_0/a_64_93# 0.00144f
C422 5v0_nter2oter_code_sc_0/nti 5v0_nter2oter_code_sc_0/gf180mcu_fd_sc_mcu7t5v0__nor2_1_0/A1 0.02637f
C423 5v0_addh_sc_0/5v0_half_adder_selector_sc_0/res_stage0 5v0_addh_sc_0/pti 0.01078f
C424 5v0_addh_sc_0/inv_pti 5v0_addh_sc_1/ctrl_sign 0
C425 5v0_add_ccal_sc_r1_0/in_sign VDD_3V3 0.19889f
C426 5v0_addh_sc_1/a_382_n1095# 5v0_addh_sc_1/m1_103_293# 0.07764f
C427 5v0_addh_sc_1/downstepper_test 5v0_addh_sc_1/ctrl_sign 0.22547f
C428 in_C_sign carry_over 0
C429 5v0_addh_sc_1/pti 5v0_addh_sc_1/m1_843_n857# 0.11666f
C430 5v0_add_ccal_sc_r1_0/gf180mcu_fd_sc_mcu7t5v0__xnor2_1_0/a_64_93# 5v0_addh_sc_1/inv_nti 0
C431 5v0_nter2oter_code_sc_0/nti carry_over 0
C432 5v0_addh_sc_0/inv_pti 5v0_addh_sc_0/pti 0.43735f
C433 in_C_sign 5v0_addh_sc_0/carry_0_probe 0.00936f
C434 5v0_addh_sc_1/5v0_half_adder_selector_sc_0/res_stage0 5v0_addh_sc_1/pti 0.01078f
C435 5v0_addh_sc_1/inv_nti 5v0_addh_sc_1/ctrl_sign 0.24909f
C436 in_C_over VDD_3V3 0.9684f
C437 5v0_addh_sc_1/ctrl_sign carry_sign 0.01563f
C438 5v0_nter2oter_code_sc_0/nti 5v0_addh_sc_0/carry_0_probe 0.00756f
C439 5v0_addh_sc_0/downstepper_test 5v0_addh_sc_0/carry_sign_probe 0
C440 5v0_addh_sc_0/m1_103_293# 5v0_addh_sc_0/m1_843_n857# 0.20659f
C441 VDD_3V3 5v0_nter2oter_code_sc_0/in 1.23199f
C442 5v0_addh_sc_0/carry_0_probe 5v0_addh_sc_0/VDD_1V65 0
C443 5v0_addh_sc_1/a_382_n1095# VDD_3V3 0.58103f
C444 5v0_addh_sc_0/inv_pti 5v0_addh_sc_0/a_n1373_n454# 0.00135f
C445 5v0_addh_sc_0/a_382_n1095# 5v0_addh_sc_0/m1_843_n857# 0.05013f
C446 in_B 5v0_add_ccal_sc_r1_0/gf180mcu_fd_sc_mcu7t5v0__xnor2_1_0/a_64_93# 0
C447 5v0_addh_sc_1/carry_0_probe 5v0_addh_sc_0/upstepper_test 0
C448 in_B 5v0_addh_sc_1/ctrl_sign 0
C449 sum 5v0_addh_sc_1/5v0_half_adder_selector_sc_0/res_stage0 0.08533f
C450 5v0_addh_sc_1/inv_pti 5v0_add_ccal_sc_r1_0/gf180mcu_fd_sc_mcu7t5v0__xnor2_1_0/a_716_68# 0.00247f
C451 5v0_addh_sc_0/inv_nti 5v0_add_ccal_sc_r1_0/gf180mcu_fd_sc_mcu7t5v0__xnor2_1_0/a_64_93# 0
C452 5v0_addh_sc_1/m1_103_293# 5v0_addh_sc_1/m1_843_n857# 0.20659f
C453 5v0_addh_sc_0/inv_nti 5v0_addh_sc_1/ctrl_sign 0
C454 5v0_addh_sc_1/carry_0_probe 5v0_add_ccal_sc_r1_0/gf180mcu_fd_sc_mcu7t5v0__xnor2_1_0/a_716_68# 0.05216f
C455 5v0_addh_sc_1/downstepper_test 5v0_add_ccal_sc_r1_0/in_sign 0
C456 in_C_over 5v0_addh_sc_0/5v0_half_adder_selector_sc_0/res_stage0 0.09613f
C457 5v0_addh_sc_0/5v0_half_adder_selector_sc_0/res_stage0 5v0_nter2oter_code_sc_0/in 0.09409f
C458 5v0_addh_sc_1/m1_103_293# 5v0_addh_sc_1/5v0_half_adder_selector_sc_0/res_stage0 0.18549f
C459 5v0_addh_sc_0/inv_nti 5v0_addh_sc_0/pti 0.42004f
C460 carry_over 5v0_addh_sc_0/m1_843_n857# 0.02574f
C461 5v0_add_ccal_sc_r1_0/gf180mcu_fd_sc_mcu7t5v0__xnor2_1_0/a_272_93# 5v0_add_ccal_sc_r1_0/gf180mcu_fd_sc_mcu7t5v0__xnor2_1_0/a_64_93# 0.00372f
C462 5v0_addh_sc_1/inv_nti 5v0_add_ccal_sc_r1_0/in_sign 0.05332f
C463 5v0_addh_sc_0/inv_pti in_C_over 0.00306f
C464 5v0_add_ccal_sc_r1_0/gf180mcu_fd_sc_mcu7t5v0__xnor2_1_0/a_272_93# 5v0_addh_sc_1/ctrl_sign 0
C465 5v0_addh_sc_1/downstepper_test in_C_over 0
C466 5v0_add_ccal_sc_r1_0/in_sign carry_sign 0.15216f
C467 VDD_3V3 5v0_addh_sc_1/m1_843_n857# 0.12251f
C468 5v0_addh_sc_0/inv_pti 5v0_nter2oter_code_sc_0/in 0
C469 5v0_addh_sc_0/carry_0_probe 5v0_addh_sc_0/m1_843_n857# 0.18526f
C470 5v0_addh_sc_1/downstepper_test 5v0_addh_sc_1/a_382_n1095# 0.00679f
C471 5v0_nter2oter_code_sc_0/nti 5v0_addh_sc_1/carry_0_probe 0.00625f
C472 5v0_addh_sc_0/inv_nti 5v0_addh_sc_0/a_n1373_n454# 0
C473 VDD_3V3 5v0_addh_sc_1/5v0_half_adder_selector_sc_0/res_stage0 0.14594f
C474 5v0_addh_sc_0/carry_sign_probe 5v0_addh_sc_1/pti 0.00123f
C475 in_C_over carry_sign 0.00173f
C476 5v0_nter2oter_code_sc_0/pti in_A 0.00193f
C477 5v0_addh_sc_1/a_382_n1095# 5v0_addh_sc_1/inv_nti 0.2846f
C478 5v0_nter2oter_code_sc_0/pti 5v0_addh_sc_1/ctrl_over 0.07536f
C479 5v0_addh_sc_1/a_382_n1095# carry_sign 0
C480 in_B 5v0_nter2oter_code_sc_0/in 0.00439f
C481 5v0_addh_sc_1/a_382_n1095# in_B 0.09306f
C482 5v0_addh_sc_0/m1_103_293# in_A 0
C483 5v0_nter2oter_code_sc_0/nti 5v0_nter2oter_code_sc_0/gf180mcu_fd_sc_mcu7t5v0__nor2_1_0/a_224_472# 0.00898f
C484 5v0_addh_sc_0/inv_nti in_C_over 0.23849f
C485 5v0_addh_sc_0/a_382_n1095# in_A 0.09306f
C486 5v0_addh_sc_1/ctrl_over 5v0_addh_sc_1/nti 0.09725f
C487 5v0_addh_sc_0/inv_nti 5v0_nter2oter_code_sc_0/in 0.03012f
C488 5v0_addh_sc_1/ctrl_over 5v0_addh_sc_1/upstepper_test 0.00631f
C489 5v0_addh_sc_1/a_n1373_n454# 5v0_addh_sc_1/ctrl_over 0
C490 5v0_addh_sc_1/m1_103_293# 5v0_addh_sc_0/carry_sign_probe 0
C491 5v0_addh_sc_0/a_n1205_n937# in_C_over 0.00106f
C492 5v0_addh_sc_1/carry_0_probe 5v0_addh_sc_0/m1_843_n857# 0
C493 5v0_addh_sc_0/a_n1778_n454# in_A 0.00182f
C494 5v0_add_ccal_sc_r1_0/gf180mcu_fd_sc_mcu7t5v0__xnor2_1_0/a_64_93# 5v0_addh_sc_0/nti 0
C495 5v0_addh_sc_1/downstepper_test 5v0_addh_sc_1/5v0_half_adder_selector_sc_0/res_stage0 0.24494f
C496 5v0_addh_sc_1/inv_nti 5v0_addh_sc_1/m1_843_n857# 0.36668f
C497 5v0_addh_sc_0/5v0_half_adder_selector_sc_0/5v0_tgate_sel_2_sc_1/input_A 5v0_addh_sc_0/a_382_n1095# 0.02928f
C498 5v0_add_ccal_sc_r1_0/gf180mcu_fd_sc_mcu7t5v0__xnor2_1_0/a_272_93# in_C_over 0
C499 5v0_addh_sc_1/ctrl_sign 5v0_addh_sc_0/nti 0
C500 5v0_nter2oter_code_sc_0/pti 5v0_addh_sc_1/nti 0.02317f
C501 5v0_addh_sc_1/ctrl_over 5v0_nter2oter_code_sc_0/gf180mcu_fd_sc_mcu7t5v0__nor2_1_0/A1 0.37378f
C502 5v0_addh_sc_0/downstepper_test VDD_3V3 0.48372f
C503 carry_sign 5v0_addh_sc_1/m1_843_n857# 0
C504 5v0_add_ccal_sc_r1_0/gf180mcu_fd_sc_mcu7t5v0__xnor2_1_0/a_272_93# 5v0_nter2oter_code_sc_0/in 0
C505 5v0_nter2oter_code_sc_0/pti 5v0_addh_sc_1/upstepper_test 0
C506 5v0_addh_sc_1/a_n1778_n454# 5v0_addh_sc_1/ctrl_over 0
C507 5v0_addh_sc_1/inv_nti 5v0_addh_sc_1/5v0_half_adder_selector_sc_0/res_stage0 0.02051f
C508 5v0_add_ccal_sc_r1_0/gf180mcu_fd_sc_mcu7t5v0__xnor2_1_0/a_64_93# 5v0_addh_sc_0/upstepper_test 0
C509 carry_over in_A 0.0014f
C510 5v0_addh_sc_0/carry_sign_probe VDD_3V3 0.24981f
C511 5v0_addh_sc_0/pti 5v0_addh_sc_0/nti 0.23276f
C512 in_B 5v0_addh_sc_1/m1_843_n857# 0
C513 sum 5v0_addh_sc_1/pti 0
C514 5v0_nter2oter_code_sc_0/pti 5v0_nter2oter_code_sc_0/gf180mcu_fd_sc_mcu7t5v0__nor2_1_0/A1 0.26329f
C515 5v0_add_ccal_sc_r1_0/gf180mcu_fd_sc_mcu7t5v0__xnor2_1_0/a_930_497# VDD_3V3 0.01437f
C516 5v0_addh_sc_0/carry_0_probe in_A 0.00552f
C517 5v0_addh_sc_0/m1_103_293# 5v0_addh_sc_0/a_382_n1095# 0.07764f
C518 5v0_add_ccal_sc_r1_0/gf180mcu_fd_sc_mcu7t5v0__xnor2_1_0/a_64_93# 5v0_add_ccal_sc_r1_0/gf180mcu_fd_sc_mcu7t5v0__xnor2_1_0/a_716_68# 0.00587f
C519 5v0_addh_sc_0/carry_0_probe 5v0_addh_sc_1/ctrl_over 0
C520 5v0_addh_sc_1/5v0_half_adder_selector_sc_0/5v0_tgate_sel_2_sc_1/input_A VDD_3V3 0.02871f
C521 5v0_addh_sc_0/a_n1373_n454# 5v0_addh_sc_0/nti 0
C522 5v0_addh_sc_1/upstepper_test 5v0_addh_sc_1/nti 0.11007f
C523 in_B 5v0_addh_sc_1/5v0_half_adder_selector_sc_0/res_stage0 0.26626f
C524 5v0_addh_sc_0/downstepper_test 5v0_addh_sc_0/5v0_half_adder_selector_sc_0/res_stage0 0.25483f
C525 5v0_add_ccal_sc_r1_0/gf180mcu_fd_sc_mcu7t5v0__xnor2_1_0/a_716_68# 5v0_addh_sc_1/ctrl_sign 0
C526 5v0_addh_sc_1/a_n1373_n454# 5v0_addh_sc_1/nti 0
C527 5v0_addh_sc_0/a_382_n1095# 5v0_addh_sc_1/upstepper_test 0
C528 5v0_addh_sc_0/upstepper_test 5v0_addh_sc_0/pti 0.02362f
C529 5v0_nter2oter_code_sc_0/pti carry_over 0
C530 5v0_addh_sc_1/a_n1205_n937# 5v0_addh_sc_1/5v0_half_adder_selector_sc_0/res_stage0 0
C531 5v0_addh_sc_1/a_n1373_n454# 5v0_addh_sc_1/upstepper_test 0
C532 5v0_addh_sc_1/m1_103_293# 5v0_addh_sc_1/pti 0.09994f
C533 carry_sign VSS 0.04388f
C534 5v0_add_ccal_sc_r1_0/a_n260_n44# VSS 0.29929f ; **FLOATING
C535 carry_over VSS 0.51042f
C536 5v0_addh_sc_0/carry_0_probe VSS 1.06364f
C537 5v0_add_ccal_sc_r1_0/gf180mcu_fd_sc_mcu7t5v0__xnor2_1_0/a_716_68# VSS 0.39576f ; **FLOATING
C538 5v0_add_ccal_sc_r1_0/gf180mcu_fd_sc_mcu7t5v0__xnor2_1_0/a_272_93# VSS 0.00614f ; **FLOATING
C539 5v0_add_ccal_sc_r1_0/gf180mcu_fd_sc_mcu7t5v0__xnor2_1_0/a_930_497# VSS 0.00162f ; **FLOATING
C540 5v0_add_ccal_sc_r1_0/gf180mcu_fd_sc_mcu7t5v0__xnor2_1_0/a_64_93# VSS 0.53355f ; **FLOATING
C541 5v0_nter2oter_code_sc_0/gf180mcu_fd_sc_mcu7t5v0__nor2_1_0/A1 VSS 0.39973f
C542 5v0_nter2oter_code_sc_0/pti VSS 0.91349f
C543 5v0_nter2oter_code_sc_0/nti VSS 0.83267f
C544 5v0_nter2oter_code_sc_0/gf180mcu_fd_sc_mcu7t5v0__nor2_1_0/a_224_472# VSS 0.00184f ; **FLOATING
C545 5v0_addh_sc_1/pti VSS 1.24857f
C546 5v0_addh_sc_1/VDD_1V65 VSS 0.09068f
C547 5v0_addh_sc_1/inv_nti VSS 1.24482f
C548 5v0_addh_sc_1/m1_843_n857# VSS 0.15939f ; **FLOATING
C549 5v0_addh_sc_1/ctrl_sign VSS 1.05268f
C550 5v0_addh_sc_1/a_n1205_n937# VSS 0 ; **FLOATING
C551 5v0_addh_sc_1/a_n1373_n454# VSS 0.00335f ; **FLOATING
C552 5v0_addh_sc_1/a_n1778_n454# VSS 0.00573f ; **FLOATING
C553 5v0_addh_sc_1/inv_pti VSS 1.24442f
C554 5v0_add_ccal_sc_r1_0/in_sign VSS 0.11384f
C555 5v0_addh_sc_1/carry_0_probe VSS 1.20012f
C556 5v0_addh_sc_1/5v0_half_adder_selector_sc_0/5v0_tgate_sel_2_sc_1/input_A VSS 0
C557 5v0_addh_sc_1/a_382_n1095# VSS 0.80936f ; **FLOATING
C558 in_B VSS 1.58466f
C559 sum VSS 0.03057f
C560 5v0_addh_sc_1/ctrl_over VSS 1.26374f
C561 VDD_3V3 VSS 39.0433f
C562 5v0_addh_sc_1/m1_103_293# VSS 0.7535f ; **FLOATING
C563 5v0_addh_sc_1/5v0_half_adder_selector_sc_0/res_stage0 VSS 0.50069f
C564 5v0_addh_sc_1/downstepper_test VSS 0.62825f
C565 5v0_addh_sc_1/upstepper_test VSS 0.60726f
C566 5v0_addh_sc_1/nti VSS 1.22335f
C567 5v0_addh_sc_0/pti VSS 1.22189f
C568 5v0_addh_sc_0/VDD_1V65 VSS 0.09081f
C569 5v0_addh_sc_0/inv_nti VSS 1.3699f
C570 5v0_addh_sc_0/m1_843_n857# VSS 0.15939f ; **FLOATING
C571 in_C_sign VSS 1.36177f
C572 5v0_addh_sc_0/a_n1205_n937# VSS 0 ; **FLOATING
C573 5v0_addh_sc_0/a_n1373_n454# VSS 0.00335f ; **FLOATING
C574 5v0_addh_sc_0/a_n1778_n454# VSS 0.00692f ; **FLOATING
C575 5v0_addh_sc_0/inv_pti VSS 1.09974f
C576 5v0_addh_sc_0/carry_sign_probe VSS 1.02667f
C577 5v0_addh_sc_0/5v0_half_adder_selector_sc_0/5v0_tgate_sel_2_sc_1/input_A VSS 0
C578 5v0_addh_sc_0/a_382_n1095# VSS 0.81948f ; **FLOATING
C579 in_A VSS 1.66357f
C580 5v0_nter2oter_code_sc_0/in VSS 1.41053f
C581 in_C_over VSS 0.83852f
C582 5v0_addh_sc_0/m1_103_293# VSS 0.75306f ; **FLOATING
C583 5v0_addh_sc_0/5v0_half_adder_selector_sc_0/res_stage0 VSS 0.51204f
C584 5v0_addh_sc_0/downstepper_test VSS 0.5928f
C585 5v0_addh_sc_0/upstepper_test VSS 0.53881f
C586 5v0_addh_sc_0/nti VSS 1.21749f
