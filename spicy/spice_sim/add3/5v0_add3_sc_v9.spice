* NGSPICE file created from 5v0_add3_sc.ext - technology: gf180mcuD

.option scale=5n

X0 int_c01 m1_n2844_n810# c01 VSS_3 nfet_06v0 ad=14.432n pd=0.504m as=14.432n ps=0.504m w=164 l=120
X1 VDD_1V65_2 c01over int_c01 VSS_3 nfet_06v0 ad=14.432n pd=0.504m as=14.432n ps=0.504m w=164 l=120
X2 5v0_add_q_sc_0/pti int_carry VSS_3 VSS_3 nfet_06v0 ad=6.336n pd=0.32m as=6.478n ps=0.255m w=72 l=578
X3 VDD_3V3_0 int_carry 5v0_add_q_sc_0/pti VDD_3V3_0 pfet_06v0 ad=12.81n pd=0.349m as=12.688n ps=0.348m w=244 l=100
X4 VDD_3V3_0 int_carry 5v0_add_q_sc_0/nti VDD_3V3_0 pfet_06v0 ad=13.616n pd=0.392m as=9.696n ps=0.394m w=96 l=150
X5 VSS_3 int_carry 5v0_add_q_sc_0/nti VSS_3 nfet_06v0 ad=6.478n pd=0.255m as=12.7n ps=0.454m w=127 l=120
X6 5v0_add_q_sc_0/pti int_carry VDD_3V3_0 VDD_3V3_0 pfet_06v0 ad=12.688n pd=0.348m as=13.616n ps=0.392m w=244 l=100
X7 5v0_add_q_sc_0/pti int_carry VDD_3V3_0 VDD_3V3_0 pfet_06v0 ad=27.328n pd=0.712m as=12.81n ps=0.349m w=244 l=100
X8 5v0_add_q_sc_0/5v0_half_adder_selector_sc_0/res_stage0 5v0_add_q_sc_0/5v0_half_adder_selector_sc_0/m1_n239_179# 5v0_add_q_sc_0/downstepper_test VSS_3 nfet_06v0 ad=14.432n pd=0.504m as=14.432n ps=0.504m w=164 l=120
X9 5v0_add_q_sc_0/5v0_half_adder_selector_sc_0/res_stage0 5v0_add_q_sc_0/5v0_half_adder_selector_sc_0/m1_n239_179# 5v0_add_q_sc_0/upstepper_test VDD_3V3_0 pfet_06v0 ad=21.472n pd=0.664m as=21.472n ps=0.664m w=244 l=100
X10 5v0_add_q_sc_0/5v0_half_adder_selector_sc_0/m1_n239_179# 5v0_add_q_sc_0/ctrl_sign VSS_3 VSS_3 nfet_06v0 ad=14.432n pd=0.504m as=14.432n ps=0.504m w=164 l=120
X11 5v0_add_q_sc_0/5v0_half_adder_selector_sc_0/m1_n239_179# 5v0_add_q_sc_0/ctrl_sign VDD_3V3_0 VDD_3V3_0 pfet_06v0 ad=21.472n pd=0.664m as=21.472n ps=0.664m w=244 l=100
X12 5v0_add_q_sc_0/5v0_half_adder_selector_sc_0/res_stage0 5v0_add_q_sc_0/ctrl_sign 5v0_add_q_sc_0/upstepper_test VSS_3 nfet_06v0 ad=31.489n pd=1.041m as=43.711n ps=1.504m w=164 l=120
X13 5v0_add_q_sc_0/5v0_half_adder_selector_sc_0/res_stage0 5v0_add_q_sc_0/ctrl_sign 5v0_add_q_sc_0/downstepper_test VDD_3V3_0 pfet_06v0 ad=46.849n pd=1.361m as=42.856n ps=1.326m w=244 l=100
X14 res_c 5v0_add_q_sc_0/5v0_half_adder_selector_sc_0/m1_n244_n517# 5v0_add_q_sc_0/5v0_half_adder_selector_sc_0/res_stage0 VSS_3 nfet_06v0 ad=17.057n pd=0.537m as=0 ps=0 w=164 l=120
X15 res_c 5v0_add_q_sc_0/5v0_half_adder_selector_sc_0/m1_n244_n517# int_carry VDD_3V3_0 pfet_06v0 ad=25.377n pd=0.697m as=46.849n ps=1.361m w=244 l=100
X16 5v0_add_q_sc_0/5v0_half_adder_selector_sc_0/m1_n244_n517# 5v0_add_q_sc_0/ctrl_over VSS_3 VSS_3 nfet_06v0 ad=14.432n pd=0.504m as=0.59241u ps=0.02092 w=164 l=120
X17 5v0_add_q_sc_0/5v0_half_adder_selector_sc_0/m1_n244_n517# 5v0_add_q_sc_0/ctrl_over VDD_3V3_0 VDD_3V3_0 pfet_06v0 ad=21.472n pd=0.664m as=0.50045u ps=0.0145 w=244 l=100
X18 res_c 5v0_add_q_sc_0/ctrl_over int_carry VSS_3 nfet_06v0 ad=0 pd=0 as=31.489n ps=1.041m w=164 l=120
X19 res_c 5v0_add_q_sc_0/ctrl_over 5v0_add_q_sc_0/5v0_half_adder_selector_sc_0/res_stage0 VDD_3V3_0 pfet_06v0 ad=0 pd=0 as=0 ps=0 w=244 l=100
X20 5v0_add_q_sc_0/inv_pti 5v0_add_q_sc_0/pti VSS_3 VSS_3 nfet_06v0 ad=14.432n pd=0.504m as=14.432n ps=0.504m w=164 l=120
X21 5v0_add_q_sc_0/inv_pti 5v0_add_q_sc_0/pti VDD_3V3_0 VDD_3V3_0 pfet_06v0 ad=21.472n pd=0.664m as=21.472n ps=0.664m w=244 l=100
X22 5v0_add_q_sc_0/a_n1373_n454# 5v0_add_q_sc_0/inv_nti 5v0_add_q_sc_0/downstepper_test VSS_3 nfet_06v0 ad=3.528n pd=0.195m as=8.599n ps=0.264m w=147 l=120
X23 5v0_add_q_sc_0/upstepper_test 5v0_add_q_sc_0/nti 5v0_add_q_sc_0/a_n1205_n937# VDD_3V3_0 pfet_06v0 ad=21.384n pd=0.662m as=5.832n ps=0.291m w=243 l=100
X24 5v0_add_q_sc_0/inv_nti 5v0_add_q_sc_0/nti VDD_3V3_0 VDD_3V3_0 pfet_06v0 ad=21.472n pd=0.664m as=21.472n ps=0.664m w=244 l=100
X25 5v0_add_q_sc_0/upstepper_test 5v0_add_q_sc_0/nti VDD_1V65_5 VSS_3 nfet_06v0 ad=14.847n pd=0.496m as=10.51n ps=0.29m w=147 l=120
X26 5v0_add_q_sc_0/a_n1205_n937# 5v0_add_q_sc_0/inv_pti VDD_3V3_0 VDD_3V3_0 pfet_06v0 ad=5.832n pd=0.291m as=21.384n ps=0.662m w=243 l=100
X27 5v0_add_q_sc_0/downstepper_test 5v0_add_q_sc_0/pti 5v0_add_q_sc_0/a_n1778_n454# VSS_3 nfet_06v0 ad=8.599n pd=0.264m as=3.528n ps=0.195m w=147 l=120
X28 5v0_add_q_sc_0/inv_nti 5v0_add_q_sc_0/nti VSS_3 VSS_3 nfet_06v0 ad=14.432n pd=0.504m as=14.432n ps=0.504m w=164 l=120
X29 5v0_add_q_sc_0/a_n1778_n454# 5v0_add_q_sc_0/inv_nti VSS_3 VSS_3 nfet_06v0 ad=3.528n pd=0.195m as=14.847n ps=0.496m w=147 l=120
X30 5v0_add_q_sc_0/upstepper_test 5v0_add_q_sc_0/inv_pti VSS_3 VSS_3 nfet_06v0 ad=14.432n pd=0.504m as=14.432n ps=0.504m w=164 l=120
X31 VDD_1V65_5 5v0_add_q_sc_0/inv_pti 5v0_add_q_sc_0/a_n1373_n454# VSS_3 nfet_06v0 ad=10.51n pd=0.29m as=3.528n ps=0.195m w=147 l=120
X32 5v0_add_q_sc_0/downstepper_test 5v0_add_q_sc_0/inv_nti VDD_3V3_0 VDD_3V3_0 pfet_06v0 ad=21.384n pd=0.662m as=21.384n ps=0.662m w=243 l=100
X33 5v0_add_q_sc_1/pti int_c01 VSS_3 VSS_3 nfet_06v0 ad=6.336n pd=0.32m as=0 ps=0 w=72 l=578
X34 VDD_3V3_1 int_c01 5v0_add_q_sc_1/pti VDD_3V3_1 pfet_06v0 ad=0.54021u pd=0.01553 as=52.704n ps=1.408m w=244 l=100
X35 VDD_3V3_1 int_c01 5v0_add_q_sc_1/nti VDD_3V3_1 pfet_06v0 ad=0 pd=0 as=9.696n ps=0.394m w=96 l=150
X36 VSS_3 int_c01 5v0_add_q_sc_1/nti VSS_3 nfet_06v0 ad=0 pd=0 as=12.7n ps=0.454m w=127 l=120
X37 5v0_add_q_sc_1/pti int_c01 VDD_3V3_1 VDD_3V3_1 pfet_06v0 ad=0 pd=0 as=0 ps=0 w=244 l=100
X38 5v0_add_q_sc_1/pti int_c01 VDD_3V3_1 VDD_3V3_1 pfet_06v0 ad=0 pd=0 as=0 ps=0 w=244 l=100
X39 5v0_add_q_sc_1/5v0_half_adder_selector_sc_0/res_stage0 5v0_add_q_sc_1/5v0_half_adder_selector_sc_0/m1_n239_179# 5v0_add_q_sc_1/downstepper_test VSS_3 nfet_06v0 ad=31.489n pd=1.041m as=31.631n ps=1.032m w=164 l=120
X40 5v0_add_q_sc_1/5v0_half_adder_selector_sc_0/res_stage0 5v0_add_q_sc_1/5v0_half_adder_selector_sc_0/m1_n239_179# 5v0_add_q_sc_1/upstepper_test VDD_3V3_1 pfet_06v0 ad=46.849n pd=1.361m as=42.856n ps=1.326m w=244 l=100
X41 5v0_add_q_sc_1/5v0_half_adder_selector_sc_0/m1_n239_179# c_2_s VSS_3 VSS_3 nfet_06v0 ad=14.432n pd=0.504m as=0 ps=0 w=164 l=120
X42 5v0_add_q_sc_1/5v0_half_adder_selector_sc_0/m1_n239_179# c_2_s VDD_3V3_1 VDD_3V3_1 pfet_06v0 ad=21.472n pd=0.664m as=0 ps=0 w=244 l=100
X43 5v0_add_q_sc_1/5v0_half_adder_selector_sc_0/res_stage0 c_2_s 5v0_add_q_sc_1/upstepper_test VSS_3 nfet_06v0 ad=0 pd=0 as=43.711n ps=1.504m w=164 l=120
X44 5v0_add_q_sc_1/5v0_half_adder_selector_sc_0/res_stage0 c_2_s 5v0_add_q_sc_1/downstepper_test VDD_3V3_1 pfet_06v0 ad=0 pd=0 as=42.856n ps=1.326m w=244 l=100
X45 int_carry 5v0_add_q_sc_1/5v0_half_adder_selector_sc_0/m1_n244_n517# 5v0_add_q_sc_1/5v0_half_adder_selector_sc_0/res_stage0 VSS_3 nfet_06v0 ad=0 pd=0 as=0 ps=0 w=164 l=120
X46 int_carry 5v0_add_q_sc_1/5v0_half_adder_selector_sc_0/m1_n244_n517# int_c01 VDD_3V3_1 pfet_06v0 ad=0 pd=0 as=42.946n ps=1.33m w=244 l=100
X47 5v0_add_q_sc_1/5v0_half_adder_selector_sc_0/m1_n244_n517# c_2_o VSS_3 VSS_3 nfet_06v0 ad=14.432n pd=0.504m as=0 ps=0 w=164 l=120
X48 5v0_add_q_sc_1/5v0_half_adder_selector_sc_0/m1_n244_n517# c_2_o VDD_3V3_1 VDD_3V3_1 pfet_06v0 ad=21.472n pd=0.664m as=0 ps=0 w=244 l=100
X49 int_carry c_2_o int_c01 VSS_3 nfet_06v0 ad=0 pd=0 as=31.489n ps=1.041m w=164 l=120
X50 int_carry c_2_o 5v0_add_q_sc_1/5v0_half_adder_selector_sc_0/res_stage0 VDD_3V3_1 pfet_06v0 ad=0 pd=0 as=0 ps=0 w=244 l=100
X51 5v0_add_q_sc_1/inv_pti 5v0_add_q_sc_1/pti VSS_3 VSS_3 nfet_06v0 ad=14.432n pd=0.504m as=0 ps=0 w=164 l=120
X52 5v0_add_q_sc_1/inv_pti 5v0_add_q_sc_1/pti VDD_3V3_1 VDD_3V3_1 pfet_06v0 ad=21.472n pd=0.664m as=0 ps=0 w=244 l=100
X53 5v0_add_q_sc_1/a_n1373_n454# 5v0_add_q_sc_1/inv_nti 5v0_add_q_sc_1/downstepper_test VSS_3 nfet_06v0 ad=7.056n pd=0.39m as=0 ps=0 w=147 l=120
X54 5v0_add_q_sc_1/upstepper_test 5v0_add_q_sc_1/nti 5v0_add_q_sc_1/a_n1205_n937# VDD_3V3_1 pfet_06v0 ad=0 pd=0 as=11.664n ps=0.582m w=243 l=100
X55 5v0_add_q_sc_1/inv_nti 5v0_add_q_sc_1/nti VDD_3V3_1 VDD_3V3_1 pfet_06v0 ad=21.472n pd=0.664m as=0 ps=0 w=244 l=100
X56 5v0_add_q_sc_1/upstepper_test 5v0_add_q_sc_1/nti VDD_1V65_1 VSS_3 nfet_06v0 ad=0 pd=0 as=21.021n ps=0.58m w=147 l=120
X57 5v0_add_q_sc_1/a_n1205_n937# 5v0_add_q_sc_1/inv_pti VDD_3V3_1 VDD_3V3_1 pfet_06v0 ad=0 pd=0 as=0 ps=0 w=243 l=100
X58 5v0_add_q_sc_1/downstepper_test 5v0_add_q_sc_1/pti 5v0_add_q_sc_1/a_n1778_n454# VSS_3 nfet_06v0 ad=0 pd=0 as=7.056n ps=0.39m w=147 l=120
X59 5v0_add_q_sc_1/inv_nti 5v0_add_q_sc_1/nti VSS_3 VSS_3 nfet_06v0 ad=14.432n pd=0.504m as=0 ps=0 w=164 l=120
X60 5v0_add_q_sc_1/a_n1778_n454# 5v0_add_q_sc_1/inv_nti VSS_3 VSS_3 nfet_06v0 ad=0 pd=0 as=0 ps=0 w=147 l=120
X61 5v0_add_q_sc_1/upstepper_test 5v0_add_q_sc_1/inv_pti VSS_3 VSS_3 nfet_06v0 ad=0 pd=0 as=0 ps=0 w=164 l=120
X62 VDD_1V65_1 5v0_add_q_sc_1/inv_pti 5v0_add_q_sc_1/a_n1373_n454# VSS_3 nfet_06v0 ad=0 pd=0 as=0 ps=0 w=147 l=120
X63 5v0_add_q_sc_1/downstepper_test 5v0_add_q_sc_1/inv_nti VDD_3V3_1 VDD_3V3_1 pfet_06v0 ad=0 pd=0 as=0 ps=0 w=243 l=100
X64 5v0_addh_sc_tile_2/ctrl_over 5v0_addh_sc_tile_2/ctrl_sign 5v0_nter2oter_code_sc_0/gf180mcu_fd_sc_mcu7t5v0__nor2_1_0/a_224_472# VDD_3V3_0 pfet_06v0 ad=21.472n pd=0.664m as=16.348n ps=0.378m w=244 l=100
X65 VSS_3 5v0_addh_sc_tile_2/ctrl_sign 5v0_addh_sc_tile_2/ctrl_over VSS_3 nfet_06v0 ad=9.944n pd=0.402m as=5.876n ps=0.217m w=113 l=120
X66 5v0_nter2oter_code_sc_0/gf180mcu_fd_sc_mcu7t5v0__nor2_1_0/a_224_472# 5v0_nter2oter_code_sc_0/nti VDD_3V3_0 VDD_3V3_0 pfet_06v0 ad=16.348n pd=0.378m as=20.932n ps=0.664m w=244 l=100
X67 5v0_addh_sc_tile_2/ctrl_over 5v0_nter2oter_code_sc_0/nti VSS_3 VSS_3 nfet_06v0 ad=5.876n pd=0.217m as=9.944n ps=0.402m w=113 l=120
X68 5v0_addh_sc_tile_2/ctrl_sign 5v0_nter2oter_code_sc_0/pti VSS_3 VSS_3 nfet_06v0 ad=14.432n pd=0.504m as=0 ps=0 w=164 l=120
X69 5v0_addh_sc_tile_2/ctrl_sign 5v0_nter2oter_code_sc_0/pti VDD_3V3_0 VDD_3V3_0 pfet_06v0 ad=21.472n pd=0.664m as=0 ps=0 w=244 l=100
X70 5v0_nter2oter_code_sc_0/pti int_012 VSS_3 VSS_3 nfet_06v0 ad=6.336n pd=0.32m as=6.478n ps=0.255m w=72 l=578
X71 VDD_3V3_1 int_012 5v0_nter2oter_code_sc_0/pti VDD_3V3_1 pfet_06v0 ad=12.81n pd=0.349m as=12.688n ps=0.348m w=244 l=100
X72 VDD_3V3_1 int_012 5v0_nter2oter_code_sc_0/nti VDD_3V3_1 pfet_06v0 ad=13.616n pd=0.392m as=9.696n ps=0.394m w=96 l=150
X73 VSS_3 int_012 5v0_nter2oter_code_sc_0/nti VSS_3 nfet_06v0 ad=6.478n pd=0.255m as=12.7n ps=0.454m w=127 l=120
X74 5v0_nter2oter_code_sc_0/pti int_012 VDD_3V3_1 VDD_3V3_1 pfet_06v0 ad=12.688n pd=0.348m as=13.616n ps=0.392m w=244 l=100
X75 5v0_nter2oter_code_sc_0/pti int_012 VDD_3V3_1 VDD_3V3_1 pfet_06v0 ad=27.328n pd=0.712m as=12.81n ps=0.349m w=244 l=100
X76 5v0_addh_sc_tile_1/ctrl_over 5v0_addh_sc_tile_1/ctrl_sign 5v0_nter2oter_code_sc_1/gf180mcu_fd_sc_mcu7t5v0__nor2_1_0/a_224_472# VDD_3V3_0 pfet_06v0 ad=21.472n pd=0.664m as=32.696n ps=0.756m w=244 l=100
X77 VSS_3 5v0_addh_sc_tile_1/ctrl_sign 5v0_addh_sc_tile_1/ctrl_over VSS_3 nfet_06v0 ad=0 pd=0 as=11.752n ps=0.434m w=113 l=120
X78 5v0_nter2oter_code_sc_1/gf180mcu_fd_sc_mcu7t5v0__nor2_1_0/a_224_472# 5v0_nter2oter_code_sc_1/nti VDD_3V3_0 VDD_3V3_0 pfet_06v0 ad=0 pd=0 as=0 ps=0 w=244 l=100
X79 5v0_addh_sc_tile_1/ctrl_over 5v0_nter2oter_code_sc_1/nti VSS_3 VSS_3 nfet_06v0 ad=0 pd=0 as=0 ps=0 w=113 l=120
X80 5v0_addh_sc_tile_1/ctrl_sign 5v0_nter2oter_code_sc_1/pti VSS_3 VSS_3 nfet_06v0 ad=14.432n pd=0.504m as=0 ps=0 w=164 l=120
X81 5v0_addh_sc_tile_1/ctrl_sign 5v0_nter2oter_code_sc_1/pti VDD_3V3_0 VDD_3V3_0 pfet_06v0 ad=21.472n pd=0.664m as=0 ps=0 w=244 l=100
X82 5v0_nter2oter_code_sc_1/pti in_2 VSS_3 VSS_3 nfet_06v0 ad=6.336n pd=0.32m as=0 ps=0 w=72 l=578
X83 VDD_3V3_1 in_2 5v0_nter2oter_code_sc_1/pti VDD_3V3_1 pfet_06v0 ad=0 pd=0 as=52.704n ps=1.408m w=244 l=100
X84 VDD_3V3_1 in_2 5v0_nter2oter_code_sc_1/nti VDD_3V3_1 pfet_06v0 ad=0 pd=0 as=9.696n ps=0.394m w=96 l=150
X85 VSS_3 in_2 5v0_nter2oter_code_sc_1/nti VSS_3 nfet_06v0 ad=0 pd=0 as=12.7n ps=0.454m w=127 l=120
X86 5v0_nter2oter_code_sc_1/pti in_2 VDD_3V3_1 VDD_3V3_1 pfet_06v0 ad=0 pd=0 as=0 ps=0 w=244 l=100
X87 5v0_nter2oter_code_sc_1/pti in_2 VDD_3V3_1 VDD_3V3_1 pfet_06v0 ad=0 pd=0 as=0 ps=0 w=244 l=100
X88 m1_n2844_n810# c01over VSS_3 VSS_3 nfet_06v0 ad=14.432n pd=0.504m as=0 ps=0 w=164 l=120
X89 m1_n2844_n810# c01over VDD_3V3_1 VDD_3V3_1 pfet_06v0 ad=21.472n pd=0.664m as=0 ps=0 w=244 l=100
X90 5v0_addh_sc_tile_0/pti in_1 VSS_3 VSS_3 nfet_06v0 ad=20.768n pd=0.824m as=0 ps=0 w=72 l=578
X91 VDD_3V3_1 in_1 5v0_addh_sc_tile_0/pti VDD_3V3_1 pfet_06v0 ad=0 pd=0 as=74.176n ps=2.072m w=244 l=100
X92 VDD_3V3_1 in_1 5v0_addh_sc_tile_0/nti VDD_3V3_1 pfet_06v0 ad=0 pd=0 as=9.696n ps=0.394m w=96 l=150
X93 VSS_3 in_1 5v0_addh_sc_tile_0/nti VSS_3 nfet_06v0 ad=0 pd=0 as=12.7n ps=0.454m w=127 l=120
X94 5v0_addh_sc_tile_0/pti in_1 VDD_3V3_1 VDD_3V3_1 pfet_06v0 ad=0 pd=0 as=0 ps=0 w=244 l=100
X95 5v0_addh_sc_tile_0/pti in_1 VDD_3V3_1 VDD_3V3_1 pfet_06v0 ad=0 pd=0 as=0 ps=0 w=244 l=100
X96 5v0_addh_sc_tile_0/5v0_half_adder_selector_sc_0/res_stage0 5v0_addh_sc_tile_0/m1_103_293# 5v0_addh_sc_tile_0/downstepper_test VSS_3 nfet_06v0 ad=31.489n pd=1.041m as=31.631n ps=1.032m w=164 l=120
X97 5v0_addh_sc_tile_0/5v0_half_adder_selector_sc_0/res_stage0 5v0_addh_sc_tile_0/m1_103_293# 5v0_addh_sc_tile_0/upstepper_test VDD_3V3_1 pfet_06v0 ad=46.849n pd=1.361m as=42.856n ps=1.326m w=244 l=100
X98 5v0_addh_sc_tile_0/m1_103_293# in_0_sign VSS_3 VSS_3 nfet_06v0 ad=14.432n pd=0.504m as=0 ps=0 w=164 l=120
X99 5v0_addh_sc_tile_0/m1_103_293# in_0_sign VDD_3V3_1 VDD_3V3_1 pfet_06v0 ad=21.472n pd=0.664m as=0 ps=0 w=244 l=100
X100 5v0_addh_sc_tile_0/5v0_half_adder_selector_sc_0/res_stage0 in_0_sign 5v0_addh_sc_tile_0/upstepper_test VSS_3 nfet_06v0 ad=0 pd=0 as=43.711n ps=1.504m w=164 l=120
X101 5v0_addh_sc_tile_0/5v0_half_adder_selector_sc_0/res_stage0 in_0_sign 5v0_addh_sc_tile_0/downstepper_test VDD_3V3_1 pfet_06v0 ad=0 pd=0 as=42.856n ps=1.326m w=244 l=100
X102 res_01 5v0_addh_sc_tile_0/a_382_n1095# 5v0_addh_sc_tile_0/5v0_half_adder_selector_sc_0/res_stage0 VSS_3 nfet_06v0 ad=31.489n pd=1.041m as=0 ps=0 w=164 l=120
X103 res_01 5v0_addh_sc_tile_0/a_382_n1095# in_1 VDD_3V3_1 pfet_06v0 ad=46.849n pd=1.361m as=21.472n ps=0.664m w=244 l=100
X104 5v0_addh_sc_tile_0/a_382_n1095# in_0_over VSS_3 VSS_3 nfet_06v0 ad=14.432n pd=0.504m as=0 ps=0 w=164 l=120
X105 5v0_addh_sc_tile_0/a_382_n1095# in_0_over VDD_3V3_1 VDD_3V3_1 pfet_06v0 ad=21.472n pd=0.664m as=0 ps=0 w=244 l=100
X106 res_01 in_0_over in_1 VSS_3 nfet_06v0 ad=0 pd=0 as=14.432n ps=0.504m w=164 l=120
X107 res_01 in_0_over 5v0_addh_sc_tile_0/5v0_half_adder_selector_sc_0/res_stage0 VDD_3V3_1 pfet_06v0 ad=0 pd=0 as=0 ps=0 w=244 l=100
X108 5v0_addh_sc_tile_0/inv_pti 5v0_addh_sc_tile_0/pti VSS_3 VSS_3 nfet_06v0 ad=28.864n pd=1.008m as=0 ps=0 w=164 l=120
X109 5v0_addh_sc_tile_0/inv_pti 5v0_addh_sc_tile_0/pti VDD_3V3_1 VDD_3V3_1 pfet_06v0 ad=42.944n pd=1.328m as=0 ps=0 w=244 l=100
X110 c01over 5v0_addh_sc_tile_0/a_382_n1095# 5v0_addh_sc_tile_0/m1_843_n857# VSS_3 nfet_06v0 ad=14.432n pd=0.504m as=14.432n ps=0.504m w=164 l=120
X111 c01over in_0_over 5v0_addh_sc_tile_0/m1_843_n857# VDD_3V3_1 pfet_06v0 ad=21.472n pd=0.664m as=21.472n ps=0.664m w=244 l=100
X112 5v0_addh_sc_tile_0/inv_nti in_0_sign c01 VDD_3V3_1 pfet_06v0 ad=21.472n pd=0.664m as=12.688n ps=0.348m w=244 l=100
X113 c01 5v0_addh_sc_tile_0/m1_103_293# 5v0_addh_sc_tile_0/inv_nti VSS_3 nfet_06v0 ad=8.528n pd=0.268m as=14.432n ps=0.504m w=164 l=120
X114 c01 5v0_addh_sc_tile_0/m1_103_293# 5v0_addh_sc_tile_0/inv_pti VDD_3V3_1 pfet_06v0 ad=12.688n pd=0.348m as=21.472n ps=0.664m w=244 l=100
X115 5v0_addh_sc_tile_0/inv_pti in_0_sign c01 VSS_3 nfet_06v0 ad=14.432n pd=0.504m as=8.528n ps=0.268m w=164 l=120
X116 5v0_addh_sc_tile_0/inv_nti in_0_sign 5v0_addh_sc_tile_0/m1_843_n857# VDD_3V3_1 pfet_06v0 ad=64.416n pd=1.992m as=46.848n ps=1.36m w=244 l=100
X117 5v0_addh_sc_tile_0/m1_843_n857# 5v0_addh_sc_tile_0/m1_103_293# 5v0_addh_sc_tile_0/inv_nti VSS_3 nfet_06v0 ad=31.488n pd=1.04m as=43.296n ps=1.512m w=164 l=120
X118 5v0_addh_sc_tile_0/m1_843_n857# 5v0_addh_sc_tile_0/m1_103_293# 5v0_addh_sc_tile_0/pti VDD_3V3_1 pfet_06v0 ad=0 pd=0 as=0 ps=0 w=244 l=100
X119 5v0_addh_sc_tile_0/pti in_0_sign 5v0_addh_sc_tile_0/m1_843_n857# VSS_3 nfet_06v0 ad=0 pd=0 as=0 ps=0 w=164 l=120
X120 5v0_addh_sc_tile_0/a_n1373_n454# 5v0_addh_sc_tile_0/inv_nti 5v0_addh_sc_tile_0/downstepper_test VSS_3 nfet_06v0 ad=3.528n pd=0.195m as=8.599n ps=0.264m w=147 l=120
X121 5v0_addh_sc_tile_0/upstepper_test 5v0_addh_sc_tile_0/nti 5v0_addh_sc_tile_0/a_n1205_n937# VDD_3V3_1 pfet_06v0 ad=21.384n pd=0.662m as=5.832n ps=0.291m w=243 l=100
X122 5v0_addh_sc_tile_0/inv_nti 5v0_addh_sc_tile_0/nti VDD_3V3_1 VDD_3V3_1 pfet_06v0 ad=21.472n pd=0.664m as=21.472n ps=0.664m w=244 l=100
X123 5v0_addh_sc_tile_0/upstepper_test 5v0_addh_sc_tile_0/nti VDD_1V65_0 VSS_3 nfet_06v0 ad=14.847n pd=0.496m as=10.51n ps=0.29m w=147 l=120
X124 c01over 5v0_addh_sc_tile_0/a_382_n1095# VDD_3V3_1 VDD_3V3_1 pfet_06v0 ad=21.472n pd=0.664m as=21.472n ps=0.664m w=244 l=100
X125 5v0_addh_sc_tile_0/a_n1205_n937# 5v0_addh_sc_tile_0/inv_pti VDD_3V3_1 VDD_3V3_1 pfet_06v0 ad=5.832n pd=0.291m as=21.384n ps=0.662m w=243 l=100
X126 5v0_addh_sc_tile_0/downstepper_test 5v0_addh_sc_tile_0/pti 5v0_addh_sc_tile_0/a_n1778_n454# VSS_3 nfet_06v0 ad=8.599n pd=0.264m as=3.528n ps=0.195m w=147 l=120
X127 5v0_addh_sc_tile_0/inv_nti 5v0_addh_sc_tile_0/nti VSS_3 VSS_3 nfet_06v0 ad=14.432n pd=0.504m as=14.432n ps=0.504m w=164 l=120
X128 5v0_addh_sc_tile_0/a_n1778_n454# 5v0_addh_sc_tile_0/inv_nti VSS_3 VSS_3 nfet_06v0 ad=3.528n pd=0.195m as=14.847n ps=0.496m w=147 l=120
X129 5v0_addh_sc_tile_0/upstepper_test 5v0_addh_sc_tile_0/inv_pti VSS_3 VSS_3 nfet_06v0 ad=14.432n pd=0.504m as=14.432n ps=0.504m w=164 l=120
X130 VDD_1V65_0 5v0_addh_sc_tile_0/inv_pti 5v0_addh_sc_tile_0/a_n1373_n454# VSS_3 nfet_06v0 ad=10.51n pd=0.29m as=3.528n ps=0.195m w=147 l=120
X131 5v0_addh_sc_tile_0/downstepper_test 5v0_addh_sc_tile_0/inv_nti VDD_3V3_1 VDD_3V3_1 pfet_06v0 ad=21.384n pd=0.662m as=21.384n ps=0.662m w=243 l=100
X132 5v0_addh_sc_tile_1/pti res_01 VSS_3 VSS_3 nfet_06v0 ad=20.768n pd=0.824m as=0 ps=0 w=72 l=578
X133 VDD_3V3_1 res_01 5v0_addh_sc_tile_1/pti VDD_3V3_1 pfet_06v0 ad=0 pd=0 as=74.176n ps=2.072m w=244 l=100
X134 VDD_3V3_1 res_01 5v0_addh_sc_tile_1/nti VDD_3V3_1 pfet_06v0 ad=0 pd=0 as=9.696n ps=0.394m w=96 l=150
X135 VSS_3 res_01 5v0_addh_sc_tile_1/nti VSS_3 nfet_06v0 ad=0 pd=0 as=12.7n ps=0.454m w=127 l=120
X136 5v0_addh_sc_tile_1/pti res_01 VDD_3V3_1 VDD_3V3_1 pfet_06v0 ad=0 pd=0 as=0 ps=0 w=244 l=100
X137 5v0_addh_sc_tile_1/pti res_01 VDD_3V3_1 VDD_3V3_1 pfet_06v0 ad=0 pd=0 as=0 ps=0 w=244 l=100
X138 5v0_addh_sc_tile_1/5v0_half_adder_selector_sc_0/res_stage0 5v0_addh_sc_tile_1/m1_103_293# 5v0_addh_sc_tile_1/downstepper_test VSS_3 nfet_06v0 ad=31.489n pd=1.041m as=31.631n ps=1.032m w=164 l=120
X139 5v0_addh_sc_tile_1/5v0_half_adder_selector_sc_0/res_stage0 5v0_addh_sc_tile_1/m1_103_293# 5v0_addh_sc_tile_1/upstepper_test VDD_3V3_1 pfet_06v0 ad=46.849n pd=1.361m as=42.856n ps=1.326m w=244 l=100
X140 5v0_addh_sc_tile_1/m1_103_293# 5v0_addh_sc_tile_1/ctrl_sign VSS_3 VSS_3 nfet_06v0 ad=14.432n pd=0.504m as=0 ps=0 w=164 l=120
X141 5v0_addh_sc_tile_1/m1_103_293# 5v0_addh_sc_tile_1/ctrl_sign VDD_3V3_1 VDD_3V3_1 pfet_06v0 ad=21.472n pd=0.664m as=0 ps=0 w=244 l=100
X142 5v0_addh_sc_tile_1/5v0_half_adder_selector_sc_0/res_stage0 5v0_addh_sc_tile_1/ctrl_sign 5v0_addh_sc_tile_1/upstepper_test VSS_3 nfet_06v0 ad=0 pd=0 as=43.711n ps=1.504m w=164 l=120
X143 5v0_addh_sc_tile_1/5v0_half_adder_selector_sc_0/res_stage0 5v0_addh_sc_tile_1/ctrl_sign 5v0_addh_sc_tile_1/downstepper_test VDD_3V3_1 pfet_06v0 ad=0 pd=0 as=42.856n ps=1.326m w=244 l=100
X144 int_012 5v0_addh_sc_tile_1/a_382_n1095# 5v0_addh_sc_tile_1/5v0_half_adder_selector_sc_0/res_stage0 VSS_3 nfet_06v0 ad=17.057n pd=0.537m as=0 ps=0 w=164 l=120
X145 int_012 5v0_addh_sc_tile_1/a_382_n1095# res_01 VDD_3V3_0 pfet_06v0 ad=25.377n pd=0.697m as=0 ps=0 w=244 l=100
X146 5v0_addh_sc_tile_1/a_382_n1095# 5v0_addh_sc_tile_1/ctrl_over VSS_3 VSS_3 nfet_06v0 ad=14.432n pd=0.504m as=0 ps=0 w=164 l=120
X147 5v0_addh_sc_tile_1/a_382_n1095# 5v0_addh_sc_tile_1/ctrl_over VDD_3V3_0 VDD_3V3_0 pfet_06v0 ad=21.472n pd=0.664m as=0 ps=0 w=244 l=100
X148 int_012 5v0_addh_sc_tile_1/ctrl_over res_01 VSS_3 nfet_06v0 ad=0 pd=0 as=0 ps=0 w=164 l=120
X149 int_012 5v0_addh_sc_tile_1/ctrl_over 5v0_addh_sc_tile_1/5v0_half_adder_selector_sc_0/res_stage0 VDD_3V3_0 pfet_06v0 ad=0 pd=0 as=0 ps=0 w=244 l=100
X150 5v0_addh_sc_tile_1/inv_pti 5v0_addh_sc_tile_1/pti VSS_3 VSS_3 nfet_06v0 ad=28.864n pd=1.008m as=0 ps=0 w=164 l=120
X151 5v0_addh_sc_tile_1/inv_pti 5v0_addh_sc_tile_1/pti VDD_3V3_1 VDD_3V3_1 pfet_06v0 ad=42.944n pd=1.328m as=0 ps=0 w=244 l=100
X152 c_2_o 5v0_addh_sc_tile_1/a_382_n1095# 5v0_addh_sc_tile_1/m1_843_n857# VSS_3 nfet_06v0 ad=14.432n pd=0.504m as=31.488n ps=1.04m w=164 l=120
X153 c_2_o 5v0_addh_sc_tile_1/ctrl_over 5v0_addh_sc_tile_1/m1_843_n857# VDD_3V3_0 pfet_06v0 ad=42.944n pd=1.328m as=46.848n ps=1.36m w=244 l=100
X154 5v0_addh_sc_tile_1/inv_nti 5v0_addh_sc_tile_1/ctrl_sign c_2_s VDD_3V3_1 pfet_06v0 ad=64.416n pd=1.992m as=25.376n ps=0.696m w=244 l=100
X155 c_2_s 5v0_addh_sc_tile_1/m1_103_293# 5v0_addh_sc_tile_1/inv_nti VSS_3 nfet_06v0 ad=17.056n pd=0.536m as=43.296n ps=1.512m w=164 l=120
X156 c_2_s 5v0_addh_sc_tile_1/m1_103_293# 5v0_addh_sc_tile_1/inv_pti VDD_3V3_1 pfet_06v0 ad=0 pd=0 as=0 ps=0 w=244 l=100
X157 5v0_addh_sc_tile_1/inv_pti 5v0_addh_sc_tile_1/ctrl_sign c_2_s VSS_3 nfet_06v0 ad=0 pd=0 as=0 ps=0 w=164 l=120
X158 5v0_addh_sc_tile_1/inv_nti 5v0_addh_sc_tile_1/ctrl_sign 5v0_addh_sc_tile_1/m1_843_n857# VDD_3V3_0 pfet_06v0 ad=0 pd=0 as=0 ps=0 w=244 l=100
X159 5v0_addh_sc_tile_1/m1_843_n857# 5v0_addh_sc_tile_1/m1_103_293# 5v0_addh_sc_tile_1/inv_nti VSS_3 nfet_06v0 ad=0 pd=0 as=0 ps=0 w=164 l=120
X160 5v0_addh_sc_tile_1/m1_843_n857# 5v0_addh_sc_tile_1/m1_103_293# 5v0_addh_sc_tile_1/pti VDD_3V3_0 pfet_06v0 ad=0 pd=0 as=0 ps=0 w=244 l=100
X161 5v0_addh_sc_tile_1/pti 5v0_addh_sc_tile_1/ctrl_sign 5v0_addh_sc_tile_1/m1_843_n857# VSS_3 nfet_06v0 ad=0 pd=0 as=0 ps=0 w=164 l=120
X162 5v0_addh_sc_tile_1/a_n1373_n454# 5v0_addh_sc_tile_1/inv_nti 5v0_addh_sc_tile_1/downstepper_test VSS_3 nfet_06v0 ad=7.056n pd=0.39m as=0 ps=0 w=147 l=120
X163 5v0_addh_sc_tile_1/upstepper_test 5v0_addh_sc_tile_1/nti 5v0_addh_sc_tile_1/a_n1205_n937# VDD_3V3_0 pfet_06v0 ad=0 pd=0 as=11.664n ps=0.582m w=243 l=100
X164 5v0_addh_sc_tile_1/inv_nti 5v0_addh_sc_tile_1/nti VDD_3V3_0 VDD_3V3_0 pfet_06v0 ad=0 pd=0 as=0 ps=0 w=244 l=100
X165 5v0_addh_sc_tile_1/upstepper_test 5v0_addh_sc_tile_1/nti VDD_1V65_3 VSS_3 nfet_06v0 ad=0 pd=0 as=21.021n ps=0.58m w=147 l=120
X166 c_2_o 5v0_addh_sc_tile_1/a_382_n1095# VDD_3V3_0 VDD_3V3_0 pfet_06v0 ad=0 pd=0 as=0 ps=0 w=244 l=100
X167 5v0_addh_sc_tile_1/a_n1205_n937# 5v0_addh_sc_tile_1/inv_pti VDD_3V3_0 VDD_3V3_0 pfet_06v0 ad=0 pd=0 as=0 ps=0 w=243 l=100
X168 5v0_addh_sc_tile_1/downstepper_test 5v0_addh_sc_tile_1/pti 5v0_addh_sc_tile_1/a_n1778_n454# VSS_3 nfet_06v0 ad=0 pd=0 as=7.056n ps=0.39m w=147 l=120
X169 5v0_addh_sc_tile_1/inv_nti 5v0_addh_sc_tile_1/nti VSS_3 VSS_3 nfet_06v0 ad=0 pd=0 as=0 ps=0 w=164 l=120
X170 5v0_addh_sc_tile_1/a_n1778_n454# 5v0_addh_sc_tile_1/inv_nti VSS_3 VSS_3 nfet_06v0 ad=0 pd=0 as=0 ps=0 w=147 l=120
X171 5v0_addh_sc_tile_1/upstepper_test 5v0_addh_sc_tile_1/inv_pti VSS_3 VSS_3 nfet_06v0 ad=0 pd=0 as=0 ps=0 w=164 l=120
X172 VDD_1V65_3 5v0_addh_sc_tile_1/inv_pti 5v0_addh_sc_tile_1/a_n1373_n454# VSS_3 nfet_06v0 ad=0 pd=0 as=0 ps=0 w=147 l=120
X173 5v0_addh_sc_tile_1/downstepper_test 5v0_addh_sc_tile_1/inv_nti VDD_3V3_0 VDD_3V3_0 pfet_06v0 ad=0 pd=0 as=0 ps=0 w=243 l=100
X174 5v0_addh_sc_tile_2/pti in_3 VSS_3 VSS_3 nfet_06v0 ad=20.768n pd=0.824m as=0 ps=0 w=72 l=578
X175 VDD_3V3_0 in_3 5v0_addh_sc_tile_2/pti VDD_3V3_0 pfet_06v0 ad=0 pd=0 as=74.176n ps=2.072m w=244 l=100
X176 VDD_3V3_0 in_3 5v0_addh_sc_tile_2/nti VDD_3V3_0 pfet_06v0 ad=0 pd=0 as=9.696n ps=0.394m w=96 l=150
X177 VSS_3 in_3 5v0_addh_sc_tile_2/nti VSS_3 nfet_06v0 ad=0 pd=0 as=12.7n ps=0.454m w=127 l=120
X178 5v0_addh_sc_tile_2/pti in_3 VDD_3V3_0 VDD_3V3_0 pfet_06v0 ad=0 pd=0 as=0 ps=0 w=244 l=100
X179 5v0_addh_sc_tile_2/pti in_3 VDD_3V3_0 VDD_3V3_0 pfet_06v0 ad=0 pd=0 as=0 ps=0 w=244 l=100
X180 5v0_addh_sc_tile_2/5v0_half_adder_selector_sc_0/res_stage0 5v0_addh_sc_tile_2/m1_103_293# 5v0_addh_sc_tile_2/downstepper_test VSS_3 nfet_06v0 ad=31.489n pd=1.041m as=31.631n ps=1.032m w=164 l=120
X181 5v0_addh_sc_tile_2/5v0_half_adder_selector_sc_0/res_stage0 5v0_addh_sc_tile_2/m1_103_293# 5v0_addh_sc_tile_2/upstepper_test VDD_3V3_0 pfet_06v0 ad=46.849n pd=1.361m as=42.856n ps=1.326m w=244 l=100
X182 5v0_addh_sc_tile_2/m1_103_293# 5v0_addh_sc_tile_2/ctrl_sign VSS_3 VSS_3 nfet_06v0 ad=14.432n pd=0.504m as=0 ps=0 w=164 l=120
X183 5v0_addh_sc_tile_2/m1_103_293# 5v0_addh_sc_tile_2/ctrl_sign VDD_3V3_0 VDD_3V3_0 pfet_06v0 ad=21.472n pd=0.664m as=0 ps=0 w=244 l=100
X184 5v0_addh_sc_tile_2/5v0_half_adder_selector_sc_0/res_stage0 5v0_addh_sc_tile_2/ctrl_sign 5v0_addh_sc_tile_2/upstepper_test VSS_3 nfet_06v0 ad=0 pd=0 as=43.711n ps=1.504m w=164 l=120
X185 5v0_addh_sc_tile_2/5v0_half_adder_selector_sc_0/res_stage0 5v0_addh_sc_tile_2/ctrl_sign 5v0_addh_sc_tile_2/downstepper_test VDD_3V3_0 pfet_06v0 ad=0 pd=0 as=42.856n ps=1.326m w=244 l=100
X186 res_0 5v0_addh_sc_tile_2/a_382_n1095# 5v0_addh_sc_tile_2/5v0_half_adder_selector_sc_0/res_stage0 VSS_3 nfet_06v0 ad=17.057n pd=0.537m as=0 ps=0 w=164 l=120
X187 res_0 5v0_addh_sc_tile_2/a_382_n1095# in_3 VDD_3V3_0 pfet_06v0 ad=25.377n pd=0.697m as=21.472n ps=0.664m w=244 l=100
X188 5v0_addh_sc_tile_2/a_382_n1095# 5v0_addh_sc_tile_2/ctrl_over VSS_3 VSS_3 nfet_06v0 ad=14.432n pd=0.504m as=0 ps=0 w=164 l=120
X189 5v0_addh_sc_tile_2/a_382_n1095# 5v0_addh_sc_tile_2/ctrl_over VDD_3V3_0 VDD_3V3_0 pfet_06v0 ad=21.472n pd=0.664m as=0 ps=0 w=244 l=100
X190 res_0 5v0_addh_sc_tile_2/ctrl_over in_3 VSS_3 nfet_06v0 ad=0 pd=0 as=14.432n ps=0.504m w=164 l=120
X191 res_0 5v0_addh_sc_tile_2/ctrl_over 5v0_addh_sc_tile_2/5v0_half_adder_selector_sc_0/res_stage0 VDD_3V3_0 pfet_06v0 ad=0 pd=0 as=0 ps=0 w=244 l=100
X192 5v0_addh_sc_tile_2/inv_pti 5v0_addh_sc_tile_2/pti VSS_3 VSS_3 nfet_06v0 ad=28.864n pd=1.008m as=0 ps=0 w=164 l=120
X193 5v0_addh_sc_tile_2/inv_pti 5v0_addh_sc_tile_2/pti VDD_3V3_0 VDD_3V3_0 pfet_06v0 ad=42.944n pd=1.328m as=0 ps=0 w=244 l=100
X194 5v0_add_q_sc_0/ctrl_over 5v0_addh_sc_tile_2/a_382_n1095# 5v0_addh_sc_tile_2/m1_843_n857# VSS_3 nfet_06v0 ad=14.432n pd=0.504m as=31.488n ps=1.04m w=164 l=120
X195 5v0_add_q_sc_0/ctrl_over 5v0_addh_sc_tile_2/ctrl_over 5v0_addh_sc_tile_2/m1_843_n857# VDD_3V3_0 pfet_06v0 ad=42.944n pd=1.328m as=46.848n ps=1.36m w=244 l=100
X196 5v0_addh_sc_tile_2/inv_nti 5v0_addh_sc_tile_2/ctrl_sign 5v0_add_q_sc_0/ctrl_sign VDD_3V3_0 pfet_06v0 ad=64.416n pd=1.992m as=25.376n ps=0.696m w=244 l=100
X197 5v0_add_q_sc_0/ctrl_sign 5v0_addh_sc_tile_2/m1_103_293# 5v0_addh_sc_tile_2/inv_nti VSS_3 nfet_06v0 ad=17.056n pd=0.536m as=43.296n ps=1.512m w=164 l=120
X198 5v0_add_q_sc_0/ctrl_sign 5v0_addh_sc_tile_2/m1_103_293# 5v0_addh_sc_tile_2/inv_pti VDD_3V3_0 pfet_06v0 ad=0 pd=0 as=0 ps=0 w=244 l=100
X199 5v0_addh_sc_tile_2/inv_pti 5v0_addh_sc_tile_2/ctrl_sign 5v0_add_q_sc_0/ctrl_sign VSS_3 nfet_06v0 ad=0 pd=0 as=0 ps=0 w=164 l=120
X200 5v0_addh_sc_tile_2/inv_nti 5v0_addh_sc_tile_2/ctrl_sign 5v0_addh_sc_tile_2/m1_843_n857# VDD_3V3_0 pfet_06v0 ad=0 pd=0 as=0 ps=0 w=244 l=100
X201 5v0_addh_sc_tile_2/m1_843_n857# 5v0_addh_sc_tile_2/m1_103_293# 5v0_addh_sc_tile_2/inv_nti VSS_3 nfet_06v0 ad=0 pd=0 as=0 ps=0 w=164 l=120
X202 5v0_addh_sc_tile_2/m1_843_n857# 5v0_addh_sc_tile_2/m1_103_293# 5v0_addh_sc_tile_2/pti VDD_3V3_0 pfet_06v0 ad=0 pd=0 as=0 ps=0 w=244 l=100
X203 5v0_addh_sc_tile_2/pti 5v0_addh_sc_tile_2/ctrl_sign 5v0_addh_sc_tile_2/m1_843_n857# VSS_3 nfet_06v0 ad=0 pd=0 as=0 ps=0 w=164 l=120
X204 5v0_addh_sc_tile_2/a_n1373_n454# 5v0_addh_sc_tile_2/inv_nti 5v0_addh_sc_tile_2/downstepper_test VSS_3 nfet_06v0 ad=7.056n pd=0.39m as=0 ps=0 w=147 l=120
X205 5v0_addh_sc_tile_2/upstepper_test 5v0_addh_sc_tile_2/nti 5v0_addh_sc_tile_2/a_n1205_n937# VDD_3V3_0 pfet_06v0 ad=0 pd=0 as=11.664n ps=0.582m w=243 l=100
X206 5v0_addh_sc_tile_2/inv_nti 5v0_addh_sc_tile_2/nti VDD_3V3_0 VDD_3V3_0 pfet_06v0 ad=0 pd=0 as=0 ps=0 w=244 l=100
X207 5v0_addh_sc_tile_2/upstepper_test 5v0_addh_sc_tile_2/nti VDD_1V65_4 VSS_3 nfet_06v0 ad=0 pd=0 as=21.021n ps=0.58m w=147 l=120
X208 5v0_add_q_sc_0/ctrl_over 5v0_addh_sc_tile_2/a_382_n1095# VDD_3V3_0 VDD_3V3_0 pfet_06v0 ad=0 pd=0 as=0 ps=0 w=244 l=100
X209 5v0_addh_sc_tile_2/a_n1205_n937# 5v0_addh_sc_tile_2/inv_pti VDD_3V3_0 VDD_3V3_0 pfet_06v0 ad=0 pd=0 as=0 ps=0 w=243 l=100
X210 5v0_addh_sc_tile_2/downstepper_test 5v0_addh_sc_tile_2/pti 5v0_addh_sc_tile_2/a_n1778_n454# VSS_3 nfet_06v0 ad=0 pd=0 as=7.056n ps=0.39m w=147 l=120
X211 5v0_addh_sc_tile_2/inv_nti 5v0_addh_sc_tile_2/nti VSS_3 VSS_3 nfet_06v0 ad=0 pd=0 as=0 ps=0 w=164 l=120
X212 5v0_addh_sc_tile_2/a_n1778_n454# 5v0_addh_sc_tile_2/inv_nti VSS_3 VSS_3 nfet_06v0 ad=0 pd=0 as=0 ps=0 w=147 l=120
X213 5v0_addh_sc_tile_2/upstepper_test 5v0_addh_sc_tile_2/inv_pti VSS_3 VSS_3 nfet_06v0 ad=0 pd=0 as=0 ps=0 w=164 l=120
X214 VDD_1V65_4 5v0_addh_sc_tile_2/inv_pti 5v0_addh_sc_tile_2/a_n1373_n454# VSS_3 nfet_06v0 ad=0 pd=0 as=0 ps=0 w=147 l=120
X215 5v0_addh_sc_tile_2/downstepper_test 5v0_addh_sc_tile_2/inv_nti VDD_3V3_0 VDD_3V3_0 pfet_06v0 ad=0 pd=0 as=0 ps=0 w=243 l=100
C0 5v0_add_q_sc_1/5v0_half_adder_selector_sc_0/m1_n239_179# 5v0_add_q_sc_1/5v0_half_adder_selector_sc_0/m1_n244_n517# 0.00585f
C1 5v0_addh_sc_tile_1/pti 5v0_add_q_sc_1/a_n1778_n454# 0
C2 int_carry 5v0_add_q_sc_0/a_n1778_n454# 0.00116f
C3 5v0_add_q_sc_0/5v0_half_adder_selector_sc_0/5v0_tgate_sel_2_sc_1/input_A 5v0_add_q_sc_0/ctrl_sign 0
C4 res_01 5v0_addh_sc_tile_0/5v0_half_adder_selector_sc_0/res_stage0 0.0902f
C5 5v0_nter2oter_code_sc_0/gf180mcu_fd_sc_mcu7t5v0__nor2_1_0/a_224_472# 5v0_addh_sc_tile_2/nti 0
C6 c_2_s 5v0_addh_sc_tile_1/5v0_half_adder_selector_sc_0/res_stage0 0
C7 c01 5v0_addh_sc_tile_0/pti 0.01168f
C8 5v0_addh_sc_tile_1/inv_pti in_0_sign 0.00171f
C9 5v0_addh_sc_tile_0/upstepper_test 5v0_addh_sc_tile_0/nti 0.11981f
C10 5v0_addh_sc_tile_0/nti 5v0_addh_sc_tile_0/downstepper_test 0.06935f
C11 5v0_add_q_sc_0/5v0_half_adder_selector_sc_0/m1_n239_179# 5v0_add_q_sc_0/ctrl_over 0.00258f
C12 5v0_addh_sc_tile_2/ctrl_sign 5v0_nter2oter_code_sc_1/pti 0.0299f
C13 5v0_addh_sc_tile_2/m1_103_293# 5v0_addh_sc_tile_2/pti 0.10002f
C14 5v0_addh_sc_tile_1/a_n1778_n454# 5v0_addh_sc_tile_1/inv_nti 0.00226f
C15 5v0_add_q_sc_1/nti 5v0_addh_sc_tile_1/pti 0
C16 5v0_add_q_sc_0/inv_pti c_2_o 0.00278f
C17 int_c01 5v0_add_q_sc_1/5v0_half_adder_selector_sc_0/m1_n244_n517# 0.07888f
C18 5v0_addh_sc_tile_1/downstepper_test VDD_3V3_1 0.09186f
C19 5v0_addh_sc_tile_1/a_382_n1095# 5v0_add_q_sc_0/downstepper_test 0.00203f
C20 5v0_addh_sc_tile_2/inv_nti 5v0_addh_sc_tile_2/pti 0.42143f
C21 VDD_1V65_1 5v0_add_q_sc_1/downstepper_test 0.13024f
C22 5v0_add_q_sc_0/5v0_half_adder_selector_sc_0/m1_n244_n517# 5v0_add_q_sc_0/ctrl_over 0.34138f
C23 int_carry 5v0_addh_sc_tile_2/inv_nti 0
C24 5v0_nter2oter_code_sc_0/pti 5v0_addh_sc_tile_2/pti 0
C25 5v0_add_q_sc_0/5v0_half_adder_selector_sc_0/m1_n244_n517# 5v0_addh_sc_tile_2/a_382_n1095# 0
C26 5v0_add_q_sc_0/inv_pti 5v0_addh_sc_tile_1/ctrl_sign 0
C27 VDD_1V65_1 c_2_s 0
C28 5v0_addh_sc_tile_1/a_n1778_n454# 5v0_addh_sc_tile_1/pti 0.00135f
C29 5v0_add_q_sc_1/pti 5v0_add_q_sc_1/a_n1373_n454# 0
C30 5v0_addh_sc_tile_1/ctrl_over 5v0_addh_sc_tile_0/a_382_n1095# 0
C31 5v0_add_q_sc_0/nti 5v0_add_q_sc_0/ctrl_over 0.00167f
C32 5v0_add_q_sc_0/ctrl_sign 5v0_addh_sc_tile_2/inv_pti 0.10221f
C33 5v0_add_q_sc_1/upstepper_test 5v0_add_q_sc_1/a_n1205_n937# 0.00334f
C34 5v0_add_q_sc_0/nti 5v0_addh_sc_tile_2/a_382_n1095# 0
C35 c_2_s 5v0_addh_sc_tile_0/inv_pti 0
C36 5v0_addh_sc_tile_1/nti 5v0_addh_sc_tile_2/downstepper_test 0
C37 5v0_addh_sc_tile_1/nti 5v0_addh_sc_tile_0/a_382_n1095# 0.01157f
C38 5v0_addh_sc_tile_0/a_n1205_n937# 5v0_addh_sc_tile_0/5v0_half_adder_selector_sc_0/res_stage0 0
C39 res_01 5v0_addh_sc_tile_0/downstepper_test 0.00308f
C40 5v0_add_q_sc_0/5v0_half_adder_selector_sc_0/res_stage0 5v0_addh_sc_tile_2/inv_nti 0
C41 5v0_add_q_sc_0/upstepper_test 5v0_addh_sc_tile_1/m1_103_293# 0.00268f
C42 5v0_addh_sc_tile_1/inv_pti int_012 0.00119f
C43 5v0_add_q_sc_0/5v0_half_adder_selector_sc_0/m1_n239_179# 5v0_addh_sc_tile_1/ctrl_sign 0
C44 5v0_addh_sc_tile_1/m1_843_n857# 5v0_addh_sc_tile_1/inv_nti 0.36668f
C45 VDD_3V3_1 5v0_add_q_sc_1/a_n1373_n454# 0.00122f
C46 5v0_nter2oter_code_sc_0/pti 5v0_addh_sc_tile_0/nti 0
C47 VDD_3V3_0 VDD_1V65_3 0.04264f
C48 c_2_s 5v0_addh_sc_tile_0/m1_843_n857# 0
C49 int_c01 5v0_add_q_sc_1/a_n1205_n937# 0
C50 5v0_addh_sc_tile_1/downstepper_test 5v0_addh_sc_tile_1/5v0_half_adder_selector_sc_0/res_stage0 0.25483f
C51 5v0_addh_sc_tile_1/a_382_n1095# 5v0_add_q_sc_0/ctrl_sign 0.0169f
C52 int_carry 5v0_addh_sc_tile_1/m1_103_293# 0
C53 5v0_add_q_sc_0/nti c_2_o 0.01581f
C54 5v0_addh_sc_tile_1/nti 5v0_addh_sc_tile_0/pti 0
C55 5v0_nter2oter_code_sc_1/nti VDD_3V3_0 0.31259f
C56 res_01 5v0_addh_sc_tile_2/m1_103_293# 0
C57 5v0_addh_sc_tile_1/a_n1205_n937# VDD_1V65_3 0.00354f
C58 5v0_addh_sc_tile_1/m1_843_n857# 5v0_addh_sc_tile_1/pti 0.11666f
C59 5v0_addh_sc_tile_1/a_382_n1095# 5v0_add_q_sc_0/pti 0
C60 5v0_nter2oter_code_sc_1/nti VDD_1V65_0 0
C61 5v0_add_q_sc_0/nti 5v0_addh_sc_tile_1/ctrl_sign 0
C62 5v0_addh_sc_tile_0/a_n1205_n937# 5v0_addh_sc_tile_0/downstepper_test 0.00453f
C63 5v0_addh_sc_tile_0/upstepper_test 5v0_addh_sc_tile_0/a_n1205_n937# 0.00334f
C64 5v0_nter2oter_code_sc_0/pti res_01 0
C65 5v0_add_q_sc_1/downstepper_test in_0_over 0
C66 5v0_addh_sc_tile_1/inv_pti 5v0_addh_sc_tile_1/inv_nti 0.26136f
C67 5v0_add_q_sc_1/inv_nti m1_n2844_n810# 0.00427f
C68 c_2_s in_0_over 0.00327f
C69 in_0_sign 5v0_addh_sc_tile_1/pti 0
C70 in_2 5v0_addh_sc_tile_1/ctrl_over 0.01618f
C71 VDD_3V3_1 VDD_1V65_2 0.01209f
C72 in_2 5v0_addh_sc_tile_1/nti 0.00613f
C73 5v0_addh_sc_tile_2/downstepper_test 5v0_addh_sc_tile_2/pti 0.20149f
C74 5v0_addh_sc_tile_1/downstepper_test 5v0_addh_sc_tile_0/m1_843_n857# 0
C75 5v0_nter2oter_code_sc_1/nti 5v0_addh_sc_tile_2/upstepper_test 0
C76 5v0_add_q_sc_0/a_n1205_n937# VDD_3V3_0 0.00891f
C77 5v0_addh_sc_tile_1/a_n1373_n454# VDD_1V65_3 0.00232f
C78 5v0_addh_sc_tile_1/inv_pti 5v0_addh_sc_tile_1/pti 0.37325f
C79 VDD_1V65_1 5v0_add_q_sc_1/a_n1373_n454# 0.00232f
C80 int_012 5v0_addh_sc_tile_1/inv_nti 0.01488f
C81 5v0_addh_sc_tile_0/m1_103_293# 5v0_addh_sc_tile_0/a_382_n1095# 0.07764f
C82 m1_n2844_n810# 5v0_addh_sc_tile_1/ctrl_sign 0.00105f
C83 res_01 5v0_addh_sc_tile_1/m1_103_293# 0
C84 5v0_addh_sc_tile_0/upstepper_test 5v0_addh_sc_tile_0/a_n1373_n454# 0
C85 5v0_addh_sc_tile_0/a_n1373_n454# 5v0_addh_sc_tile_0/downstepper_test 0.00442f
C86 5v0_nter2oter_code_sc_1/nti 5v0_addh_sc_tile_2/ctrl_over 0
C87 5v0_addh_sc_tile_0/nti 5v0_addh_sc_tile_0/a_382_n1095# 0
C88 5v0_add_q_sc_1/5v0_half_adder_selector_sc_0/res_stage0 5v0_add_q_sc_1/nti 0.00372f
C89 int_012 5v0_addh_sc_tile_1/pti 0
C90 c01over c_2_s 0.01582f
C91 c_2_o 5v0_add_q_sc_1/5v0_half_adder_selector_sc_0/m1_n244_n517# 0.34508f
C92 5v0_addh_sc_tile_0/m1_103_293# 5v0_addh_sc_tile_0/pti 0.10002f
C93 VDD_1V65_4 5v0_addh_sc_tile_2/pti 0.00234f
C94 5v0_addh_sc_tile_1/downstepper_test in_0_over 0
C95 int_c01 5v0_addh_sc_tile_1/m1_103_293# 0
C96 5v0_addh_sc_tile_1/downstepper_test VDD_3V3_0 0.41827f
C97 5v0_nter2oter_code_sc_0/gf180mcu_fd_sc_mcu7t5v0__nor2_1_0/a_224_472# VDD_3V3_0 0.01413f
C98 5v0_addh_sc_tile_1/a_n1778_n454# VDD_1V65_3 0
C99 5v0_addh_sc_tile_0/nti 5v0_addh_sc_tile_0/pti 0.24563f
C100 m1_n2844_n810# VDD_3V3_1 0.14824f
C101 5v0_addh_sc_tile_1/ctrl_over 5v0_add_q_sc_0/downstepper_test 0
C102 5v0_addh_sc_tile_1/upstepper_test 5v0_addh_sc_tile_1/5v0_half_adder_selector_sc_0/5v0_tgate_sel_2_sc_1/input_A 0
C103 5v0_add_q_sc_1/downstepper_test 5v0_add_q_sc_1/a_n1778_n454# 0.0031f
C104 5v0_addh_sc_tile_1/ctrl_sign 5v0_addh_sc_tile_0/5v0_half_adder_selector_sc_0/res_stage0 0.00758f
C105 in_2 5v0_addh_sc_tile_2/pti 0
C106 c_2_s 5v0_add_q_sc_1/a_n1778_n454# 0
C107 5v0_addh_sc_tile_1/a_n1205_n937# 5v0_addh_sc_tile_1/downstepper_test 0.00453f
C108 5v0_addh_sc_tile_0/upstepper_test 5v0_addh_sc_tile_0/a_n1778_n454# 0
C109 5v0_addh_sc_tile_0/a_n1778_n454# 5v0_addh_sc_tile_0/downstepper_test 0.0031f
C110 res_01 5v0_addh_sc_tile_0/a_382_n1095# 0.17536f
C111 5v0_add_q_sc_1/inv_nti 5v0_add_q_sc_1/a_n1205_n937# 0
C112 5v0_addh_sc_tile_1/ctrl_over 5v0_add_q_sc_0/inv_nti 0
C113 m1_n2844_n810# 5v0_addh_sc_tile_0/inv_nti 0.02458f
C114 5v0_add_q_sc_1/downstepper_test 5v0_add_q_sc_1/nti 0.06596f
C115 5v0_addh_sc_tile_1/upstepper_test c01 0
C116 c_2_o 5v0_add_q_sc_1/a_n1205_n937# 0
C117 5v0_addh_sc_tile_1/inv_nti 5v0_addh_sc_tile_1/pti 0.42143f
C118 5v0_add_q_sc_1/nti c_2_s 0.2845f
C119 5v0_add_q_sc_0/ctrl_over 5v0_addh_sc_tile_2/m1_103_293# 0.01398f
C120 VDD_3V3_1 5v0_add_q_sc_1/5v0_half_adder_selector_sc_0/m1_n244_n517# 0.28925f
C121 5v0_addh_sc_tile_1/downstepper_test c01over 0.01317f
C122 in_2 5v0_addh_sc_tile_0/nti 0.0018f
C123 5v0_addh_sc_tile_2/m1_103_293# 5v0_addh_sc_tile_2/a_382_n1095# 0.07764f
C124 res_01 5v0_addh_sc_tile_0/pti 0
C125 5v0_add_q_sc_0/inv_pti VDD_3V3_0 0.40694f
C126 VDD_3V3_1 5v0_addh_sc_tile_0/5v0_half_adder_selector_sc_0/res_stage0 0.16177f
C127 5v0_addh_sc_tile_2/ctrl_sign 5v0_addh_sc_tile_2/inv_pti 0.28426f
C128 5v0_addh_sc_tile_1/ctrl_over 5v0_add_q_sc_0/ctrl_sign 0.00366f
C129 5v0_add_q_sc_0/ctrl_over 5v0_addh_sc_tile_2/inv_nti 0.01761f
C130 in_1 5v0_addh_sc_tile_0/5v0_half_adder_selector_sc_0/res_stage0 0.2646f
C131 5v0_addh_sc_tile_0/upstepper_test 5v0_addh_sc_tile_1/ctrl_sign 0
C132 5v0_addh_sc_tile_1/ctrl_sign 5v0_addh_sc_tile_0/downstepper_test 0.02017f
C133 5v0_addh_sc_tile_2/inv_nti 5v0_addh_sc_tile_2/a_382_n1095# 0.28654f
C134 5v0_addh_sc_tile_1/a_n1373_n454# 5v0_addh_sc_tile_1/downstepper_test 0.00442f
C135 5v0_addh_sc_tile_1/nti 5v0_add_q_sc_0/ctrl_sign 0
C136 5v0_addh_sc_tile_1/downstepper_test 5v0_addh_sc_tile_2/ctrl_over 0.01399f
C137 5v0_nter2oter_code_sc_1/gf180mcu_fd_sc_mcu7t5v0__nor2_1_0/a_224_472# 5v0_addh_sc_tile_1/ctrl_sign 0
C138 5v0_addh_sc_tile_1/ctrl_over 5v0_add_q_sc_0/pti 0.00209f
C139 5v0_nter2oter_code_sc_0/gf180mcu_fd_sc_mcu7t5v0__nor2_1_0/a_224_472# 5v0_addh_sc_tile_2/ctrl_over 0.0326f
C140 5v0_addh_sc_tile_0/inv_nti 5v0_addh_sc_tile_0/5v0_half_adder_selector_sc_0/res_stage0 0.02878f
C141 5v0_add_q_sc_0/upstepper_test 5v0_add_q_sc_0/downstepper_test 0.38867f
C142 5v0_addh_sc_tile_0/pti int_c01 0.00102f
C143 5v0_add_q_sc_0/5v0_half_adder_selector_sc_0/m1_n239_179# VDD_3V3_0 0.30519f
C144 in_0_sign VDD_1V65_3 0
C145 5v0_addh_sc_tile_2/m1_843_n857# 5v0_addh_sc_tile_2/pti 0.11666f
C146 VDD_3V3_1 5v0_add_q_sc_1/a_n1205_n937# 0.00891f
C147 5v0_add_q_sc_0/upstepper_test 5v0_add_q_sc_0/inv_nti 0.0011f
C148 in_2 res_01 0.02606f
C149 m1_n2844_n810# 5v0_addh_sc_tile_0/inv_pti 0.00753f
C150 5v0_add_q_sc_0/downstepper_test 5v0_addh_sc_tile_2/pti 0
C151 int_carry 5v0_addh_sc_tile_2/m1_843_n857# 0
C152 5v0_addh_sc_tile_1/upstepper_test 5v0_addh_sc_tile_1/ctrl_over 0.0043f
C153 int_carry 5v0_add_q_sc_0/downstepper_test 0.17146f
C154 5v0_add_q_sc_0/5v0_half_adder_selector_sc_0/m1_n244_n517# VDD_3V3_0 0.29978f
C155 5v0_addh_sc_tile_0/upstepper_test VDD_3V3_1 0.45677f
C156 5v0_addh_sc_tile_2/inv_pti 5v0_addh_sc_tile_2/a_n1373_n454# 0.00135f
C157 5v0_addh_sc_tile_1/inv_pti VDD_1V65_3 0.14775f
C158 VDD_3V3_1 5v0_addh_sc_tile_0/downstepper_test 0.51279f
C159 c_2_s 5v0_addh_sc_tile_1/m1_843_n857# 0.0069f
C160 5v0_addh_sc_tile_1/upstepper_test 5v0_addh_sc_tile_1/nti 0.11981f
C161 5v0_addh_sc_tile_1/ctrl_over 5v0_nter2oter_code_sc_0/nti 0
C162 5v0_addh_sc_tile_0/upstepper_test in_1 0.01604f
C163 in_1 5v0_addh_sc_tile_0/downstepper_test 0.18203f
C164 m1_n2844_n810# 5v0_addh_sc_tile_0/m1_843_n857# 0.00191f
C165 5v0_add_q_sc_0/nti VDD_3V3_0 0.63773f
C166 5v0_addh_sc_tile_2/inv_nti 5v0_addh_sc_tile_1/ctrl_sign 0
C167 int_carry 5v0_add_q_sc_0/inv_nti 0.02537f
C168 5v0_nter2oter_code_sc_0/pti 5v0_addh_sc_tile_1/ctrl_sign 0.00632f
C169 5v0_addh_sc_tile_1/a_n1778_n454# 5v0_addh_sc_tile_1/downstepper_test 0.0031f
C170 5v0_add_q_sc_0/inv_pti 5v0_addh_sc_tile_2/ctrl_over 0
C171 5v0_addh_sc_tile_0/inv_nti 5v0_addh_sc_tile_0/downstepper_test 0.29989f
C172 5v0_addh_sc_tile_0/upstepper_test 5v0_addh_sc_tile_0/inv_nti 0.00736f
C173 5v0_add_q_sc_0/upstepper_test 5v0_add_q_sc_0/ctrl_sign 0.08746f
C174 5v0_add_q_sc_0/5v0_half_adder_selector_sc_0/res_stage0 5v0_add_q_sc_0/downstepper_test 0.25483f
C175 5v0_add_q_sc_1/inv_nti 5v0_addh_sc_tile_1/m1_103_293# 0.00334f
C176 c_2_s in_0_sign 0
C177 5v0_addh_sc_tile_2/nti 5v0_addh_sc_tile_2/inv_nti 0.22786f
C178 5v0_add_q_sc_1/nti 5v0_add_q_sc_1/a_n1373_n454# 0
C179 5v0_addh_sc_tile_2/nti 5v0_nter2oter_code_sc_0/pti 0
C180 5v0_add_q_sc_0/upstepper_test 5v0_add_q_sc_0/pti 0
C181 5v0_add_q_sc_0/ctrl_sign 5v0_addh_sc_tile_2/pti 0.011f
C182 5v0_addh_sc_tile_0/inv_pti 5v0_addh_sc_tile_0/5v0_half_adder_selector_sc_0/res_stage0 0.01365f
C183 c_2_o 5v0_addh_sc_tile_1/m1_103_293# 0.01922f
C184 c01over VDD_1V65_2 0.03848f
C185 5v0_addh_sc_tile_1/inv_pti 5v0_add_q_sc_1/downstepper_test 0.00756f
C186 5v0_addh_sc_tile_0/a_n1373_n454# 5v0_addh_sc_tile_0/pti 0
C187 5v0_add_q_sc_0/5v0_half_adder_selector_sc_0/m1_n239_179# 5v0_addh_sc_tile_2/ctrl_over 0.00716f
C188 5v0_nter2oter_code_sc_1/nti int_012 0.00204f
C189 5v0_add_q_sc_0/a_n1373_n454# VDD_3V3_0 0.00122f
C190 int_carry 5v0_add_q_sc_0/ctrl_sign 0.00264f
C191 res_c 5v0_add_q_sc_0/downstepper_test 0.00302f
C192 5v0_addh_sc_tile_1/inv_pti c_2_s 0.12531f
C193 m1_n2844_n810# in_0_over 0.00329f
C194 5v0_nter2oter_code_sc_0/pti VDD_3V3_1 0.29053f
C195 5v0_addh_sc_tile_2/downstepper_test 5v0_addh_sc_tile_2/a_382_n1095# 0.00679f
C196 5v0_addh_sc_tile_1/ctrl_sign 5v0_addh_sc_tile_1/m1_103_293# 0.60951f
C197 5v0_nter2oter_code_sc_0/pti in_1 0
C198 int_carry 5v0_add_q_sc_0/pti 0.6113f
C199 VDD_1V65_1 5v0_add_q_sc_1/a_n1205_n937# 0.00354f
C200 5v0_add_q_sc_0/5v0_half_adder_selector_sc_0/m1_n244_n517# 5v0_addh_sc_tile_2/ctrl_over 0.00443f
C201 5v0_addh_sc_tile_1/ctrl_over VDD_1V65_5 0
C202 5v0_addh_sc_tile_2/5v0_half_adder_selector_sc_0/res_stage0 5v0_addh_sc_tile_2/m1_103_293# 0.18487f
C203 5v0_add_q_sc_0/5v0_half_adder_selector_sc_0/res_stage0 5v0_add_q_sc_0/ctrl_sign 0.22359f
C204 5v0_add_q_sc_1/inv_nti 5v0_addh_sc_tile_0/a_382_n1095# 0
C205 5v0_nter2oter_code_sc_0/pti 5v0_addh_sc_tile_0/inv_nti 0.00589f
C206 5v0_add_q_sc_0/nti 5v0_addh_sc_tile_2/ctrl_over 0
C207 5v0_addh_sc_tile_1/inv_nti VDD_1V65_3 0.08611f
C208 5v0_addh_sc_tile_0/inv_pti 5v0_addh_sc_tile_0/downstepper_test 0.14186f
C209 5v0_addh_sc_tile_0/upstepper_test 5v0_addh_sc_tile_0/inv_pti 0.07282f
C210 5v0_addh_sc_tile_2/5v0_half_adder_selector_sc_0/res_stage0 5v0_addh_sc_tile_2/inv_nti 0.02878f
C211 5v0_add_q_sc_1/nti VDD_1V65_2 0.02331f
C212 5v0_addh_sc_tile_2/m1_103_293# in_3 0
C213 5v0_addh_sc_tile_0/a_n1778_n454# 5v0_addh_sc_tile_0/pti 0.00135f
C214 res_c 5v0_add_q_sc_0/ctrl_sign 0
C215 5v0_nter2oter_code_sc_1/nti 5v0_addh_sc_tile_1/inv_nti 0.00264f
C216 VDD_3V3_1 5v0_addh_sc_tile_1/m1_103_293# 0.62378f
C217 in_0_over 5v0_addh_sc_tile_0/5v0_half_adder_selector_sc_0/res_stage0 0.09179f
C218 5v0_add_q_sc_1/inv_nti 5v0_addh_sc_tile_0/pti 0.00104f
C219 VDD_1V65_3 5v0_addh_sc_tile_1/pti 0.00234f
C220 5v0_addh_sc_tile_0/a_382_n1095# 5v0_addh_sc_tile_1/ctrl_sign 0.01186f
C221 5v0_addh_sc_tile_2/inv_nti in_3 0.28245f
C222 m1_n2844_n810# c01over 0.41041f
C223 5v0_addh_sc_tile_1/inv_pti 5v0_addh_sc_tile_1/downstepper_test 0.1369f
C224 5v0_nter2oter_code_sc_0/pti in_3 0.00219f
C225 res_01 5v0_add_q_sc_0/ctrl_sign 0.00787f
C226 5v0_add_q_sc_0/inv_pti 5v0_addh_sc_tile_1/m1_843_n857# 0
C227 5v0_addh_sc_tile_1/ctrl_over 5v0_nter2oter_code_sc_1/pti 0.00583f
C228 5v0_addh_sc_tile_0/nti 5v0_nter2oter_code_sc_0/nti 0.00244f
C229 5v0_nter2oter_code_sc_1/nti 5v0_addh_sc_tile_1/pti 0
C230 5v0_add_q_sc_1/pti 5v0_addh_sc_tile_0/a_382_n1095# 0
C231 5v0_add_q_sc_1/downstepper_test 5v0_addh_sc_tile_1/inv_nti 0.00441f
C232 5v0_addh_sc_tile_2/nti 5v0_addh_sc_tile_2/downstepper_test 0.06935f
C233 5v0_addh_sc_tile_1/nti 5v0_nter2oter_code_sc_1/pti 0
C234 c_2_s 5v0_addh_sc_tile_1/inv_nti 0.05407f
C235 5v0_add_q_sc_0/upstepper_test VDD_1V65_5 0.16859f
C236 5v0_addh_sc_tile_0/pti 5v0_addh_sc_tile_1/ctrl_sign 0.00125f
C237 5v0_addh_sc_tile_1/downstepper_test int_012 0.03365f
C238 5v0_addh_sc_tile_1/5v0_half_adder_selector_sc_0/res_stage0 5v0_addh_sc_tile_1/m1_103_293# 0.18549f
C239 VDD_3V3_1 5v0_addh_sc_tile_0/a_382_n1095# 0.63349f
C240 5v0_add_q_sc_1/downstepper_test 5v0_addh_sc_tile_1/pti 0.00147f
C241 5v0_addh_sc_tile_2/ctrl_sign 5v0_addh_sc_tile_1/ctrl_over 0.019f
C242 5v0_addh_sc_tile_1/upstepper_test res_01 0.01604f
C243 5v0_addh_sc_tile_0/upstepper_test in_0_over 0.00168f
C244 in_0_over 5v0_addh_sc_tile_0/downstepper_test 0.02344f
C245 in_1 5v0_addh_sc_tile_0/a_382_n1095# 0.09307f
C246 m1_n2844_n810# 5v0_add_q_sc_1/nti 0.00573f
C247 VDD_3V3_0 5v0_addh_sc_tile_0/downstepper_test 0
C248 VDD_1V65_4 5v0_addh_sc_tile_1/ctrl_sign 0
C249 c_2_s 5v0_addh_sc_tile_1/pti 0.01108f
C250 int_carry VDD_1V65_5 0.03394f
C251 5v0_addh_sc_tile_2/ctrl_sign 5v0_addh_sc_tile_1/nti 0.01236f
C252 5v0_addh_sc_tile_0/5v0_half_adder_selector_sc_0/5v0_tgate_sel_2_sc_1/input_A 5v0_addh_sc_tile_0/5v0_half_adder_selector_sc_0/res_stage0 0.00253f
C253 5v0_nter2oter_code_sc_1/gf180mcu_fd_sc_mcu7t5v0__nor2_1_0/a_224_472# VDD_3V3_0 0.01644f
C254 5v0_addh_sc_tile_0/upstepper_test VDD_1V65_0 0.16859f
C255 VDD_1V65_0 5v0_addh_sc_tile_0/downstepper_test 0.13024f
C256 5v0_addh_sc_tile_0/inv_nti 5v0_addh_sc_tile_0/a_382_n1095# 0.28672f
C257 5v0_addh_sc_tile_2/nti VDD_1V65_4 0.21326f
C258 5v0_addh_sc_tile_0/pti VDD_3V3_1 0.68621f
C259 5v0_add_q_sc_0/nti 5v0_addh_sc_tile_1/m1_843_n857# 0
C260 in_2 5v0_addh_sc_tile_1/ctrl_sign 0.1696f
C261 5v0_addh_sc_tile_0/pti in_1 0.66373f
C262 5v0_addh_sc_tile_2/5v0_half_adder_selector_sc_0/res_stage0 5v0_addh_sc_tile_2/downstepper_test 0.24494f
C263 5v0_addh_sc_tile_2/m1_103_293# VDD_3V3_0 0.75958f
C264 5v0_addh_sc_tile_0/a_382_n1095# 5v0_addh_sc_tile_1/5v0_half_adder_selector_sc_0/res_stage0 0
C265 5v0_addh_sc_tile_1/downstepper_test 5v0_addh_sc_tile_1/inv_nti 0.29493f
C266 5v0_add_q_sc_1/nti 5v0_add_q_sc_1/5v0_half_adder_selector_sc_0/m1_n244_n517# 0
C267 5v0_addh_sc_tile_0/pti 5v0_addh_sc_tile_0/inv_nti 0.4209f
C268 5v0_addh_sc_tile_2/m1_843_n857# 5v0_add_q_sc_0/ctrl_over 0.17802f
C269 5v0_nter2oter_code_sc_1/pti 5v0_addh_sc_tile_2/pti 0.00125f
C270 5v0_add_q_sc_0/ctrl_over 5v0_add_q_sc_0/downstepper_test 0.02328f
C271 VDD_3V3_0 5v0_addh_sc_tile_2/inv_nti 0.88474f
C272 5v0_addh_sc_tile_2/m1_843_n857# 5v0_addh_sc_tile_2/a_382_n1095# 0.05013f
C273 5v0_addh_sc_tile_2/downstepper_test in_3 0.18203f
C274 5v0_addh_sc_tile_0/upstepper_test c01over 0
C275 5v0_add_q_sc_0/downstepper_test 5v0_addh_sc_tile_2/a_382_n1095# 0.00139f
C276 5v0_addh_sc_tile_0/5v0_half_adder_selector_sc_0/5v0_tgate_sel_2_sc_1/input_A 5v0_addh_sc_tile_0/downstepper_test 0
C277 5v0_addh_sc_tile_0/upstepper_test 5v0_addh_sc_tile_0/5v0_half_adder_selector_sc_0/5v0_tgate_sel_2_sc_1/input_A 0
C278 5v0_nter2oter_code_sc_0/pti VDD_3V3_0 0.17187f
C279 5v0_addh_sc_tile_1/downstepper_test 5v0_addh_sc_tile_1/pti 0.19626f
C280 in_2 VDD_3V3_1 0.90866f
C281 in_2 in_1 0
C282 5v0_addh_sc_tile_0/nti 5v0_nter2oter_code_sc_1/pti 0
C283 5v0_addh_sc_tile_2/ctrl_sign 5v0_addh_sc_tile_2/pti 0.28211f
C284 5v0_addh_sc_tile_0/inv_pti 5v0_addh_sc_tile_0/a_382_n1095# 0.00129f
C285 int_carry 5v0_addh_sc_tile_2/ctrl_sign 0
C286 in_2 5v0_addh_sc_tile_0/inv_nti 0.0153f
C287 5v0_addh_sc_tile_2/m1_103_293# 5v0_addh_sc_tile_2/upstepper_test 0.07773f
C288 c_2_o 5v0_add_q_sc_0/downstepper_test 0.0085f
C289 5v0_add_q_sc_1/nti 5v0_add_q_sc_1/a_n1205_n937# 0
C290 5v0_add_q_sc_0/inv_pti 5v0_addh_sc_tile_1/inv_nti 0
C291 5v0_add_q_sc_0/ctrl_over 5v0_add_q_sc_0/ctrl_sign 0.02618f
C292 m1_n2844_n810# in_0_sign 0.0018f
C293 VDD_1V65_4 in_3 0.01451f
C294 5v0_addh_sc_tile_2/upstepper_test 5v0_addh_sc_tile_2/inv_nti 0.00736f
C295 VDD_3V3_0 5v0_addh_sc_tile_1/m1_103_293# 0.14668f
C296 5v0_addh_sc_tile_0/a_382_n1095# 5v0_addh_sc_tile_0/m1_843_n857# 0.05013f
C297 c_2_o 5v0_add_q_sc_0/inv_nti 0
C298 5v0_add_q_sc_0/ctrl_sign 5v0_addh_sc_tile_2/a_382_n1095# 0.00651f
C299 5v0_addh_sc_tile_2/m1_103_293# 5v0_addh_sc_tile_2/ctrl_over 0.05856f
C300 5v0_addh_sc_tile_2/5v0_half_adder_selector_sc_0/5v0_tgate_sel_2_sc_1/input_A 5v0_add_q_sc_0/ctrl_over 0
C301 5v0_addh_sc_tile_0/pti 5v0_addh_sc_tile_0/inv_pti 0.44081f
C302 5v0_addh_sc_tile_2/5v0_half_adder_selector_sc_0/5v0_tgate_sel_2_sc_1/input_A 5v0_addh_sc_tile_2/a_382_n1095# 0.02928f
C303 5v0_add_q_sc_0/ctrl_over 5v0_add_q_sc_0/pti 0
C304 5v0_add_q_sc_0/inv_pti 5v0_addh_sc_tile_1/pti 0
C305 5v0_add_q_sc_0/5v0_half_adder_selector_sc_0/m1_n239_179# 5v0_addh_sc_tile_1/inv_nti 0
C306 5v0_addh_sc_tile_1/inv_pti m1_n2844_n810# 0
C307 res_01 5v0_nter2oter_code_sc_1/pti 0
C308 5v0_addh_sc_tile_2/inv_nti 5v0_addh_sc_tile_2/ctrl_over 0.26006f
C309 5v0_addh_sc_tile_2/a_n1373_n454# 5v0_addh_sc_tile_2/pti 0
C310 5v0_addh_sc_tile_0/pti 5v0_addh_sc_tile_0/m1_843_n857# 0.11666f
C311 5v0_nter2oter_code_sc_0/pti 5v0_addh_sc_tile_2/ctrl_over 0.00125f
C312 5v0_addh_sc_tile_1/5v0_half_adder_selector_sc_0/5v0_tgate_sel_2_sc_1/input_A 5v0_addh_sc_tile_1/a_382_n1095# 0.02928f
C313 5v0_add_q_sc_1/downstepper_test 5v0_add_q_sc_1/5v0_half_adder_selector_sc_0/res_stage0 0.25483f
C314 5v0_add_q_sc_0/5v0_half_adder_selector_sc_0/m1_n239_179# 5v0_addh_sc_tile_1/pti 0
C315 in_0_over 5v0_addh_sc_tile_0/a_382_n1095# 0.63576f
C316 5v0_add_q_sc_1/5v0_half_adder_selector_sc_0/res_stage0 c_2_s 0.22434f
C317 5v0_addh_sc_tile_0/a_382_n1095# VDD_3V3_0 0
C318 5v0_addh_sc_tile_2/downstepper_test VDD_3V3_0 0.5243f
C319 in_0_sign 5v0_addh_sc_tile_0/5v0_half_adder_selector_sc_0/res_stage0 0.22359f
C320 c_2_o 5v0_add_q_sc_0/pti 0.00513f
C321 c01over 5v0_addh_sc_tile_1/m1_103_293# 0.002f
C322 5v0_add_q_sc_0/nti 5v0_addh_sc_tile_1/inv_nti 0
C323 5v0_add_q_sc_0/ctrl_sign 5v0_addh_sc_tile_1/ctrl_sign 0
C324 in_2 5v0_addh_sc_tile_0/inv_pti 0.00153f
C325 5v0_addh_sc_tile_2/ctrl_sign res_01 0
C326 5v0_addh_sc_tile_2/a_n1778_n454# 5v0_addh_sc_tile_2/pti 0.00135f
C327 5v0_addh_sc_tile_0/pti in_0_over 0.10966f
C328 5v0_add_q_sc_0/nti 5v0_addh_sc_tile_1/pti 0
C329 5v0_addh_sc_tile_1/ctrl_over 5v0_addh_sc_tile_2/inv_pti 0.00359f
C330 5v0_addh_sc_tile_1/upstepper_test 5v0_addh_sc_tile_1/ctrl_sign 0.10431f
C331 5v0_addh_sc_tile_0/pti VDD_1V65_0 0.00234f
C332 5v0_add_q_sc_1/downstepper_test c_2_s 0.25694f
C333 5v0_add_q_sc_1/nti 5v0_addh_sc_tile_1/m1_103_293# 0.00685f
C334 VDD_3V3_0 VDD_1V65_4 0.0468f
C335 5v0_addh_sc_tile_2/m1_843_n857# in_3 0
C336 5v0_addh_sc_tile_2/downstepper_test 5v0_addh_sc_tile_2/upstepper_test 0.38555f
C337 c01over 5v0_addh_sc_tile_0/a_382_n1095# 0.08249f
C338 in_0_sign 5v0_addh_sc_tile_0/downstepper_test 0.14463f
C339 5v0_addh_sc_tile_0/upstepper_test in_0_sign 0.08746f
C340 5v0_addh_sc_tile_1/nti 5v0_addh_sc_tile_2/inv_pti 0
C341 5v0_nter2oter_code_sc_0/nti 5v0_addh_sc_tile_1/ctrl_sign 0
C342 5v0_addh_sc_tile_0/a_382_n1095# 5v0_addh_sc_tile_0/5v0_half_adder_selector_sc_0/5v0_tgate_sel_2_sc_1/input_A 0.02928f
C343 5v0_addh_sc_tile_1/downstepper_test VDD_1V65_3 0.13024f
C344 5v0_add_q_sc_0/ctrl_over VDD_1V65_5 0
C345 5v0_add_q_sc_0/5v0_half_adder_selector_sc_0/5v0_tgate_sel_2_sc_1/input_A 5v0_add_q_sc_0/upstepper_test 0
C346 5v0_addh_sc_tile_2/nti 5v0_nter2oter_code_sc_0/nti 0.00237f
C347 5v0_addh_sc_tile_2/downstepper_test 5v0_addh_sc_tile_2/ctrl_over 0.02378f
C348 in_2 VDD_3V3_0 0.0135f
C349 5v0_addh_sc_tile_1/ctrl_over 5v0_addh_sc_tile_1/a_382_n1095# 0.70472f
C350 c01over 5v0_addh_sc_tile_0/pti 0.14494f
C351 5v0_nter2oter_code_sc_1/nti 5v0_addh_sc_tile_1/downstepper_test 0
C352 5v0_addh_sc_tile_1/upstepper_test VDD_3V3_1 0.39457f
C353 in_2 VDD_1V65_0 0
C354 5v0_addh_sc_tile_1/nti 5v0_addh_sc_tile_1/a_382_n1095# 0
C355 5v0_addh_sc_tile_1/5v0_half_adder_selector_sc_0/res_stage0 5v0_add_q_sc_0/ctrl_sign 0
C356 5v0_addh_sc_tile_2/5v0_half_adder_selector_sc_0/5v0_tgate_sel_2_sc_1/input_A 5v0_addh_sc_tile_2/5v0_half_adder_selector_sc_0/res_stage0 0.00253f
C357 VDD_3V3_1 5v0_nter2oter_code_sc_0/nti 0.09208f
C358 5v0_add_q_sc_1/nti 5v0_addh_sc_tile_0/a_382_n1095# 0
C359 5v0_addh_sc_tile_2/upstepper_test VDD_1V65_4 0.16859f
C360 5v0_nter2oter_code_sc_1/gf180mcu_fd_sc_mcu7t5v0__nor2_1_0/a_224_472# int_012 0
C361 5v0_addh_sc_tile_1/inv_pti 5v0_addh_sc_tile_2/m1_103_293# 0
C362 5v0_add_q_sc_0/upstepper_test 5v0_addh_sc_tile_2/inv_pti 0
C363 5v0_addh_sc_tile_1/nti res_0 0
C364 5v0_add_q_sc_0/5v0_half_adder_selector_sc_0/5v0_tgate_sel_2_sc_1/input_A 5v0_add_q_sc_0/5v0_half_adder_selector_sc_0/res_stage0 0.00253f
C365 5v0_addh_sc_tile_1/downstepper_test c_2_s 0
C366 5v0_addh_sc_tile_1/inv_pti 5v0_addh_sc_tile_2/inv_nti 0
C367 VDD_1V65_4 5v0_addh_sc_tile_2/ctrl_over 0.00145f
C368 5v0_addh_sc_tile_1/m1_843_n857# 5v0_addh_sc_tile_1/m1_103_293# 0.20659f
C369 5v0_addh_sc_tile_2/inv_pti 5v0_addh_sc_tile_2/pti 0.44081f
C370 5v0_addh_sc_tile_1/upstepper_test 5v0_addh_sc_tile_1/5v0_half_adder_selector_sc_0/res_stage0 0.27475f
C371 5v0_add_q_sc_1/nti 5v0_addh_sc_tile_0/pti 0.00264f
C372 5v0_addh_sc_tile_2/m1_103_293# int_012 0.00332f
C373 5v0_add_q_sc_0/upstepper_test 5v0_addh_sc_tile_1/a_382_n1095# 0.0104f
C374 5v0_addh_sc_tile_2/ctrl_sign 5v0_add_q_sc_0/ctrl_over 0.00758f
C375 in_2 5v0_addh_sc_tile_2/ctrl_over 0
C376 5v0_addh_sc_tile_2/m1_843_n857# VDD_3V3_0 0.17677f
C377 5v0_addh_sc_tile_2/ctrl_sign 5v0_addh_sc_tile_2/a_382_n1095# 0.07412f
C378 5v0_add_q_sc_1/downstepper_test 5v0_add_q_sc_1/a_n1373_n454# 0.00442f
C379 int_012 5v0_addh_sc_tile_2/inv_nti 0
C380 5v0_addh_sc_tile_1/5v0_half_adder_selector_sc_0/5v0_tgate_sel_2_sc_1/input_A 5v0_addh_sc_tile_1/ctrl_over 0.04656f
C381 VDD_3V3_0 5v0_add_q_sc_0/downstepper_test 0.55841f
C382 5v0_nter2oter_code_sc_0/nti in_3 0.00248f
C383 5v0_nter2oter_code_sc_0/pti int_012 0.58802f
C384 int_carry 5v0_addh_sc_tile_1/a_382_n1095# 0.00603f
C385 5v0_nter2oter_code_sc_1/pti 5v0_addh_sc_tile_1/ctrl_sign 0.28956f
C386 VDD_3V3_0 5v0_add_q_sc_0/inv_nti 0.56502f
C387 5v0_addh_sc_tile_1/inv_pti 5v0_addh_sc_tile_1/m1_103_293# 0.17653f
C388 res_0 5v0_addh_sc_tile_2/pti 0
C389 5v0_addh_sc_tile_2/nti 5v0_nter2oter_code_sc_1/pti 0
C390 5v0_addh_sc_tile_1/upstepper_test 5v0_addh_sc_tile_0/m1_843_n857# 0.00724f
C391 5v0_addh_sc_tile_2/m1_103_293# 5v0_addh_sc_tile_1/inv_nti 0.00513f
C392 5v0_add_q_sc_0/5v0_half_adder_selector_sc_0/res_stage0 5v0_addh_sc_tile_1/a_382_n1095# 0.00175f
C393 5v0_addh_sc_tile_2/ctrl_sign 5v0_addh_sc_tile_1/ctrl_sign 0.036f
C394 5v0_addh_sc_tile_0/a_382_n1095# in_0_sign 0.07412f
C395 res_01 5v0_addh_sc_tile_2/inv_pti 0
C396 VDD_3V3_0 5v0_add_q_sc_0/ctrl_sign 0.80665f
C397 5v0_addh_sc_tile_2/inv_nti 5v0_addh_sc_tile_1/inv_nti 0
C398 VDD_3V3_1 5v0_nter2oter_code_sc_1/pti 0.29062f
C399 5v0_addh_sc_tile_2/5v0_half_adder_selector_sc_0/5v0_tgate_sel_2_sc_1/input_A VDD_3V3_0 0.02871f
C400 5v0_addh_sc_tile_2/m1_103_293# 5v0_addh_sc_tile_1/pti 0
C401 c_2_s VDD_1V65_2 0.00149f
C402 5v0_addh_sc_tile_2/nti 5v0_addh_sc_tile_2/a_n1205_n937# 0
C403 VDD_3V3_0 5v0_add_q_sc_0/pti 0.57843f
C404 5v0_addh_sc_tile_2/nti 5v0_addh_sc_tile_2/ctrl_sign 0.01914f
C405 5v0_addh_sc_tile_2/m1_843_n857# 5v0_addh_sc_tile_2/ctrl_over 0.10619f
C406 5v0_addh_sc_tile_1/inv_pti 5v0_addh_sc_tile_0/a_382_n1095# 0
C407 5v0_add_q_sc_0/downstepper_test 5v0_addh_sc_tile_2/ctrl_over 0.01272f
C408 5v0_addh_sc_tile_0/inv_nti 5v0_nter2oter_code_sc_1/pti 0.00491f
C409 5v0_addh_sc_tile_0/pti in_0_sign 0.27027f
C410 5v0_addh_sc_tile_1/upstepper_test in_0_over 0.01202f
C411 res_01 5v0_addh_sc_tile_1/a_382_n1095# 0.09307f
C412 5v0_addh_sc_tile_1/upstepper_test VDD_3V3_0 0.13286f
C413 5v0_addh_sc_tile_2/ctrl_sign VDD_3V3_1 0.00526f
C414 5v0_add_q_sc_0/a_n1205_n937# 5v0_add_q_sc_0/nti 0
C415 5v0_addh_sc_tile_1/inv_pti 5v0_addh_sc_tile_0/pti 0.00107f
C416 5v0_addh_sc_tile_1/nti 5v0_addh_sc_tile_1/ctrl_over 0.0773f
C417 VDD_3V3_0 5v0_nter2oter_code_sc_0/nti 0.31492f
C418 5v0_addh_sc_tile_1/inv_nti 5v0_addh_sc_tile_1/m1_103_293# 0.35313f
C419 5v0_addh_sc_tile_2/ctrl_sign 5v0_addh_sc_tile_0/inv_nti 0
C420 5v0_addh_sc_tile_1/a_n1205_n937# 5v0_addh_sc_tile_1/upstepper_test 0.00334f
C421 5v0_addh_sc_tile_2/5v0_half_adder_selector_sc_0/5v0_tgate_sel_2_sc_1/input_A 5v0_addh_sc_tile_2/upstepper_test 0
C422 5v0_add_q_sc_1/5v0_half_adder_selector_sc_0/res_stage0 5v0_add_q_sc_1/5v0_half_adder_selector_sc_0/m1_n244_n517# 0.08646f
C423 5v0_addh_sc_tile_2/nti 5v0_addh_sc_tile_2/a_n1373_n454# 0
C424 5v0_add_q_sc_0/ctrl_sign 5v0_addh_sc_tile_2/ctrl_over 0.2177f
C425 5v0_addh_sc_tile_2/5v0_half_adder_selector_sc_0/res_stage0 5v0_addh_sc_tile_2/a_n1205_n937# 0
C426 5v0_addh_sc_tile_0/m1_103_293# c01 0.21008f
C427 m1_n2844_n810# c_2_s 0.00441f
C428 5v0_addh_sc_tile_2/ctrl_sign 5v0_addh_sc_tile_2/5v0_half_adder_selector_sc_0/res_stage0 0.25152f
C429 5v0_addh_sc_tile_1/pti 5v0_addh_sc_tile_1/m1_103_293# 0.10002f
C430 5v0_add_q_sc_1/inv_pti 5v0_addh_sc_tile_1/a_382_n1095# 0
C431 5v0_addh_sc_tile_2/5v0_half_adder_selector_sc_0/5v0_tgate_sel_2_sc_1/input_A 5v0_addh_sc_tile_2/ctrl_over 0.04656f
C432 5v0_addh_sc_tile_1/upstepper_test c01over 0.02788f
C433 5v0_addh_sc_tile_1/inv_pti in_2 0
C434 5v0_addh_sc_tile_0/inv_pti 5v0_nter2oter_code_sc_1/pti 0
C435 5v0_add_q_sc_0/5v0_half_adder_selector_sc_0/5v0_tgate_sel_2_sc_1/input_A 5v0_add_q_sc_0/ctrl_over 0.04656f
C436 5v0_addh_sc_tile_2/ctrl_sign in_3 0.0062f
C437 5v0_addh_sc_tile_0/a_382_n1095# 5v0_addh_sc_tile_1/inv_nti 0
C438 5v0_add_q_sc_0/upstepper_test 5v0_addh_sc_tile_1/ctrl_over 0.00229f
C439 5v0_addh_sc_tile_1/a_n1373_n454# 5v0_addh_sc_tile_1/upstepper_test 0
C440 5v0_addh_sc_tile_1/upstepper_test 5v0_addh_sc_tile_2/ctrl_over 0
C441 5v0_add_q_sc_1/5v0_half_adder_selector_sc_0/res_stage0 5v0_add_q_sc_1/a_n1205_n937# 0
C442 5v0_add_q_sc_1/downstepper_test 5v0_add_q_sc_1/5v0_half_adder_selector_sc_0/m1_n244_n517# 0.00507f
C443 5v0_add_q_sc_0/inv_pti 5v0_add_q_sc_0/5v0_half_adder_selector_sc_0/m1_n239_179# 0
C444 5v0_addh_sc_tile_2/nti 5v0_addh_sc_tile_2/a_n1778_n454# 0.00142f
C445 VDD_3V3_0 VDD_1V65_5 0.04709f
C446 c_2_s 5v0_add_q_sc_1/5v0_half_adder_selector_sc_0/m1_n244_n517# 0
C447 in_2 int_012 0.00863f
C448 5v0_nter2oter_code_sc_0/nti 5v0_addh_sc_tile_2/ctrl_over 0.22761f
C449 5v0_addh_sc_tile_1/ctrl_over 5v0_addh_sc_tile_2/pti 0
C450 5v0_addh_sc_tile_0/a_382_n1095# 5v0_addh_sc_tile_1/pti 0.00485f
C451 int_carry 5v0_addh_sc_tile_1/ctrl_over 0.01695f
C452 5v0_addh_sc_tile_0/pti 5v0_addh_sc_tile_1/inv_nti 0
C453 5v0_addh_sc_tile_1/nti 5v0_addh_sc_tile_2/pti 0
C454 5v0_add_q_sc_1/upstepper_test 5v0_add_q_sc_1/5v0_half_adder_selector_sc_0/5v0_tgate_sel_2_sc_1/input_A 0
C455 5v0_addh_sc_tile_1/downstepper_test m1_n2844_n810# 0
C456 5v0_nter2oter_code_sc_1/nti 5v0_addh_sc_tile_0/upstepper_test 0
C457 5v0_nter2oter_code_sc_1/nti 5v0_addh_sc_tile_0/downstepper_test 0
C458 5v0_addh_sc_tile_2/a_n1373_n454# in_3 0.00163f
C459 5v0_addh_sc_tile_2/inv_pti 5v0_addh_sc_tile_2/a_382_n1095# 0.00129f
C460 5v0_add_q_sc_0/inv_pti 5v0_add_q_sc_0/nti 0.21873f
C461 5v0_addh_sc_tile_1/nti 5v0_addh_sc_tile_0/m1_103_293# 0
C462 5v0_nter2oter_code_sc_1/nti 5v0_nter2oter_code_sc_1/gf180mcu_fd_sc_mcu7t5v0__nor2_1_0/a_224_472# 0.00898f
C463 5v0_addh_sc_tile_0/nti 5v0_addh_sc_tile_1/ctrl_over 0
C464 5v0_add_q_sc_0/5v0_half_adder_selector_sc_0/res_stage0 5v0_addh_sc_tile_1/ctrl_over 0
C465 5v0_addh_sc_tile_0/pti 5v0_addh_sc_tile_1/pti 0
C466 5v0_addh_sc_tile_1/a_n1778_n454# 5v0_addh_sc_tile_1/upstepper_test 0
C467 5v0_add_q_sc_1/downstepper_test 5v0_add_q_sc_1/a_n1205_n937# 0.00453f
C468 5v0_add_q_sc_0/5v0_half_adder_selector_sc_0/m1_n244_n517# 5v0_add_q_sc_0/5v0_half_adder_selector_sc_0/m1_n239_179# 0.00585f
C469 VDD_3V3_0 5v0_nter2oter_code_sc_1/pti 0.19634f
C470 c01 int_c01 0.05455f
C471 5v0_addh_sc_tile_1/inv_pti 5v0_addh_sc_tile_2/m1_843_n857# 0
C472 5v0_addh_sc_tile_1/a_382_n1095# 5v0_add_q_sc_0/ctrl_over 0
C473 res_c 5v0_addh_sc_tile_1/ctrl_over 0
C474 5v0_add_q_sc_0/a_n1373_n454# 5v0_add_q_sc_0/inv_pti 0.00135f
C475 VDD_1V65_5 5v0_addh_sc_tile_2/ctrl_over 0
C476 5v0_add_q_sc_0/pti 5v0_addh_sc_tile_1/m1_843_n857# 0.00111f
C477 5v0_add_q_sc_0/upstepper_test 5v0_addh_sc_tile_2/pti 0
C478 VDD_3V3_0 5v0_addh_sc_tile_2/a_n1205_n937# 0.00891f
C479 5v0_addh_sc_tile_2/inv_pti 5v0_addh_sc_tile_1/ctrl_sign 0.00447f
C480 5v0_addh_sc_tile_2/a_n1778_n454# in_3 0.00182f
C481 5v0_addh_sc_tile_2/ctrl_sign VDD_3V3_0 1.61336f
C482 5v0_add_q_sc_0/5v0_half_adder_selector_sc_0/m1_n244_n517# 5v0_add_q_sc_0/nti 0
C483 int_carry 5v0_add_q_sc_0/upstepper_test 0.02583f
C484 res_0 5v0_add_q_sc_0/ctrl_over 0
C485 res_01 5v0_addh_sc_tile_1/ctrl_over 0.25947f
C486 res_0 5v0_addh_sc_tile_2/a_382_n1095# 0.16245f
C487 5v0_addh_sc_tile_1/a_382_n1095# c_2_o 0.08702f
C488 res_01 5v0_addh_sc_tile_1/nti 0.54752f
C489 int_carry 5v0_addh_sc_tile_2/pti 0.00318f
C490 5v0_addh_sc_tile_2/nti 5v0_addh_sc_tile_2/inv_pti 0.24025f
C491 5v0_addh_sc_tile_1/inv_pti 5v0_add_q_sc_0/ctrl_sign 0
C492 5v0_add_q_sc_0/5v0_half_adder_selector_sc_0/res_stage0 5v0_add_q_sc_0/upstepper_test 0.27475f
C493 5v0_addh_sc_tile_1/a_382_n1095# 5v0_addh_sc_tile_1/ctrl_sign 0.07412f
C494 5v0_nter2oter_code_sc_1/pti 5v0_addh_sc_tile_2/ctrl_over 0
C495 5v0_add_q_sc_0/5v0_half_adder_selector_sc_0/res_stage0 5v0_addh_sc_tile_2/pti 0
C496 m1_n2844_n810# VDD_1V65_2 0.00448f
C497 5v0_addh_sc_tile_2/upstepper_test 5v0_addh_sc_tile_2/a_n1205_n937# 0.00334f
C498 VDD_3V3_0 5v0_addh_sc_tile_2/a_n1373_n454# 0.00122f
C499 5v0_addh_sc_tile_2/ctrl_sign 5v0_addh_sc_tile_2/upstepper_test 0.15846f
C500 5v0_add_q_sc_0/a_n1373_n454# 5v0_add_q_sc_0/nti 0
C501 int_carry 5v0_add_q_sc_0/5v0_half_adder_selector_sc_0/res_stage0 0.27792f
C502 5v0_nter2oter_code_sc_1/gf180mcu_fd_sc_mcu7t5v0__nor2_1_0/a_224_472# 5v0_addh_sc_tile_1/downstepper_test 0
C503 int_012 5v0_add_q_sc_0/ctrl_sign 0.01026f
C504 5v0_add_q_sc_0/downstepper_test 5v0_addh_sc_tile_1/inv_nti 0
C505 5v0_addh_sc_tile_1/inv_pti 5v0_addh_sc_tile_1/upstepper_test 0.06901f
C506 res_c 5v0_addh_sc_tile_2/pti 0
C507 5v0_addh_sc_tile_2/a_n1205_n937# 5v0_addh_sc_tile_2/ctrl_over 0
C508 5v0_addh_sc_tile_1/a_382_n1095# VDD_3V3_1 0.02507f
C509 5v0_addh_sc_tile_2/ctrl_sign 5v0_addh_sc_tile_2/ctrl_over 0.63344f
C510 res_c int_carry 0.167f
C511 5v0_addh_sc_tile_2/nti res_0 0
C512 5v0_addh_sc_tile_2/5v0_half_adder_selector_sc_0/res_stage0 5v0_addh_sc_tile_2/inv_pti 0.01003f
C513 5v0_addh_sc_tile_1/downstepper_test 5v0_addh_sc_tile_2/m1_103_293# 0.00921f
C514 c_2_s 5v0_addh_sc_tile_1/m1_103_293# 0.22665f
C515 5v0_addh_sc_tile_1/upstepper_test int_012 0.00268f
C516 5v0_addh_sc_tile_1/5v0_half_adder_selector_sc_0/5v0_tgate_sel_2_sc_1/input_A c_2_o 0
C517 5v0_addh_sc_tile_1/downstepper_test 5v0_addh_sc_tile_2/inv_nti 0.00392f
C518 int_carry 5v0_add_q_sc_1/upstepper_test 0
C519 5v0_addh_sc_tile_2/upstepper_test 5v0_addh_sc_tile_2/a_n1373_n454# 0
C520 5v0_addh_sc_tile_2/inv_pti in_3 0.05631f
C521 res_c 5v0_add_q_sc_0/5v0_half_adder_selector_sc_0/res_stage0 0.08533f
C522 res_01 5v0_addh_sc_tile_0/m1_103_293# 0
C523 int_012 5v0_nter2oter_code_sc_0/nti 0.23186f
C524 5v0_add_q_sc_0/ctrl_sign 5v0_addh_sc_tile_1/inv_nti 0
C525 5v0_addh_sc_tile_1/5v0_half_adder_selector_sc_0/5v0_tgate_sel_2_sc_1/input_A 5v0_addh_sc_tile_1/ctrl_sign 0
C526 5v0_addh_sc_tile_1/a_382_n1095# 5v0_addh_sc_tile_1/5v0_half_adder_selector_sc_0/res_stage0 0.08951f
C527 c_2_o 5v0_add_q_sc_1/5v0_half_adder_selector_sc_0/5v0_tgate_sel_2_sc_1/input_A 0.04656f
C528 res_01 5v0_addh_sc_tile_0/nti 0
C529 int_carry int_c01 0.17661f
C530 5v0_addh_sc_tile_0/m1_103_293# int_c01 0
C531 5v0_add_q_sc_0/ctrl_sign 5v0_addh_sc_tile_1/pti 0
C532 c_2_s 5v0_addh_sc_tile_0/a_382_n1095# 0
C533 res_0 5v0_addh_sc_tile_2/5v0_half_adder_selector_sc_0/res_stage0 0.08533f
C534 5v0_addh_sc_tile_1/ctrl_over 5v0_add_q_sc_0/ctrl_over 0
C535 5v0_addh_sc_tile_1/upstepper_test 5v0_addh_sc_tile_1/inv_nti 0.00736f
C536 5v0_addh_sc_tile_1/ctrl_over 5v0_addh_sc_tile_2/a_382_n1095# 0
C537 5v0_addh_sc_tile_2/upstepper_test 5v0_addh_sc_tile_2/a_n1778_n454# 0
C538 5v0_addh_sc_tile_1/downstepper_test 5v0_addh_sc_tile_1/m1_103_293# 0.10533f
C539 VDD_1V65_1 5v0_addh_sc_tile_1/a_382_n1095# 0
C540 5v0_add_q_sc_1/pti c01 0
C541 5v0_add_q_sc_0/5v0_half_adder_selector_sc_0/5v0_tgate_sel_2_sc_1/input_A VDD_3V3_0 0.02871f
C542 5v0_addh_sc_tile_1/nti 5v0_addh_sc_tile_2/a_382_n1095# 0
C543 res_0 in_3 0.16326f
C544 c_2_s 5v0_addh_sc_tile_0/pti 0.00768f
C545 5v0_addh_sc_tile_1/upstepper_test 5v0_addh_sc_tile_1/pti 0.02161f
C546 5v0_addh_sc_tile_0/a_n1205_n937# 5v0_addh_sc_tile_0/nti 0
C547 5v0_nter2oter_code_sc_1/nti in_2 0.19929f
C548 VDD_3V3_1 5v0_add_q_sc_1/5v0_half_adder_selector_sc_0/5v0_tgate_sel_2_sc_1/input_A 0.02871f
C549 5v0_add_q_sc_1/5v0_half_adder_selector_sc_0/m1_n239_179# 5v0_add_q_sc_1/upstepper_test 0.07502f
C550 c01 VDD_3V3_1 0.17781f
C551 5v0_add_q_sc_0/5v0_half_adder_selector_sc_0/m1_n239_179# 5v0_addh_sc_tile_2/inv_nti 0
C552 5v0_add_q_sc_0/nti 5v0_add_q_sc_0/a_n1778_n454# 0.00142f
C553 5v0_addh_sc_tile_1/ctrl_over c_2_o 0.12383f
C554 5v0_addh_sc_tile_1/nti c_2_o 0
C555 c01 5v0_addh_sc_tile_0/inv_nti 0.17527f
C556 5v0_addh_sc_tile_1/5v0_half_adder_selector_sc_0/5v0_tgate_sel_2_sc_1/input_A 5v0_addh_sc_tile_1/5v0_half_adder_selector_sc_0/res_stage0 0.00253f
C557 VDD_3V3_0 5v0_addh_sc_tile_2/inv_pti 1.08715f
C558 5v0_addh_sc_tile_1/ctrl_over 5v0_addh_sc_tile_1/ctrl_sign 0.49329f
C559 5v0_add_q_sc_1/5v0_half_adder_selector_sc_0/m1_n239_179# int_c01 0.00189f
C560 5v0_add_q_sc_1/upstepper_test int_c01 0.02545f
C561 5v0_add_q_sc_0/5v0_half_adder_selector_sc_0/m1_n244_n517# 5v0_addh_sc_tile_2/inv_nti 0
C562 5v0_addh_sc_tile_1/nti 5v0_addh_sc_tile_1/ctrl_sign 0.14557f
C563 5v0_add_q_sc_0/upstepper_test 5v0_add_q_sc_0/ctrl_over 0.00167f
C564 m1_n2844_n810# 5v0_addh_sc_tile_0/downstepper_test 0
C565 5v0_add_q_sc_0/upstepper_test 5v0_addh_sc_tile_2/a_382_n1095# 0
C566 5v0_add_q_sc_1/inv_pti 5v0_add_q_sc_1/5v0_half_adder_selector_sc_0/m1_n239_179# 0
C567 5v0_add_q_sc_1/inv_pti 5v0_add_q_sc_1/upstepper_test 0.0467f
C568 5v0_addh_sc_tile_2/nti 5v0_addh_sc_tile_1/ctrl_over 0
C569 int_012 5v0_nter2oter_code_sc_1/pti 0.00485f
C570 5v0_addh_sc_tile_0/a_n1373_n454# 5v0_addh_sc_tile_0/nti 0
C571 5v0_addh_sc_tile_1/inv_pti 5v0_addh_sc_tile_2/ctrl_sign 0
C572 5v0_add_q_sc_0/5v0_half_adder_selector_sc_0/m1_n239_179# 5v0_addh_sc_tile_1/m1_103_293# 0
C573 5v0_add_q_sc_0/ctrl_over 5v0_addh_sc_tile_2/pti 0.13176f
C574 5v0_addh_sc_tile_1/a_382_n1095# VDD_3V3_0 0.61115f
C575 5v0_addh_sc_tile_2/pti 5v0_addh_sc_tile_2/a_382_n1095# 0.12254f
C576 int_carry 5v0_add_q_sc_0/ctrl_over 0.15164f
C577 int_carry 5v0_addh_sc_tile_2/a_382_n1095# 0.0013f
C578 5v0_addh_sc_tile_1/ctrl_over VDD_3V3_1 0.02424f
C579 5v0_add_q_sc_1/inv_pti int_c01 0.08427f
C580 5v0_addh_sc_tile_1/ctrl_over in_1 0
C581 VDD_1V65_2 5v0_addh_sc_tile_1/m1_103_293# 0
C582 5v0_add_q_sc_0/upstepper_test c_2_o 0.01814f
C583 5v0_addh_sc_tile_2/upstepper_test 5v0_addh_sc_tile_2/inv_pti 0.07254f
C584 5v0_addh_sc_tile_1/nti VDD_3V3_1 0.14047f
C585 5v0_addh_sc_tile_2/ctrl_sign int_012 0.30294f
C586 5v0_addh_sc_tile_1/nti in_1 0.00579f
C587 res_0 VDD_3V3_0 0.09575f
C588 5v0_addh_sc_tile_1/ctrl_over 5v0_addh_sc_tile_0/inv_nti 0
C589 5v0_add_q_sc_0/5v0_half_adder_selector_sc_0/res_stage0 5v0_add_q_sc_0/ctrl_over 0.09148f
C590 c01 5v0_addh_sc_tile_0/inv_pti 0.17523f
C591 5v0_addh_sc_tile_0/downstepper_test 5v0_addh_sc_tile_0/5v0_half_adder_selector_sc_0/res_stage0 0.25483f
C592 5v0_addh_sc_tile_0/upstepper_test 5v0_addh_sc_tile_0/5v0_half_adder_selector_sc_0/res_stage0 0.27475f
C593 5v0_add_q_sc_0/5v0_half_adder_selector_sc_0/res_stage0 5v0_addh_sc_tile_2/a_382_n1095# 0.0013f
C594 5v0_add_q_sc_0/upstepper_test 5v0_addh_sc_tile_1/ctrl_sign 0
C595 5v0_addh_sc_tile_1/nti 5v0_addh_sc_tile_0/inv_nti 0
C596 5v0_addh_sc_tile_2/inv_pti 5v0_addh_sc_tile_2/ctrl_over 0.0554f
C597 5v0_addh_sc_tile_0/a_n1778_n454# 5v0_addh_sc_tile_0/nti 0.00142f
C598 int_carry c_2_o 0.30261f
C599 c01 5v0_addh_sc_tile_0/m1_843_n857# 0.00703f
C600 5v0_addh_sc_tile_2/pti 5v0_addh_sc_tile_1/ctrl_sign 0.00148f
C601 5v0_addh_sc_tile_1/a_382_n1095# c01over 0
C602 5v0_addh_sc_tile_1/ctrl_over 5v0_addh_sc_tile_1/5v0_half_adder_selector_sc_0/res_stage0 0.11033f
C603 res_c 5v0_add_q_sc_0/ctrl_over 0.20136f
C604 int_carry 5v0_addh_sc_tile_1/ctrl_sign 0
C605 5v0_addh_sc_tile_1/nti 5v0_addh_sc_tile_2/5v0_half_adder_selector_sc_0/res_stage0 0
C606 5v0_addh_sc_tile_1/nti 5v0_addh_sc_tile_1/5v0_half_adder_selector_sc_0/res_stage0 0.00372f
C607 5v0_addh_sc_tile_0/m1_103_293# 5v0_addh_sc_tile_1/ctrl_sign 0.00101f
C608 5v0_add_q_sc_0/a_n1205_n937# 5v0_add_q_sc_0/downstepper_test 0.00453f
C609 5v0_addh_sc_tile_2/ctrl_sign 5v0_addh_sc_tile_1/inv_nti 0.00386f
C610 5v0_addh_sc_tile_2/nti 5v0_addh_sc_tile_2/pti 0.24563f
C611 5v0_add_q_sc_0/upstepper_test VDD_3V3_1 0
C612 res_01 5v0_add_q_sc_0/ctrl_over 0
C613 res_01 5v0_addh_sc_tile_2/a_382_n1095# 0
C614 5v0_addh_sc_tile_1/5v0_half_adder_selector_sc_0/5v0_tgate_sel_2_sc_1/input_A VDD_3V3_0 0.02871f
C615 m1_n2844_n810# 5v0_addh_sc_tile_1/m1_103_293# 0
C616 5v0_addh_sc_tile_0/upstepper_test 5v0_addh_sc_tile_0/downstepper_test 0.38867f
C617 5v0_addh_sc_tile_0/nti 5v0_addh_sc_tile_1/ctrl_sign 0
C618 5v0_add_q_sc_0/a_n1205_n937# 5v0_add_q_sc_0/inv_nti 0
C619 5v0_addh_sc_tile_1/upstepper_test VDD_1V65_3 0.16859f
C620 5v0_addh_sc_tile_0/pti VDD_1V65_2 0
C621 5v0_addh_sc_tile_2/ctrl_sign 5v0_addh_sc_tile_1/pti 0
C622 c01 in_0_over 0.00413f
C623 int_carry VDD_3V3_1 0.20806f
C624 res_0 5v0_addh_sc_tile_2/ctrl_over 0.20137f
C625 5v0_add_q_sc_1/inv_nti 5v0_add_q_sc_1/upstepper_test 0.0011f
C626 5v0_addh_sc_tile_1/a_382_n1095# 5v0_add_q_sc_1/nti 0
C627 5v0_addh_sc_tile_0/m1_103_293# VDD_3V3_1 0.73472f
C628 res_01 c_2_o 0.00136f
C629 5v0_addh_sc_tile_0/m1_103_293# in_1 0
C630 5v0_add_q_sc_1/upstepper_test c_2_o 0.00943f
C631 5v0_add_q_sc_1/5v0_half_adder_selector_sc_0/m1_n239_179# c_2_o 0.00258f
C632 5v0_add_q_sc_1/inv_nti int_c01 0.02537f
C633 5v0_addh_sc_tile_0/nti VDD_3V3_1 0.74269f
C634 5v0_addh_sc_tile_1/nti 5v0_addh_sc_tile_0/m1_843_n857# 0
C635 res_01 5v0_addh_sc_tile_1/ctrl_sign 0.17378f
C636 5v0_addh_sc_tile_0/m1_103_293# 5v0_addh_sc_tile_0/inv_nti 0.35313f
C637 m1_n2844_n810# 5v0_addh_sc_tile_0/a_382_n1095# 0.04008f
C638 5v0_addh_sc_tile_0/nti in_1 0.52138f
C639 5v0_addh_sc_tile_2/5v0_half_adder_selector_sc_0/res_stage0 5v0_addh_sc_tile_2/pti 0.00979f
C640 5v0_nter2oter_code_sc_0/pti 5v0_addh_sc_tile_0/downstepper_test 0.0027f
C641 c_2_o int_c01 0.24448f
C642 5v0_addh_sc_tile_1/upstepper_test c_2_s 0
C643 5v0_add_q_sc_1/inv_pti 5v0_add_q_sc_1/inv_nti 0.08256f
C644 5v0_addh_sc_tile_0/nti 5v0_addh_sc_tile_0/inv_nti 0.22786f
C645 5v0_add_q_sc_1/pti 5v0_add_q_sc_1/upstepper_test 0
C646 c01 c01over 0.05948f
C647 5v0_addh_sc_tile_2/pti in_3 0.66373f
C648 int_c01 5v0_addh_sc_tile_1/ctrl_sign 0
C649 5v0_add_q_sc_1/inv_pti c_2_o 0.0024f
C650 m1_n2844_n810# 5v0_addh_sc_tile_0/pti 0.00644f
C651 5v0_addh_sc_tile_1/ctrl_over in_0_over 0
C652 5v0_addh_sc_tile_2/m1_103_293# 5v0_addh_sc_tile_2/inv_nti 0.35313f
C653 5v0_addh_sc_tile_1/ctrl_over VDD_3V3_0 1.20698f
C654 5v0_addh_sc_tile_1/downstepper_test 5v0_add_q_sc_0/ctrl_sign 0.00426f
C655 res_01 VDD_3V3_1 1.22329f
C656 5v0_add_q_sc_1/upstepper_test VDD_3V3_1 0.46215f
C657 5v0_add_q_sc_0/inv_pti 5v0_add_q_sc_0/downstepper_test 0.07797f
C658 5v0_addh_sc_tile_1/nti in_0_over 0.00205f
C659 5v0_addh_sc_tile_1/a_382_n1095# 5v0_addh_sc_tile_1/m1_843_n857# 0.05013f
C660 res_01 in_1 0.18462f
C661 5v0_add_q_sc_1/5v0_half_adder_selector_sc_0/m1_n239_179# VDD_3V3_1 0.29031f
C662 5v0_add_q_sc_1/pti int_c01 0.54174f
C663 5v0_addh_sc_tile_1/ctrl_over VDD_1V65_0 0
C664 5v0_addh_sc_tile_1/nti VDD_3V3_0 0.44319f
C665 5v0_addh_sc_tile_0/a_382_n1095# 5v0_addh_sc_tile_0/5v0_half_adder_selector_sc_0/res_stage0 0.08951f
C666 5v0_add_q_sc_0/inv_pti 5v0_add_q_sc_0/inv_nti 0.08256f
C667 5v0_addh_sc_tile_1/inv_pti 5v0_addh_sc_tile_2/inv_pti 0
C668 5v0_addh_sc_tile_1/a_n1205_n937# 5v0_addh_sc_tile_1/ctrl_over 0.00169f
C669 res_01 5v0_addh_sc_tile_0/inv_nti 0.0179f
C670 5v0_add_q_sc_1/inv_pti 5v0_add_q_sc_1/pti 0.19726f
C671 5v0_addh_sc_tile_0/m1_103_293# 5v0_addh_sc_tile_0/inv_pti 0.17653f
C672 5v0_add_q_sc_0/5v0_half_adder_selector_sc_0/m1_n239_179# 5v0_add_q_sc_0/downstepper_test 0.09961f
C673 VDD_3V3_1 int_c01 1.23205f
C674 5v0_addh_sc_tile_1/a_n1205_n937# 5v0_addh_sc_tile_1/nti 0
C675 c01 5v0_add_q_sc_1/nti 0
C676 5v0_addh_sc_tile_1/downstepper_test 5v0_addh_sc_tile_1/upstepper_test 0.38867f
C677 res_01 5v0_addh_sc_tile_2/5v0_half_adder_selector_sc_0/res_stage0 0
C678 5v0_addh_sc_tile_0/pti 5v0_addh_sc_tile_0/5v0_half_adder_selector_sc_0/res_stage0 0.01078f
C679 5v0_addh_sc_tile_0/nti 5v0_addh_sc_tile_0/inv_pti 0.24025f
C680 5v0_addh_sc_tile_1/ctrl_over 5v0_addh_sc_tile_2/upstepper_test 0
C681 5v0_addh_sc_tile_1/ctrl_over c01over 0
C682 res_01 5v0_addh_sc_tile_1/5v0_half_adder_selector_sc_0/res_stage0 0.26626f
C683 5v0_addh_sc_tile_0/m1_103_293# 5v0_addh_sc_tile_0/m1_843_n857# 0.20659f
C684 5v0_add_q_sc_1/inv_pti VDD_3V3_1 0.40305f
C685 int_012 5v0_addh_sc_tile_2/inv_pti 0.00498f
C686 5v0_addh_sc_tile_0/inv_nti int_c01 0
C687 5v0_add_q_sc_0/ctrl_over 5v0_addh_sc_tile_2/a_382_n1095# 0.06871f
C688 5v0_addh_sc_tile_0/a_n1205_n937# VDD_3V3_1 0.00891f
C689 5v0_nter2oter_code_sc_0/gf180mcu_fd_sc_mcu7t5v0__nor2_1_0/a_224_472# 5v0_nter2oter_code_sc_0/nti 0.00842f
C690 5v0_add_q_sc_0/inv_pti 5v0_add_q_sc_0/ctrl_sign 0.00263f
C691 5v0_add_q_sc_0/5v0_half_adder_selector_sc_0/m1_n244_n517# 5v0_add_q_sc_0/downstepper_test 0.00507f
C692 5v0_addh_sc_tile_1/inv_pti 5v0_addh_sc_tile_1/a_382_n1095# 0.00129f
C693 5v0_addh_sc_tile_1/nti c01over 0.013f
C694 5v0_addh_sc_tile_1/nti 5v0_addh_sc_tile_2/upstepper_test 0.00102f
C695 5v0_addh_sc_tile_0/a_382_n1095# 5v0_addh_sc_tile_0/downstepper_test 0.00679f
C696 5v0_add_q_sc_0/nti 5v0_add_q_sc_0/downstepper_test 0.07205f
C697 5v0_add_q_sc_0/upstepper_test VDD_3V3_0 0.55779f
C698 5v0_nter2oter_code_sc_1/nti 5v0_nter2oter_code_sc_1/pti 0.00234f
C699 5v0_add_q_sc_0/a_n1205_n937# VDD_1V65_5 0.00354f
C700 5v0_add_q_sc_0/inv_pti 5v0_add_q_sc_0/pti 0.19726f
C701 5v0_addh_sc_tile_1/ctrl_over 5v0_addh_sc_tile_2/ctrl_over 0.02247f
C702 5v0_addh_sc_tile_0/a_n1205_n937# 5v0_addh_sc_tile_0/inv_nti 0
C703 5v0_addh_sc_tile_1/a_n1373_n454# 5v0_addh_sc_tile_1/nti 0
C704 VDD_1V65_1 5v0_add_q_sc_1/upstepper_test 0.16859f
C705 5v0_add_q_sc_0/nti 5v0_add_q_sc_0/inv_nti 0.20874f
C706 5v0_add_q_sc_0/5v0_half_adder_selector_sc_0/m1_n239_179# 5v0_add_q_sc_0/ctrl_sign 0.307f
C707 5v0_addh_sc_tile_2/ctrl_sign VDD_1V65_3 0
C708 5v0_addh_sc_tile_1/nti 5v0_addh_sc_tile_2/ctrl_over 0.00207f
C709 5v0_addh_sc_tile_1/a_382_n1095# int_012 0.16245f
C710 VDD_3V3_0 5v0_addh_sc_tile_2/pti 0.713f
C711 int_carry VDD_3V3_0 1.5908f
C712 5v0_addh_sc_tile_0/pti 5v0_addh_sc_tile_0/downstepper_test 0.20149f
C713 5v0_addh_sc_tile_0/upstepper_test 5v0_addh_sc_tile_0/pti 0.02426f
C714 5v0_addh_sc_tile_2/m1_103_293# 5v0_addh_sc_tile_2/downstepper_test 0.0934f
C715 5v0_addh_sc_tile_0/m1_103_293# in_0_over 0.02633f
C716 5v0_addh_sc_tile_1/ctrl_over 5v0_add_q_sc_1/nti 0
C717 5v0_nter2oter_code_sc_1/nti 5v0_addh_sc_tile_2/ctrl_sign 0.01527f
C718 5v0_addh_sc_tile_0/a_n1373_n454# VDD_3V3_1 0.00122f
C719 5v0_addh_sc_tile_2/inv_pti 5v0_addh_sc_tile_1/inv_nti 0
C720 5v0_add_q_sc_0/a_n1373_n454# 5v0_add_q_sc_0/downstepper_test 0.00442f
C721 5v0_add_q_sc_0/5v0_half_adder_selector_sc_0/m1_n244_n517# 5v0_add_q_sc_0/ctrl_sign 0
C722 5v0_add_q_sc_1/inv_nti c_2_o 0.00311f
C723 VDD_1V65_1 int_c01 0.03394f
C724 5v0_addh_sc_tile_0/a_n1373_n454# in_1 0.00163f
C725 res_01 5v0_addh_sc_tile_0/m1_843_n857# 0
C726 5v0_addh_sc_tile_2/downstepper_test 5v0_addh_sc_tile_2/inv_nti 0.29987f
C727 5v0_addh_sc_tile_0/nti in_0_over 0.00162f
C728 5v0_addh_sc_tile_0/nti VDD_3V3_0 0
C729 5v0_add_q_sc_0/nti 5v0_add_q_sc_0/ctrl_sign 0
C730 5v0_add_q_sc_0/5v0_half_adder_selector_sc_0/res_stage0 VDD_3V3_0 0.16909f
C731 5v0_addh_sc_tile_0/inv_pti int_c01 0.00636f
C732 5v0_add_q_sc_0/a_n1373_n454# 5v0_add_q_sc_0/inv_nti 0
C733 5v0_addh_sc_tile_2/nti 5v0_add_q_sc_0/ctrl_over 0
C734 5v0_addh_sc_tile_0/a_n1373_n454# 5v0_addh_sc_tile_0/inv_nti 0
C735 5v0_add_q_sc_1/inv_nti 5v0_addh_sc_tile_1/ctrl_sign 0
C736 5v0_add_q_sc_1/inv_pti VDD_1V65_1 0.14775f
C737 5v0_addh_sc_tile_2/nti 5v0_addh_sc_tile_2/a_382_n1095# 0
C738 5v0_addh_sc_tile_0/nti VDD_1V65_0 0.21326f
C739 5v0_addh_sc_tile_2/inv_pti 5v0_addh_sc_tile_1/pti 0
C740 5v0_add_q_sc_0/nti 5v0_add_q_sc_0/pti 0.1782f
C741 5v0_addh_sc_tile_1/a_n1778_n454# 5v0_addh_sc_tile_1/nti 0.00142f
C742 5v0_addh_sc_tile_2/upstepper_test 5v0_addh_sc_tile_2/pti 0.02426f
C743 c01 in_0_sign 0.24834f
C744 in_2 5v0_addh_sc_tile_0/upstepper_test 0
C745 in_2 5v0_addh_sc_tile_0/downstepper_test 0.0129f
C746 5v0_add_q_sc_0/upstepper_test 5v0_addh_sc_tile_2/ctrl_over 0.00252f
C747 5v0_addh_sc_tile_1/a_382_n1095# 5v0_addh_sc_tile_1/inv_nti 0.28394f
C748 c_2_o 5v0_addh_sc_tile_1/ctrl_sign 0.01552f
C749 5v0_add_q_sc_1/inv_nti 5v0_add_q_sc_1/pti 0.10916f
C750 res_c VDD_3V3_0 0.09697f
C751 5v0_addh_sc_tile_0/m1_103_293# c01over 0.01488f
C752 5v0_addh_sc_tile_2/ctrl_over 5v0_addh_sc_tile_2/pti 0.16185f
C753 5v0_addh_sc_tile_0/a_n1778_n454# in_1 0.00182f
C754 res_01 in_0_over 0.21152f
C755 5v0_add_q_sc_1/pti c_2_o 0
C756 res_01 VDD_3V3_0 0.0901f
C757 int_carry 5v0_addh_sc_tile_2/ctrl_over 0.00714f
C758 5v0_addh_sc_tile_2/inv_nti VDD_1V65_4 0.08611f
C759 5v0_addh_sc_tile_1/a_382_n1095# 5v0_addh_sc_tile_1/pti 0.12627f
C760 5v0_add_q_sc_1/inv_nti VDD_3V3_1 0.56275f
C761 5v0_addh_sc_tile_0/nti c01over 0
C762 5v0_add_q_sc_0/a_n1373_n454# 5v0_add_q_sc_0/pti 0
C763 5v0_add_q_sc_0/inv_pti VDD_1V65_5 0.14775f
C764 5v0_addh_sc_tile_1/ctrl_over 5v0_addh_sc_tile_1/m1_843_n857# 0.10251f
C765 5v0_add_q_sc_1/pti 5v0_addh_sc_tile_1/ctrl_sign 0
C766 5v0_addh_sc_tile_0/a_n1778_n454# 5v0_addh_sc_tile_0/inv_nti 0.00226f
C767 5v0_addh_sc_tile_2/nti 5v0_addh_sc_tile_1/ctrl_sign 0
C768 VDD_3V3_1 c_2_o 0.6465f
C769 5v0_add_q_sc_0/ctrl_over 5v0_addh_sc_tile_2/5v0_half_adder_selector_sc_0/res_stage0 0
C770 5v0_add_q_sc_1/inv_nti 5v0_addh_sc_tile_0/inv_nti 0
C771 5v0_addh_sc_tile_2/5v0_half_adder_selector_sc_0/res_stage0 5v0_addh_sc_tile_2/a_382_n1095# 0.08951f
C772 5v0_add_q_sc_0/5v0_half_adder_selector_sc_0/res_stage0 5v0_addh_sc_tile_2/ctrl_over 0.00474f
C773 5v0_addh_sc_tile_1/5v0_half_adder_selector_sc_0/res_stage0 5v0_addh_sc_tile_2/a_382_n1095# 0
C774 5v0_addh_sc_tile_0/a_n1373_n454# 5v0_addh_sc_tile_0/inv_pti 0.00135f
C775 int_carry 5v0_add_q_sc_1/nti 0
C776 5v0_nter2oter_code_sc_0/pti in_2 0.00216f
C777 5v0_addh_sc_tile_2/ctrl_sign 5v0_addh_sc_tile_1/downstepper_test 0.00468f
C778 VDD_3V3_1 5v0_addh_sc_tile_1/ctrl_sign 0.87932f
C779 5v0_add_q_sc_0/ctrl_over in_3 0.00136f
C780 5v0_nter2oter_code_sc_0/gf180mcu_fd_sc_mcu7t5v0__nor2_1_0/a_224_472# 5v0_addh_sc_tile_2/ctrl_sign 0
C781 5v0_addh_sc_tile_1/upstepper_test m1_n2844_n810# 0.00447f
C782 in_1 5v0_addh_sc_tile_1/ctrl_sign 0.01394f
C783 in_3 5v0_addh_sc_tile_2/a_382_n1095# 0.09307f
C784 5v0_addh_sc_tile_0/a_n1205_n937# in_0_over 0
C785 res_01 5v0_addh_sc_tile_2/upstepper_test 0
C786 5v0_addh_sc_tile_1/nti in_0_sign 0
C787 res_01 c01over 0.00236f
C788 res_c 5v0_addh_sc_tile_2/ctrl_over 0.00127f
C789 5v0_add_q_sc_1/pti VDD_3V3_1 0.56896f
C790 5v0_addh_sc_tile_0/inv_nti 5v0_addh_sc_tile_1/ctrl_sign 0.02895f
C791 5v0_addh_sc_tile_1/inv_pti 5v0_addh_sc_tile_1/ctrl_over 0.0052f
C792 5v0_addh_sc_tile_0/a_n1205_n937# VDD_1V65_0 0.00354f
C793 c_2_o 5v0_addh_sc_tile_1/5v0_half_adder_selector_sc_0/res_stage0 0
C794 5v0_add_q_sc_0/nti VDD_1V65_5 0.21326f
C795 5v0_addh_sc_tile_1/a_n1373_n454# res_01 0.00163f
C796 5v0_addh_sc_tile_1/inv_pti 5v0_addh_sc_tile_1/nti 0.23171f
C797 res_01 5v0_addh_sc_tile_2/ctrl_over 0.00181f
C798 5v0_add_q_sc_0/a_n1778_n454# 5v0_add_q_sc_0/downstepper_test 0.0031f
C799 5v0_add_q_sc_0/upstepper_test 5v0_addh_sc_tile_1/m1_843_n857# 0.0015f
C800 5v0_add_q_sc_1/inv_nti VDD_1V65_1 0.01114f
C801 c01over int_c01 0.23208f
C802 5v0_addh_sc_tile_1/5v0_half_adder_selector_sc_0/res_stage0 5v0_addh_sc_tile_1/ctrl_sign 0.22639f
C803 5v0_addh_sc_tile_0/pti 5v0_addh_sc_tile_0/a_382_n1095# 0.12627f
C804 VDD_3V3_1 in_1 1.00116f
C805 5v0_addh_sc_tile_2/m1_843_n857# 5v0_addh_sc_tile_2/m1_103_293# 0.20659f
C806 5v0_addh_sc_tile_1/ctrl_over int_012 0.27048f
C807 5v0_add_q_sc_1/upstepper_test 5v0_add_q_sc_1/a_n1778_n454# 0
C808 5v0_add_q_sc_0/a_n1778_n454# 5v0_add_q_sc_0/inv_nti 0.00214f
C809 in_3 5v0_addh_sc_tile_1/ctrl_sign 0
C810 5v0_addh_sc_tile_2/nti 5v0_addh_sc_tile_2/5v0_half_adder_selector_sc_0/res_stage0 0.00372f
C811 VDD_1V65_1 c_2_o 0.04751f
C812 VDD_3V3_1 5v0_addh_sc_tile_0/inv_nti 0.85215f
C813 5v0_addh_sc_tile_1/nti int_012 0.0044f
C814 int_carry 5v0_addh_sc_tile_1/m1_843_n857# 0.00836f
C815 5v0_addh_sc_tile_2/downstepper_test VDD_1V65_4 0.13024f
C816 5v0_addh_sc_tile_2/m1_843_n857# 5v0_addh_sc_tile_2/inv_nti 0.36668f
C817 5v0_addh_sc_tile_0/inv_nti in_1 0.28245f
C818 5v0_add_q_sc_0/downstepper_test 5v0_addh_sc_tile_2/inv_nti 0
C819 5v0_add_q_sc_1/upstepper_test 5v0_add_q_sc_1/nti 0.11962f
C820 5v0_add_q_sc_0/a_n1373_n454# VDD_1V65_5 0.00232f
C821 5v0_addh_sc_tile_0/a_n1373_n454# VDD_1V65_0 0.00232f
C822 int_c01 5v0_add_q_sc_1/a_n1778_n454# 0.00116f
C823 5v0_addh_sc_tile_2/nti in_3 0.52138f
C824 5v0_addh_sc_tile_1/a_n1778_n454# res_01 0.00182f
C825 VDD_3V3_1 5v0_addh_sc_tile_1/5v0_half_adder_selector_sc_0/res_stage0 0.01812f
C826 VDD_1V65_1 5v0_add_q_sc_1/pti 0.00115f
C827 5v0_add_q_sc_1/nti int_c01 0.68929f
C828 5v0_nter2oter_code_sc_1/nti 5v0_addh_sc_tile_2/inv_pti 0
C829 5v0_add_q_sc_0/a_n1778_n454# 5v0_add_q_sc_0/pti 0.00135f
C830 5v0_addh_sc_tile_2/m1_103_293# 5v0_add_q_sc_0/ctrl_sign 0.21173f
C831 5v0_addh_sc_tile_0/m1_103_293# in_0_sign 0.60072f
C832 5v0_add_q_sc_0/ctrl_over VDD_3V3_0 0.91135f
C833 5v0_addh_sc_tile_1/ctrl_over 5v0_addh_sc_tile_1/inv_nti 0.47006f
C834 5v0_addh_sc_tile_0/m1_843_n857# 5v0_addh_sc_tile_1/ctrl_sign 0
C835 VDD_3V3_0 5v0_addh_sc_tile_2/a_382_n1095# 0.66129f
C836 5v0_addh_sc_tile_1/inv_pti 5v0_addh_sc_tile_2/pti 0
C837 5v0_add_q_sc_1/inv_pti 5v0_add_q_sc_1/nti 0.21255f
C838 int_carry 5v0_addh_sc_tile_1/inv_pti 0.00157f
C839 5v0_addh_sc_tile_1/nti 5v0_addh_sc_tile_1/inv_nti 0.22702f
C840 VDD_1V65_1 VDD_3V3_1 0.0427f
C841 5v0_add_q_sc_0/downstepper_test 5v0_addh_sc_tile_1/m1_103_293# 0
C842 in_2 5v0_addh_sc_tile_0/pti 0
C843 5v0_add_q_sc_0/ctrl_sign 5v0_addh_sc_tile_2/inv_nti 0.12058f
C844 5v0_addh_sc_tile_0/nti in_0_sign 0
C845 5v0_add_q_sc_1/inv_nti in_0_over 0.00113f
C846 5v0_addh_sc_tile_1/inv_pti 5v0_addh_sc_tile_0/m1_103_293# 0.00205f
C847 5v0_addh_sc_tile_0/a_n1778_n454# VDD_1V65_0 0
C848 5v0_addh_sc_tile_1/ctrl_over 5v0_addh_sc_tile_1/pti 0.11567f
C849 VDD_3V3_1 5v0_addh_sc_tile_0/inv_pti 1.0512f
C850 res_01 5v0_addh_sc_tile_1/m1_843_n857# 0
C851 5v0_addh_sc_tile_0/inv_pti in_1 0.05631f
C852 int_012 5v0_addh_sc_tile_2/pti 0.00286f
C853 5v0_addh_sc_tile_2/5v0_half_adder_selector_sc_0/res_stage0 in_3 0.26626f
C854 c_2_o VDD_3V3_0 0.33124f
C855 5v0_addh_sc_tile_1/nti 5v0_addh_sc_tile_1/pti 0.24193f
C856 5v0_addh_sc_tile_0/inv_pti 5v0_addh_sc_tile_0/inv_nti 0.25737f
C857 VDD_3V3_1 5v0_addh_sc_tile_0/m1_843_n857# 0.22222f
C858 in_1 5v0_addh_sc_tile_0/m1_843_n857# 0
C859 in_0_over 5v0_addh_sc_tile_1/ctrl_sign 0.03467f
C860 VDD_3V3_0 5v0_addh_sc_tile_1/ctrl_sign 0.42962f
C861 5v0_add_q_sc_1/downstepper_test 5v0_addh_sc_tile_1/a_382_n1095# 0.00433f
C862 res_01 in_0_sign 0
C863 5v0_addh_sc_tile_1/a_382_n1095# c_2_s 0.00155f
C864 VDD_1V65_0 5v0_addh_sc_tile_1/ctrl_sign 0
C865 5v0_addh_sc_tile_0/nti int_012 0.0033f
C866 5v0_addh_sc_tile_0/inv_nti 5v0_addh_sc_tile_0/m1_843_n857# 0.36668f
C867 5v0_add_q_sc_0/upstepper_test 5v0_addh_sc_tile_1/inv_nti 0.00109f
C868 5v0_nter2oter_code_sc_0/pti 5v0_nter2oter_code_sc_0/nti 0.00234f
C869 5v0_add_q_sc_1/inv_nti c01over 0.00204f
C870 5v0_add_q_sc_0/ctrl_over 5v0_addh_sc_tile_2/ctrl_over 0.15107f
C871 5v0_addh_sc_tile_2/nti VDD_3V3_0 0.7527f
C872 5v0_addh_sc_tile_2/ctrl_over 5v0_addh_sc_tile_2/a_382_n1095# 0.69037f
C873 5v0_add_q_sc_1/inv_pti 5v0_addh_sc_tile_1/m1_843_n857# 0
C874 5v0_addh_sc_tile_1/inv_pti res_01 0.05503f
C875 5v0_addh_sc_tile_1/inv_nti 5v0_addh_sc_tile_2/pti 0
C876 c01over c_2_o 0
C877 int_c01 in_0_sign 0
C878 VDD_3V3_1 in_0_over 0.64118f
C879 5v0_add_q_sc_0/upstepper_test 5v0_addh_sc_tile_1/pti 0.0029f
C880 5v0_addh_sc_tile_1/downstepper_test 5v0_addh_sc_tile_2/inv_pti 0.01675f
C881 int_carry 5v0_addh_sc_tile_1/inv_nti 0.0263f
C882 VDD_3V3_1 VDD_3V3_0 0.00215f
C883 in_0_over in_1 0.13684f
C884 5v0_add_q_sc_0/a_n1778_n454# VDD_1V65_5 0
C885 5v0_addh_sc_tile_1/upstepper_test 5v0_addh_sc_tile_1/m1_103_293# 0.07773f
C886 c01over 5v0_addh_sc_tile_1/ctrl_sign 0.02298f
C887 VDD_3V3_1 VDD_1V65_0 0.04264f
C888 5v0_add_q_sc_1/inv_nti 5v0_add_q_sc_1/a_n1778_n454# 0.00214f
C889 5v0_addh_sc_tile_1/inv_pti int_c01 0.00686f
C890 res_01 int_012 0.17192f
C891 5v0_add_q_sc_1/5v0_half_adder_selector_sc_0/res_stage0 5v0_add_q_sc_1/5v0_half_adder_selector_sc_0/5v0_tgate_sel_2_sc_1/input_A 0.00253f
C892 VDD_1V65_0 in_1 0.01451f
C893 5v0_addh_sc_tile_0/inv_nti in_0_over 0.21462f
C894 5v0_addh_sc_tile_2/pti 5v0_addh_sc_tile_1/pti 0
C895 5v0_addh_sc_tile_2/downstepper_test 5v0_add_q_sc_0/ctrl_sign 0
C896 int_carry 5v0_addh_sc_tile_1/pti 0
C897 5v0_add_q_sc_1/pti c01over 0
C898 5v0_addh_sc_tile_2/nti 5v0_addh_sc_tile_2/upstepper_test 0.11981f
C899 5v0_addh_sc_tile_2/5v0_half_adder_selector_sc_0/5v0_tgate_sel_2_sc_1/input_A 5v0_addh_sc_tile_2/downstepper_test 0
C900 5v0_add_q_sc_1/inv_nti 5v0_add_q_sc_1/nti 0.20056f
C901 5v0_addh_sc_tile_2/ctrl_over 5v0_addh_sc_tile_1/ctrl_sign 0
C902 5v0_addh_sc_tile_0/inv_nti VDD_1V65_0 0.08611f
C903 5v0_addh_sc_tile_0/m1_103_293# 5v0_addh_sc_tile_1/pti 0.00135f
C904 5v0_nter2oter_code_sc_1/pti 5v0_addh_sc_tile_0/downstepper_test 0.00775f
C905 5v0_addh_sc_tile_1/downstepper_test 5v0_addh_sc_tile_1/a_382_n1095# 0.00679f
C906 5v0_addh_sc_tile_2/5v0_half_adder_selector_sc_0/res_stage0 VDD_3V3_0 0.16541f
C907 5v0_addh_sc_tile_0/inv_pti 5v0_addh_sc_tile_0/m1_843_n857# 0
C908 in_0_over 5v0_addh_sc_tile_1/5v0_half_adder_selector_sc_0/res_stage0 0
C909 5v0_addh_sc_tile_1/5v0_half_adder_selector_sc_0/res_stage0 VDD_3V3_0 0.11354f
C910 5v0_add_q_sc_1/nti c_2_o 0.00725f
C911 5v0_addh_sc_tile_2/nti 5v0_addh_sc_tile_2/ctrl_over 0.007f
C912 c01over VDD_3V3_1 0.82164f
C913 VDD_3V3_1 5v0_addh_sc_tile_0/5v0_half_adder_selector_sc_0/5v0_tgate_sel_2_sc_1/input_A 0.02871f
C914 5v0_addh_sc_tile_1/upstepper_test 5v0_addh_sc_tile_0/a_382_n1095# 0.00208f
C915 c01over in_1 0.00136f
C916 VDD_3V3_0 in_3 1.10285f
C917 5v0_add_q_sc_1/pti 5v0_add_q_sc_1/a_n1778_n454# 0.00135f
C918 5v0_add_q_sc_0/5v0_half_adder_selector_sc_0/m1_n244_n517# 5v0_add_q_sc_0/5v0_half_adder_selector_sc_0/5v0_tgate_sel_2_sc_1/input_A 0.02928f
C919 5v0_add_q_sc_1/nti 5v0_addh_sc_tile_1/ctrl_sign 0.00138f
C920 5v0_add_q_sc_1/downstepper_test 5v0_add_q_sc_1/5v0_half_adder_selector_sc_0/5v0_tgate_sel_2_sc_1/input_A 0
C921 5v0_addh_sc_tile_1/a_n1205_n937# 5v0_addh_sc_tile_1/5v0_half_adder_selector_sc_0/res_stage0 0
C922 res_01 5v0_addh_sc_tile_1/inv_nti 0.28104f
C923 c01 c_2_s 0.00205f
C924 c01over 5v0_addh_sc_tile_0/inv_nti 0.03007f
C925 5v0_addh_sc_tile_2/ctrl_sign 5v0_nter2oter_code_sc_1/gf180mcu_fd_sc_mcu7t5v0__nor2_1_0/a_224_472# 0.00629f
C926 VDD_3V3_1 5v0_addh_sc_tile_2/ctrl_over 0.00186f
C927 c_2_s 5v0_add_q_sc_1/5v0_half_adder_selector_sc_0/5v0_tgate_sel_2_sc_1/input_A 0
C928 5v0_add_q_sc_1/pti 5v0_add_q_sc_1/nti 0.15563f
C929 5v0_add_q_sc_0/5v0_half_adder_selector_sc_0/m1_n239_179# 5v0_addh_sc_tile_2/inv_pti 0.00128f
C930 5v0_nter2oter_code_sc_1/pti 5v0_addh_sc_tile_2/inv_nti 0
C931 5v0_addh_sc_tile_1/ctrl_over VDD_1V65_3 0.02438f
C932 5v0_add_q_sc_0/inv_pti 5v0_addh_sc_tile_1/a_382_n1095# 0
C933 5v0_addh_sc_tile_0/inv_pti in_0_over 0
C934 5v0_addh_sc_tile_2/5v0_half_adder_selector_sc_0/res_stage0 5v0_addh_sc_tile_2/upstepper_test 0.27475f
C935 5v0_nter2oter_code_sc_0/pti 5v0_nter2oter_code_sc_1/pti 0.20957f
C936 5v0_addh_sc_tile_1/nti VDD_1V65_3 0.21326f
C937 res_01 5v0_addh_sc_tile_1/pti 0.67368f
C938 c01over 5v0_addh_sc_tile_1/5v0_half_adder_selector_sc_0/res_stage0 0.00121f
C939 int_c01 5v0_addh_sc_tile_1/inv_nti 0
C940 5v0_addh_sc_tile_2/ctrl_sign 5v0_addh_sc_tile_2/m1_103_293# 0.61512f
C941 5v0_addh_sc_tile_0/inv_pti VDD_1V65_0 0.14775f
C942 5v0_add_q_sc_1/nti VDD_3V3_1 0.5318f
C943 5v0_nter2oter_code_sc_1/nti 5v0_addh_sc_tile_1/ctrl_over 0.2759f
C944 in_0_over 5v0_addh_sc_tile_0/m1_843_n857# 0.09998f
C945 5v0_addh_sc_tile_2/upstepper_test in_3 0.01604f
C946 5v0_addh_sc_tile_1/downstepper_test 5v0_addh_sc_tile_1/5v0_half_adder_selector_sc_0/5v0_tgate_sel_2_sc_1/input_A 0
C947 5v0_nter2oter_code_sc_1/nti 5v0_addh_sc_tile_1/nti 0.20212f
C948 5v0_addh_sc_tile_2/5v0_half_adder_selector_sc_0/res_stage0 5v0_addh_sc_tile_2/ctrl_over 0.09179f
C949 5v0_add_q_sc_0/5v0_half_adder_selector_sc_0/m1_n239_179# 5v0_addh_sc_tile_1/a_382_n1095# 0.0035f
C950 5v0_addh_sc_tile_2/inv_nti 5v0_addh_sc_tile_2/a_n1205_n937# 0
C951 5v0_addh_sc_tile_2/ctrl_sign 5v0_addh_sc_tile_2/inv_nti 0.24905f
C952 c_2_o 5v0_addh_sc_tile_1/m1_843_n857# 0.18406f
C953 5v0_addh_sc_tile_1/5v0_half_adder_selector_sc_0/res_stage0 5v0_addh_sc_tile_2/ctrl_over 0.00478f
C954 5v0_addh_sc_tile_2/ctrl_sign 5v0_nter2oter_code_sc_0/pti 0.23385f
C955 5v0_addh_sc_tile_1/inv_pti 5v0_addh_sc_tile_2/a_382_n1095# 0
C956 5v0_addh_sc_tile_2/ctrl_over in_3 0.1551f
C957 5v0_addh_sc_tile_1/m1_843_n857# 5v0_addh_sc_tile_1/ctrl_sign 0.24363f
C958 5v0_addh_sc_tile_1/ctrl_over c_2_s 0
C959 5v0_add_q_sc_0/5v0_half_adder_selector_sc_0/m1_n244_n517# 5v0_addh_sc_tile_1/a_382_n1095# 0
C960 5v0_add_q_sc_0/downstepper_test 5v0_add_q_sc_0/inv_nti 0.1819f
C961 c01over 5v0_addh_sc_tile_0/inv_pti 0.0146f
C962 in_2 5v0_nter2oter_code_sc_0/nti 0
C963 5v0_add_q_sc_0/nti 5v0_addh_sc_tile_1/a_382_n1095# 0
C964 5v0_addh_sc_tile_1/inv_pti 5v0_add_q_sc_1/inv_nti 0.00455f
C965 in_0_over VDD_3V3_0 0
C966 c01over 5v0_addh_sc_tile_0/m1_843_n857# 0.18378f
C967 int_012 5v0_addh_sc_tile_2/a_382_n1095# 0
C968 in_0_sign 5v0_addh_sc_tile_1/ctrl_sign 0
C969 VDD_1V65_1 5v0_add_q_sc_1/a_n1778_n454# 0
C970 5v0_addh_sc_tile_1/inv_pti c_2_o 0.01474f
C971 5v0_addh_sc_tile_2/inv_nti 5v0_addh_sc_tile_2/a_n1373_n454# 0
C972 5v0_addh_sc_tile_2/m1_843_n857# 5v0_add_q_sc_0/ctrl_sign 0.00871f
C973 VDD_1V65_0 in_0_over 0.00145f
C974 int_carry 5v0_add_q_sc_1/5v0_half_adder_selector_sc_0/res_stage0 0.17113f
C975 VDD_3V3_1 5v0_addh_sc_tile_1/m1_843_n857# 0.00388f
C976 5v0_add_q_sc_0/ctrl_sign 5v0_add_q_sc_0/downstepper_test 0.14564f
C977 VDD_1V65_1 5v0_add_q_sc_1/nti 0.21326f
C978 5v0_addh_sc_tile_1/a_n1205_n937# VDD_3V3_0 0.00891f
C979 5v0_addh_sc_tile_1/inv_pti 5v0_addh_sc_tile_1/ctrl_sign 0.41772f
C980 5v0_addh_sc_tile_2/downstepper_test 5v0_nter2oter_code_sc_1/pti 0
C981 5v0_add_q_sc_0/downstepper_test 5v0_add_q_sc_0/pti 0.0825f
C982 5v0_nter2oter_code_sc_1/nti 5v0_addh_sc_tile_2/pti 0
C983 5v0_add_q_sc_1/nti 5v0_addh_sc_tile_0/inv_pti 0
C984 c_2_o int_012 0
C985 5v0_addh_sc_tile_1/inv_pti 5v0_add_q_sc_1/pti 0
C986 5v0_addh_sc_tile_1/downstepper_test 5v0_addh_sc_tile_1/ctrl_over 0.16058f
C987 VDD_3V3_1 in_0_sign 0.65887f
C988 5v0_nter2oter_code_sc_0/gf180mcu_fd_sc_mcu7t5v0__nor2_1_0/a_224_472# 5v0_addh_sc_tile_1/ctrl_over 0
C989 5v0_add_q_sc_0/inv_nti 5v0_add_q_sc_0/pti 0.11055f
C990 in_1 in_0_sign 0
C991 c01over in_0_over 0.12282f
C992 c01over VDD_3V3_0 0
C993 5v0_addh_sc_tile_2/upstepper_test VDD_3V3_0 0.46517f
C994 5v0_addh_sc_tile_1/downstepper_test 5v0_addh_sc_tile_1/nti 0.06935f
C995 in_0_over 5v0_addh_sc_tile_0/5v0_half_adder_selector_sc_0/5v0_tgate_sel_2_sc_1/input_A 0.04656f
C996 int_012 5v0_addh_sc_tile_1/ctrl_sign 0.01034f
C997 5v0_addh_sc_tile_0/pti 5v0_nter2oter_code_sc_1/pti 0
C998 5v0_addh_sc_tile_2/downstepper_test 5v0_addh_sc_tile_2/a_n1205_n937# 0.00453f
C999 5v0_addh_sc_tile_2/inv_nti 5v0_addh_sc_tile_2/a_n1778_n454# 0.00226f
C1000 5v0_addh_sc_tile_2/ctrl_sign 5v0_addh_sc_tile_2/downstepper_test 0.20835f
C1001 5v0_nter2oter_code_sc_1/nti 5v0_addh_sc_tile_0/nti 0
C1002 5v0_add_q_sc_0/a_n1205_n937# 5v0_add_q_sc_0/upstepper_test 0.00334f
C1003 5v0_addh_sc_tile_0/inv_nti in_0_sign 0.24892f
C1004 int_carry 5v0_add_q_sc_1/downstepper_test 0.00477f
C1005 5v0_addh_sc_tile_1/inv_pti VDD_3V3_1 0.81122f
C1006 int_carry c_2_s 0.00413f
C1007 5v0_addh_sc_tile_2/nti int_012 0.00515f
C1008 5v0_addh_sc_tile_1/a_n1373_n454# VDD_3V3_0 0.00122f
C1009 5v0_add_q_sc_1/inv_nti 5v0_addh_sc_tile_1/inv_nti 0
C1010 VDD_3V3_0 5v0_addh_sc_tile_2/ctrl_over 2.0131f
C1011 5v0_addh_sc_tile_0/m1_103_293# c_2_s 0
C1012 5v0_add_q_sc_0/ctrl_sign 5v0_add_q_sc_0/pti 0
C1013 5v0_addh_sc_tile_1/inv_pti 5v0_addh_sc_tile_0/inv_nti 0
C1014 5v0_add_q_sc_1/5v0_half_adder_selector_sc_0/res_stage0 5v0_add_q_sc_1/upstepper_test 0.27475f
C1015 int_carry 5v0_add_q_sc_0/a_n1205_n937# 0
C1016 res_01 VDD_1V65_3 0.01451f
C1017 5v0_add_q_sc_1/5v0_half_adder_selector_sc_0/res_stage0 5v0_add_q_sc_1/5v0_half_adder_selector_sc_0/m1_n239_179# 0.18379f
C1018 c_2_o 5v0_addh_sc_tile_1/inv_nti 0.03482f
C1019 VDD_3V3_1 int_012 0.92139f
C1020 5v0_add_q_sc_0/inv_pti 5v0_addh_sc_tile_1/ctrl_over 0.00152f
C1021 in_1 int_012 0.00145f
C1022 5v0_add_q_sc_1/inv_nti 5v0_addh_sc_tile_1/pti 0.00257f
C1023 5v0_add_q_sc_1/nti in_0_over 0.00117f
C1024 in_2 5v0_nter2oter_code_sc_1/pti 0.46231f
C1025 c01over 5v0_addh_sc_tile_0/5v0_half_adder_selector_sc_0/5v0_tgate_sel_2_sc_1/input_A 0
C1026 5v0_nter2oter_code_sc_1/nti res_01 0.01204f
C1027 VDD_1V65_4 5v0_addh_sc_tile_2/a_n1205_n937# 0.00354f
C1028 5v0_addh_sc_tile_2/downstepper_test 5v0_addh_sc_tile_2/a_n1373_n454# 0.00442f
C1029 5v0_addh_sc_tile_1/inv_nti 5v0_addh_sc_tile_1/ctrl_sign 0.25029f
C1030 5v0_addh_sc_tile_2/ctrl_sign VDD_1V65_4 0
C1031 5v0_addh_sc_tile_1/inv_pti 5v0_addh_sc_tile_1/5v0_half_adder_selector_sc_0/res_stage0 0.01365f
C1032 5v0_add_q_sc_1/5v0_half_adder_selector_sc_0/res_stage0 int_c01 0.27251f
C1033 5v0_add_q_sc_0/a_n1205_n937# 5v0_add_q_sc_0/5v0_half_adder_selector_sc_0/res_stage0 0
C1034 5v0_nter2oter_code_sc_1/gf180mcu_fd_sc_mcu7t5v0__nor2_1_0/a_224_472# 5v0_addh_sc_tile_2/inv_pti 0
C1035 5v0_addh_sc_tile_0/inv_nti int_012 0.00631f
C1036 c_2_o 5v0_addh_sc_tile_1/pti 0.16959f
C1037 5v0_add_q_sc_0/5v0_half_adder_selector_sc_0/m1_n239_179# 5v0_addh_sc_tile_1/ctrl_over 0.00107f
C1038 5v0_add_q_sc_1/pti 5v0_addh_sc_tile_1/inv_nti 0
C1039 5v0_addh_sc_tile_2/upstepper_test 5v0_addh_sc_tile_2/ctrl_over 0.16997f
C1040 5v0_add_q_sc_1/inv_pti 5v0_add_q_sc_1/5v0_half_adder_selector_sc_0/res_stage0 0
C1041 5v0_add_q_sc_0/downstepper_test VDD_1V65_5 0.13024f
C1042 5v0_addh_sc_tile_2/ctrl_sign in_2 0.0048f
C1043 5v0_addh_sc_tile_1/ctrl_sign 5v0_addh_sc_tile_1/pti 0.48393f
C1044 5v0_addh_sc_tile_0/inv_pti in_0_sign 0.23041f
C1045 5v0_add_q_sc_1/downstepper_test 5v0_add_q_sc_1/upstepper_test 0.38867f
C1046 5v0_add_q_sc_1/downstepper_test 5v0_add_q_sc_1/5v0_half_adder_selector_sc_0/m1_n239_179# 0.09961f
C1047 5v0_addh_sc_tile_1/5v0_half_adder_selector_sc_0/res_stage0 int_012 0.1871f
C1048 5v0_addh_sc_tile_2/m1_103_293# 5v0_addh_sc_tile_2/inv_pti 0.17639f
C1049 m1_n2844_n810# c01 0.12483f
C1050 5v0_add_q_sc_1/upstepper_test c_2_s 0.13566f
C1051 5v0_add_q_sc_1/5v0_half_adder_selector_sc_0/m1_n239_179# c_2_s 0.30422f
C1052 5v0_add_q_sc_0/inv_nti VDD_1V65_5 0.01114f
C1053 VDD_3V3_1 5v0_addh_sc_tile_1/inv_nti 0.11496f
C1054 5v0_add_q_sc_1/pti 5v0_addh_sc_tile_1/pti 0
C1055 in_0_sign 5v0_addh_sc_tile_0/m1_843_n857# 0.24363f
C1056 int_012 in_3 0.01005f
C1057 5v0_add_q_sc_1/nti c01over 0.11172f
C1058 5v0_add_q_sc_0/nti 5v0_addh_sc_tile_1/ctrl_over 0
C1059 5v0_addh_sc_tile_2/downstepper_test 5v0_addh_sc_tile_2/a_n1778_n454# 0.0031f
C1060 VDD_1V65_4 5v0_addh_sc_tile_2/a_n1373_n454# 0.00232f
C1061 5v0_addh_sc_tile_2/inv_nti 5v0_addh_sc_tile_2/inv_pti 0.2615f
C1062 5v0_add_q_sc_1/downstepper_test int_c01 0.16195f
C1063 5v0_add_q_sc_0/inv_pti 5v0_add_q_sc_0/upstepper_test 0.0467f
C1064 c_2_s int_c01 0.20634f
C1065 5v0_addh_sc_tile_1/inv_pti 5v0_addh_sc_tile_0/m1_843_n857# 0.00739f
C1066 VDD_3V3_0 5v0_addh_sc_tile_1/m1_843_n857# 0.20528f
C1067 VDD_3V3_1 5v0_addh_sc_tile_1/pti 0.57114f
C1068 5v0_add_q_sc_1/inv_pti 5v0_add_q_sc_1/downstepper_test 0.07669f
C1069 5v0_add_q_sc_1/5v0_half_adder_selector_sc_0/m1_n244_n517# 5v0_add_q_sc_1/5v0_half_adder_selector_sc_0/5v0_tgate_sel_2_sc_1/input_A 0.02928f
C1070 5v0_add_q_sc_1/nti 5v0_add_q_sc_1/a_n1778_n454# 0
C1071 5v0_add_q_sc_1/inv_pti c_2_s 0.05919f
C1072 int_carry 5v0_add_q_sc_0/inv_pti 0.08665f
C1073 5v0_add_q_sc_0/5v0_half_adder_selector_sc_0/m1_n239_179# 5v0_add_q_sc_0/upstepper_test 0.07502f
C1074 5v0_addh_sc_tile_0/inv_nti 5v0_addh_sc_tile_1/pti 0
C1075 c01 5v0_addh_sc_tile_0/5v0_half_adder_selector_sc_0/res_stage0 0
C1076 5v0_addh_sc_tile_1/5v0_half_adder_selector_sc_0/res_stage0 5v0_addh_sc_tile_1/inv_nti 0.02399f
C1077 VDD_1V65_5 5v0_add_q_sc_0/pti 0.00115f
C1078 in_0_over in_0_sign 0.05861f
C1079 in_0_sign VDD_3V3_0 0
C1080 5v0_addh_sc_tile_1/downstepper_test res_01 0.18203f
C1081 5v0_add_q_sc_0/5v0_half_adder_selector_sc_0/m1_n239_179# 5v0_addh_sc_tile_2/pti 0
C1082 VDD_1V65_4 5v0_addh_sc_tile_2/a_n1778_n454# 0
C1083 5v0_addh_sc_tile_2/ctrl_sign 5v0_addh_sc_tile_2/m1_843_n857# 0.24363f
C1084 5v0_add_q_sc_0/inv_pti 5v0_add_q_sc_0/5v0_half_adder_selector_sc_0/res_stage0 0
C1085 int_carry 5v0_add_q_sc_0/5v0_half_adder_selector_sc_0/m1_n239_179# 0.00189f
C1086 res_0 5v0_addh_sc_tile_2/inv_nti 0.01449f
C1087 5v0_addh_sc_tile_1/5v0_half_adder_selector_sc_0/res_stage0 5v0_addh_sc_tile_1/pti 0.01078f
C1088 5v0_addh_sc_tile_1/inv_pti in_0_over 0.00926f
C1089 5v0_addh_sc_tile_1/inv_pti VDD_3V3_0 0.1766f
C1090 5v0_add_q_sc_0/upstepper_test 5v0_add_q_sc_0/nti 0.11981f
C1091 5v0_add_q_sc_0/5v0_half_adder_selector_sc_0/m1_n244_n517# 5v0_addh_sc_tile_2/pti 0.00139f
C1092 int_carry 5v0_add_q_sc_0/5v0_half_adder_selector_sc_0/m1_n244_n517# 0.07888f
C1093 5v0_add_q_sc_0/5v0_half_adder_selector_sc_0/res_stage0 5v0_add_q_sc_0/5v0_half_adder_selector_sc_0/m1_n239_179# 0.18379f
C1094 5v0_addh_sc_tile_0/upstepper_test c01 0
C1095 5v0_addh_sc_tile_1/a_382_n1095# 5v0_addh_sc_tile_1/m1_103_293# 0.07764f
C1096 c01 5v0_addh_sc_tile_0/downstepper_test 0
C1097 5v0_add_q_sc_1/upstepper_test 5v0_add_q_sc_1/a_n1373_n454# 0
C1098 int_carry 5v0_add_q_sc_0/nti 0.62238f
C1099 c01over in_0_sign 0.01012f
C1100 int_012 VDD_3V3_0 2.39715f
C1101 5v0_addh_sc_tile_0/5v0_half_adder_selector_sc_0/5v0_tgate_sel_2_sc_1/input_A in_0_sign 0
C1102 5v0_addh_sc_tile_1/ctrl_over 5v0_addh_sc_tile_0/5v0_half_adder_selector_sc_0/res_stage0 0
C1103 5v0_addh_sc_tile_2/downstepper_test 5v0_addh_sc_tile_2/inv_pti 0.13388f
C1104 5v0_addh_sc_tile_2/ctrl_sign 5v0_add_q_sc_0/ctrl_sign 0.27145f
C1105 5v0_add_q_sc_1/5v0_half_adder_selector_sc_0/res_stage0 c_2_o 0.11645f
C1106 5v0_add_q_sc_0/a_n1373_n454# 5v0_add_q_sc_0/upstepper_test 0
C1107 5v0_add_q_sc_0/5v0_half_adder_selector_sc_0/m1_n244_n517# 5v0_add_q_sc_0/5v0_half_adder_selector_sc_0/res_stage0 0.08646f
C1108 5v0_addh_sc_tile_2/ctrl_sign 5v0_addh_sc_tile_2/5v0_half_adder_selector_sc_0/5v0_tgate_sel_2_sc_1/input_A 0
C1109 int_c01 5v0_add_q_sc_1/a_n1373_n454# 0.00136f
C1110 5v0_addh_sc_tile_1/inv_pti c01over 0.01474f
C1111 5v0_add_q_sc_0/5v0_half_adder_selector_sc_0/res_stage0 5v0_add_q_sc_0/nti 0.00372f
C1112 5v0_addh_sc_tile_0/m1_843_n857# 5v0_addh_sc_tile_1/pti 0
C1113 5v0_add_q_sc_0/5v0_half_adder_selector_sc_0/m1_n239_179# res_01 0
C1114 int_carry 5v0_add_q_sc_0/a_n1373_n454# 0.00136f
C1115 res_c 5v0_add_q_sc_0/5v0_half_adder_selector_sc_0/m1_n244_n517# 0.16119f
C1116 5v0_add_q_sc_1/inv_pti 5v0_add_q_sc_1/a_n1373_n454# 0.00135f
C1117 5v0_addh_sc_tile_1/inv_pti 5v0_addh_sc_tile_1/a_n1373_n454# 0.00135f
C1118 5v0_addh_sc_tile_1/inv_pti 5v0_addh_sc_tile_2/ctrl_over 0
C1119 5v0_add_q_sc_1/inv_nti 5v0_add_q_sc_1/downstepper_test 0.17947f
C1120 res_c 5v0_add_q_sc_0/nti 0
C1121 5v0_addh_sc_tile_2/ctrl_sign 5v0_addh_sc_tile_1/upstepper_test 0
C1122 5v0_add_q_sc_1/inv_nti c_2_s 0.10096f
C1123 5v0_nter2oter_code_sc_1/nti 5v0_addh_sc_tile_1/ctrl_sign 0.13214f
C1124 5v0_add_q_sc_1/nti in_0_sign 0
C1125 in_0_over 5v0_addh_sc_tile_1/inv_nti 0
C1126 5v0_addh_sc_tile_0/upstepper_test 5v0_addh_sc_tile_1/ctrl_over 0
C1127 5v0_addh_sc_tile_1/ctrl_over 5v0_addh_sc_tile_0/downstepper_test 0
C1128 m1_n2844_n810# 5v0_addh_sc_tile_0/m1_103_293# 0
C1129 VDD_3V3_0 5v0_addh_sc_tile_1/inv_nti 0.66943f
C1130 VDD_1V65_4 5v0_addh_sc_tile_2/inv_pti 0.14775f
C1131 5v0_nter2oter_code_sc_1/gf180mcu_fd_sc_mcu7t5v0__nor2_1_0/a_224_472# 5v0_addh_sc_tile_1/ctrl_over 0.02885f
C1132 5v0_addh_sc_tile_2/ctrl_sign 5v0_nter2oter_code_sc_0/nti 0.03693f
C1133 5v0_add_q_sc_1/downstepper_test c_2_o 0.12191f
C1134 res_0 5v0_addh_sc_tile_2/downstepper_test 0.00302f
C1135 c_2_s c_2_o 0.02923f
C1136 5v0_add_q_sc_1/5v0_half_adder_selector_sc_0/res_stage0 VDD_3V3_1 0.14945f
C1137 5v0_addh_sc_tile_1/inv_pti 5v0_add_q_sc_1/nti 0.00413f
C1138 int_012 5v0_addh_sc_tile_2/ctrl_over 1.76395f
C1139 5v0_addh_sc_tile_1/a_n1205_n937# 5v0_addh_sc_tile_1/inv_nti 0
C1140 5v0_add_q_sc_1/downstepper_test 5v0_addh_sc_tile_1/ctrl_sign 0.00227f
C1141 in_0_over 5v0_addh_sc_tile_1/pti 0.00417f
C1142 in_2 5v0_addh_sc_tile_2/inv_pti 0
C1143 VDD_3V3_0 5v0_addh_sc_tile_1/pti 0.08682f
C1144 int_c01 VDD_1V65_2 0.02356f
C1145 c_2_s 5v0_addh_sc_tile_1/ctrl_sign 0.24986f
C1146 int_carry 5v0_add_q_sc_1/5v0_half_adder_selector_sc_0/m1_n244_n517# 0.16119f
C1147 5v0_addh_sc_tile_1/ctrl_over 5v0_addh_sc_tile_2/m1_103_293# 0
C1148 5v0_nter2oter_code_sc_1/nti VDD_3V3_1 0.0701f
C1149 5v0_add_q_sc_1/pti 5v0_add_q_sc_1/downstepper_test 0.08084f
C1150 5v0_addh_sc_tile_1/downstepper_test 5v0_addh_sc_tile_2/a_382_n1095# 0.0018f
C1151 5v0_nter2oter_code_sc_1/nti in_1 0
C1152 5v0_addh_sc_tile_1/nti 5v0_addh_sc_tile_2/m1_103_293# 0.00116f
C1153 5v0_add_q_sc_1/pti c_2_s 0.15254f
C1154 5v0_addh_sc_tile_1/ctrl_over 5v0_addh_sc_tile_2/inv_nti 0
C1155 c01over 5v0_addh_sc_tile_1/inv_nti 0
C1156 5v0_addh_sc_tile_0/m1_103_293# 5v0_addh_sc_tile_0/5v0_half_adder_selector_sc_0/res_stage0 0.18549f
C1157 5v0_nter2oter_code_sc_0/pti 5v0_addh_sc_tile_1/ctrl_over 0.00235f
C1158 5v0_nter2oter_code_sc_1/nti 5v0_addh_sc_tile_0/inv_nti 0.00216f
C1159 5v0_add_q_sc_0/5v0_half_adder_selector_sc_0/5v0_tgate_sel_2_sc_1/input_A 5v0_add_q_sc_0/downstepper_test 0
C1160 res_0 VDD_1V65_4 0
C1161 5v0_addh_sc_tile_1/nti 5v0_addh_sc_tile_2/inv_nti 0
C1162 5v0_add_q_sc_1/downstepper_test VDD_3V3_1 0.52531f
C1163 5v0_addh_sc_tile_0/nti 5v0_addh_sc_tile_0/5v0_half_adder_selector_sc_0/res_stage0 0.00372f
C1164 c_2_s VDD_3V3_1 1.08276f
C1165 5v0_addh_sc_tile_1/a_n1373_n454# 5v0_addh_sc_tile_1/inv_nti 0
C1166 5v0_addh_sc_tile_2/ctrl_over 5v0_addh_sc_tile_1/inv_nti 0.00155f
C1167 5v0_addh_sc_tile_1/downstepper_test c_2_o 0
C1168 c01over 5v0_addh_sc_tile_1/pti 0.0051f
C1169 c01 5v0_addh_sc_tile_0/a_382_n1095# 0.02324f
C1170 5v0_add_q_sc_0/upstepper_test 5v0_add_q_sc_0/a_n1778_n454# 0
C1171 c_2_s 5v0_addh_sc_tile_0/inv_nti 0.00142f
C1172 5v0_addh_sc_tile_1/inv_pti 5v0_addh_sc_tile_1/m1_843_n857# 0
C1173 m1_n2844_n810# int_c01 0.11648f
C1174 5v0_addh_sc_tile_1/downstepper_test 5v0_addh_sc_tile_1/ctrl_sign 0.20144f
C1175 5v0_add_q_sc_0/inv_pti 5v0_add_q_sc_0/ctrl_over 0
C1176 5v0_nter2oter_code_sc_1/nti in_3 0
C1177 5v0_addh_sc_tile_1/a_n1373_n454# 5v0_addh_sc_tile_1/pti 0
C1178 5v0_addh_sc_tile_2/ctrl_over 5v0_addh_sc_tile_1/pti 0
C1179 5v0_add_q_sc_1/inv_nti 5v0_add_q_sc_1/a_n1373_n454# 0
C1180 5v0_add_q_sc_1/nti 5v0_addh_sc_tile_1/inv_nti 0
C1181 5v0_addh_sc_tile_2/m1_843_n857# 5v0_addh_sc_tile_2/inv_pti 0
C1182 5v0_addh_sc_tile_1/ctrl_over 5v0_addh_sc_tile_1/m1_103_293# 0.02786f
C1183 5v0_addh_sc_tile_0/upstepper_test 5v0_addh_sc_tile_0/m1_103_293# 0.07773f
C1184 5v0_addh_sc_tile_0/m1_103_293# 5v0_addh_sc_tile_0/downstepper_test 0.10533f
C1185 VDD_1V65_2 VSS_3 0.07318f
C1186 5v0_addh_sc_tile_2/pti VSS_3 1.17571f
C1187 VDD_1V65_4 VSS_3 0.09068f
C1188 5v0_addh_sc_tile_2/inv_nti VSS_3 1.3751f
C1189 5v0_addh_sc_tile_2/m1_843_n857# VSS_3 0.16265f ; **FLOATING
C1190 5v0_addh_sc_tile_2/ctrl_sign VSS_3 1.27243f
C1191 5v0_addh_sc_tile_2/a_n1205_n937# VSS_3 0 ; **FLOATING
C1192 5v0_addh_sc_tile_2/a_n1373_n454# VSS_3 0.00335f ; **FLOATING
C1193 5v0_addh_sc_tile_2/a_n1778_n454# VSS_3 0.00573f ; **FLOATING
C1194 5v0_addh_sc_tile_2/inv_pti VSS_3 0.92511f
C1195 5v0_addh_sc_tile_2/5v0_half_adder_selector_sc_0/5v0_tgate_sel_2_sc_1/input_A VSS_3 0
C1196 5v0_addh_sc_tile_2/a_382_n1095# VSS_3 0.83941f ; **FLOATING
C1197 in_3 VSS_3 1.64882f
C1198 res_0 VSS_3 0.02768f
C1199 5v0_addh_sc_tile_2/ctrl_over VSS_3 0.80165f
C1200 5v0_addh_sc_tile_2/m1_103_293# VSS_3 0.74864f ; **FLOATING
C1201 5v0_addh_sc_tile_2/5v0_half_adder_selector_sc_0/res_stage0 VSS_3 0.50069f
C1202 5v0_addh_sc_tile_2/downstepper_test VSS_3 0.58281f
C1203 5v0_addh_sc_tile_2/upstepper_test VSS_3 0.53687f
C1204 5v0_addh_sc_tile_2/nti VSS_3 1.2554f
C1205 5v0_addh_sc_tile_1/pti VSS_3 1.17421f
C1206 VDD_1V65_3 VSS_3 0.09068f
C1207 5v0_addh_sc_tile_1/inv_nti VSS_3 1.35629f
C1208 5v0_addh_sc_tile_1/m1_843_n857# VSS_3 0.15965f ; **FLOATING
C1209 5v0_addh_sc_tile_1/ctrl_sign VSS_3 1.3078f
C1210 5v0_addh_sc_tile_1/a_n1205_n937# VSS_3 0 ; **FLOATING
C1211 5v0_addh_sc_tile_1/a_n1373_n454# VSS_3 0.00335f ; **FLOATING
C1212 5v0_addh_sc_tile_1/a_n1778_n454# VSS_3 0.00573f ; **FLOATING
C1213 5v0_addh_sc_tile_1/inv_pti VSS_3 0.92626f
C1214 VDD_3V3_1 VSS_3 38.89917f
C1215 5v0_addh_sc_tile_1/5v0_half_adder_selector_sc_0/5v0_tgate_sel_2_sc_1/input_A VSS_3 0
C1216 5v0_addh_sc_tile_1/a_382_n1095# VSS_3 0.81445f ; **FLOATING
C1217 res_01 VSS_3 1.54805f
C1218 int_012 VSS_3 1.10181f
C1219 5v0_addh_sc_tile_1/ctrl_over VSS_3 0.79116f
C1220 5v0_addh_sc_tile_1/m1_103_293# VSS_3 0.74864f ; **FLOATING
C1221 5v0_addh_sc_tile_1/5v0_half_adder_selector_sc_0/res_stage0 VSS_3 0.50069f
C1222 5v0_addh_sc_tile_1/downstepper_test VSS_3 0.58281f
C1223 5v0_addh_sc_tile_1/upstepper_test VSS_3 0.53687f
C1224 5v0_addh_sc_tile_1/nti VSS_3 1.26884f
C1225 5v0_addh_sc_tile_0/pti VSS_3 1.17945f
C1226 VDD_1V65_0 VSS_3 0.09068f
C1227 5v0_addh_sc_tile_0/inv_nti VSS_3 1.36061f
C1228 5v0_addh_sc_tile_0/m1_843_n857# VSS_3 0.15969f ; **FLOATING
C1229 in_0_sign VSS_3 0.87016f
C1230 5v0_addh_sc_tile_0/a_n1205_n937# VSS_3 0 ; **FLOATING
C1231 5v0_addh_sc_tile_0/a_n1373_n454# VSS_3 0.00335f ; **FLOATING
C1232 5v0_addh_sc_tile_0/a_n1778_n454# VSS_3 0.00573f ; **FLOATING
C1233 5v0_addh_sc_tile_0/inv_pti VSS_3 0.92409f
C1234 c01 VSS_3 0.24862f
C1235 5v0_addh_sc_tile_0/5v0_half_adder_selector_sc_0/5v0_tgate_sel_2_sc_1/input_A VSS_3 0
C1236 5v0_addh_sc_tile_0/a_382_n1095# VSS_3 0.81488f ; **FLOATING
C1237 in_1 VSS_3 1.70172f
C1238 in_0_over VSS_3 0.49348f
C1239 5v0_addh_sc_tile_0/m1_103_293# VSS_3 0.74828f ; **FLOATING
C1240 5v0_addh_sc_tile_0/5v0_half_adder_selector_sc_0/res_stage0 VSS_3 0.50069f
C1241 5v0_addh_sc_tile_0/downstepper_test VSS_3 0.58464f
C1242 5v0_addh_sc_tile_0/upstepper_test VSS_3 0.53687f
C1243 5v0_addh_sc_tile_0/nti VSS_3 1.25562f
C1244 in_2 VSS_3 0.95085f
C1245 5v0_nter2oter_code_sc_1/pti VSS_3 0.62525f
C1246 5v0_nter2oter_code_sc_1/nti VSS_3 0.65963f
C1247 5v0_nter2oter_code_sc_1/gf180mcu_fd_sc_mcu7t5v0__nor2_1_0/a_224_472# VSS_3 0 ; **FLOATING
C1248 5v0_nter2oter_code_sc_0/pti VSS_3 0.61125f
C1249 5v0_nter2oter_code_sc_0/nti VSS_3 0.66288f
C1250 5v0_nter2oter_code_sc_0/gf180mcu_fd_sc_mcu7t5v0__nor2_1_0/a_224_472# VSS_3 0 ; **FLOATING
C1251 5v0_add_q_sc_1/pti VSS_3 0.59838f
C1252 VDD_1V65_1 VSS_3 0.09068f
C1253 5v0_add_q_sc_1/inv_nti VSS_3 0.53562f
C1254 5v0_add_q_sc_1/inv_pti VSS_3 0.59603f
C1255 5v0_add_q_sc_1/a_n1205_n937# VSS_3 0 ; **FLOATING
C1256 5v0_add_q_sc_1/a_n1373_n454# VSS_3 0.00335f ; **FLOATING
C1257 5v0_add_q_sc_1/a_n1778_n454# VSS_3 0.00573f ; **FLOATING
C1258 5v0_add_q_sc_1/5v0_half_adder_selector_sc_0/5v0_tgate_sel_2_sc_1/input_A VSS_3 0
C1259 5v0_add_q_sc_1/5v0_half_adder_selector_sc_0/m1_n244_n517# VSS_3 0.29628f ; **FLOATING
C1260 int_c01 VSS_3 1.92885f
C1261 c_2_o VSS_3 0.97319f
C1262 5v0_add_q_sc_1/5v0_half_adder_selector_sc_0/m1_n239_179# VSS_3 0.29901f ; **FLOATING
C1263 5v0_add_q_sc_1/5v0_half_adder_selector_sc_0/res_stage0 VSS_3 0.50836f
C1264 5v0_add_q_sc_1/downstepper_test VSS_3 0.63842f
C1265 c_2_s VSS_3 1.0206f
C1266 5v0_add_q_sc_1/upstepper_test VSS_3 0.5468f
C1267 5v0_add_q_sc_1/nti VSS_3 1.26615f
C1268 5v0_add_q_sc_0/pti VSS_3 0.59945f
C1269 VDD_1V65_5 VSS_3 0.09068f
C1270 5v0_add_q_sc_0/inv_nti VSS_3 0.53562f
C1271 5v0_add_q_sc_0/inv_pti VSS_3 0.59603f
C1272 5v0_add_q_sc_0/a_n1205_n937# VSS_3 0 ; **FLOATING
C1273 5v0_add_q_sc_0/a_n1373_n454# VSS_3 0.00335f ; **FLOATING
C1274 5v0_add_q_sc_0/a_n1778_n454# VSS_3 0.00573f ; **FLOATING
C1275 5v0_add_q_sc_0/5v0_half_adder_selector_sc_0/5v0_tgate_sel_2_sc_1/input_A VSS_3 0
C1276 5v0_add_q_sc_0/5v0_half_adder_selector_sc_0/m1_n244_n517# VSS_3 0.29628f ; **FLOATING
C1277 int_carry VSS_3 2.49654f
C1278 res_c VSS_3 0.0293f
C1279 5v0_add_q_sc_0/ctrl_over VSS_3 0.73852f
C1280 5v0_add_q_sc_0/5v0_half_adder_selector_sc_0/m1_n239_179# VSS_3 0.29907f ; **FLOATING
C1281 5v0_add_q_sc_0/5v0_half_adder_selector_sc_0/res_stage0 VSS_3 0.50905f
C1282 5v0_add_q_sc_0/downstepper_test VSS_3 0.64239f
C1283 5v0_add_q_sc_0/ctrl_sign VSS_3 0.49276f
C1284 VDD_3V3_0 VSS_3 47.31763f
C1285 5v0_add_q_sc_0/upstepper_test VSS_3 0.54953f
C1286 5v0_add_q_sc_0/nti VSS_3 1.27003f
C1287 c01over VSS_3 0.62913f
C1288 m1_n2844_n810# VSS_3 0.48929f ; **FLOATING
