* NGSPICE file created from 5v0_add3_sc.ext - technology: gf180mcuD

.option scale=5n

X0 5v0_add_q_sc_1/ternary_input m1_n2844_n810# 5v0_addh_sc_tile_0/carry_sign_probe VSS_3 nfet_06v0 ad=14.432n pd=0.504m as=14.432n ps=0.504m w=164 l=120
X1 VDD_1V65_2 5v0_addh_sc_tile_0/carry_0_probe 5v0_add_q_sc_1/ternary_input VSS_3 nfet_06v0 ad=14.432n pd=0.504m as=14.432n ps=0.504m w=164 l=120
X2 5v0_add_q_sc_0/pti 5v0_add_q_sc_0/ternary_input VSS_3 VSS_3 nfet_06v0 ad=6.336n pd=0.32m as=6.478n ps=0.255m w=72 l=578
X3 VDD_3V3_0 5v0_add_q_sc_0/ternary_input 5v0_add_q_sc_0/pti VDD_3V3_0 pfet_06v0 ad=12.81n pd=0.349m as=12.688n ps=0.348m w=244 l=100
X4 VDD_3V3_0 5v0_add_q_sc_0/ternary_input 5v0_add_q_sc_0/nti VDD_3V3_0 pfet_06v0 ad=13.616n pd=0.392m as=9.696n ps=0.394m w=96 l=150
X5 VSS_3 5v0_add_q_sc_0/ternary_input 5v0_add_q_sc_0/nti VSS_3 nfet_06v0 ad=6.478n pd=0.255m as=12.7n ps=0.454m w=127 l=120
X6 5v0_add_q_sc_0/pti 5v0_add_q_sc_0/ternary_input VDD_3V3_0 VDD_3V3_0 pfet_06v0 ad=12.688n pd=0.348m as=13.616n ps=0.392m w=244 l=100
X7 5v0_add_q_sc_0/pti 5v0_add_q_sc_0/ternary_input VDD_3V3_0 VDD_3V3_0 pfet_06v0 ad=27.328n pd=0.712m as=12.81n ps=0.349m w=244 l=100
X8 5v0_add_q_sc_0/5v0_half_adder_selector_sc_0/res_stage0 5v0_add_q_sc_0/5v0_half_adder_selector_sc_0/m1_n239_179# 5v0_add_q_sc_0/downstepper_test VSS_3 nfet_06v0 ad=14.432n pd=0.504m as=14.432n ps=0.504m w=164 l=120
X9 5v0_add_q_sc_0/5v0_half_adder_selector_sc_0/res_stage0 5v0_add_q_sc_0/5v0_half_adder_selector_sc_0/m1_n239_179# 5v0_add_q_sc_0/upstepper_test VDD_3V3_0 pfet_06v0 ad=21.472n pd=0.664m as=21.472n ps=0.664m w=244 l=100
X10 5v0_add_q_sc_0/5v0_half_adder_selector_sc_0/m1_n239_179# 5v0_add_q_sc_0/ctrl_sign VSS_3 VSS_3 nfet_06v0 ad=14.432n pd=0.504m as=14.432n ps=0.504m w=164 l=120
X11 5v0_add_q_sc_0/5v0_half_adder_selector_sc_0/m1_n239_179# 5v0_add_q_sc_0/ctrl_sign VDD_3V3_0 VDD_3V3_0 pfet_06v0 ad=21.472n pd=0.664m as=21.472n ps=0.664m w=244 l=100
X12 5v0_add_q_sc_0/5v0_half_adder_selector_sc_0/res_stage0 5v0_add_q_sc_0/ctrl_sign 5v0_add_q_sc_0/upstepper_test VSS_3 nfet_06v0 ad=31.489n pd=1.041m as=43.711n ps=1.504m w=164 l=120
X13 5v0_add_q_sc_0/5v0_half_adder_selector_sc_0/res_stage0 5v0_add_q_sc_0/ctrl_sign 5v0_add_q_sc_0/downstepper_test VDD_3V3_0 pfet_06v0 ad=46.849n pd=1.361m as=42.856n ps=1.326m w=244 l=100
X14 res_c 5v0_add_q_sc_0/5v0_half_adder_selector_sc_0/m1_n244_n517# 5v0_add_q_sc_0/5v0_half_adder_selector_sc_0/res_stage0 VSS_3 nfet_06v0 ad=17.057n pd=0.537m as=0 ps=0 w=164 l=120
X15 res_c 5v0_add_q_sc_0/5v0_half_adder_selector_sc_0/m1_n244_n517# 5v0_add_q_sc_0/ternary_input VDD_3V3_0 pfet_06v0 ad=25.377n pd=0.697m as=46.849n ps=1.361m w=244 l=100
X16 5v0_add_q_sc_0/5v0_half_adder_selector_sc_0/m1_n244_n517# 5v0_add_q_sc_0/ctrl_over VSS_3 VSS_3 nfet_06v0 ad=14.432n pd=0.504m as=0.54033u ps=0.01928 w=164 l=120
X17 5v0_add_q_sc_0/5v0_half_adder_selector_sc_0/m1_n244_n517# 5v0_add_q_sc_0/ctrl_over VDD_3V3_0 VDD_3V3_0 pfet_06v0 ad=21.472n pd=0.664m as=0.4126u ps=0.01232 w=244 l=100
X18 res_c 5v0_add_q_sc_0/ctrl_over 5v0_add_q_sc_0/ternary_input VSS_3 nfet_06v0 ad=0 pd=0 as=31.489n ps=1.041m w=164 l=120
X19 res_c 5v0_add_q_sc_0/ctrl_over 5v0_add_q_sc_0/5v0_half_adder_selector_sc_0/res_stage0 VDD_3V3_0 pfet_06v0 ad=0 pd=0 as=0 ps=0 w=244 l=100
X20 5v0_add_q_sc_0/inv_pti 5v0_add_q_sc_0/pti 5v0_add_q_sc_0/not_internal_0/a_36_68# VSS_3 nfet_06v0 ad=14.432n pd=0.504m as=14.432n ps=0.504m w=164 l=120
X21 5v0_add_q_sc_0/inv_pti 5v0_add_q_sc_0/pti 5v0_add_q_sc_0/not_internal_0/a_56_472# VDD_3V3_0 pfet_06v0 ad=21.472n pd=0.664m as=21.472n ps=0.664m w=244 l=100
X22 5v0_add_q_sc_0/a_n1373_n454# 5v0_add_q_sc_0/inv_nti 5v0_add_q_sc_0/downstepper_test VSS_3 nfet_06v0 ad=3.528n pd=0.195m as=8.599n ps=0.264m w=147 l=120
X23 5v0_add_q_sc_0/upstepper_test 5v0_add_q_sc_0/nti 5v0_add_q_sc_0/a_n1205_n937# VDD_3V3_0 pfet_06v0 ad=21.384n pd=0.662m as=5.832n ps=0.291m w=243 l=100
X24 5v0_add_q_sc_0/inv_nti 5v0_add_q_sc_0/nti VDD_3V3_0 VDD_3V3_0 pfet_06v0 ad=21.472n pd=0.664m as=21.472n ps=0.664m w=244 l=100
X25 5v0_add_q_sc_0/upstepper_test 5v0_add_q_sc_0/nti VDD_1V65_5 VSS_3 nfet_06v0 ad=14.847n pd=0.496m as=10.51n ps=0.29m w=147 l=120
X26 5v0_add_q_sc_0/a_n1205_n937# 5v0_add_q_sc_0/inv_pti VDD_3V3_0 VDD_3V3_0 pfet_06v0 ad=5.832n pd=0.291m as=21.384n ps=0.662m w=243 l=100
X27 5v0_add_q_sc_0/downstepper_test 5v0_add_q_sc_0/pti 5v0_add_q_sc_0/a_n1778_n454# VSS_3 nfet_06v0 ad=8.599n pd=0.264m as=3.528n ps=0.195m w=147 l=120
X28 5v0_add_q_sc_0/inv_nti 5v0_add_q_sc_0/nti VSS_3 VSS_3 nfet_06v0 ad=14.432n pd=0.504m as=14.432n ps=0.504m w=164 l=120
X29 5v0_add_q_sc_0/a_n1778_n454# 5v0_add_q_sc_0/inv_nti VSS_3 VSS_3 nfet_06v0 ad=3.528n pd=0.195m as=14.847n ps=0.496m w=147 l=120
X30 5v0_add_q_sc_0/upstepper_test 5v0_add_q_sc_0/inv_pti VSS_3 VSS_3 nfet_06v0 ad=14.432n pd=0.504m as=14.432n ps=0.504m w=164 l=120
X31 VDD_1V65_5 5v0_add_q_sc_0/inv_pti 5v0_add_q_sc_0/a_n1373_n454# VSS_3 nfet_06v0 ad=10.51n pd=0.29m as=3.528n ps=0.195m w=147 l=120
X32 5v0_add_q_sc_0/downstepper_test 5v0_add_q_sc_0/inv_nti VDD_3V3_0 VDD_3V3_0 pfet_06v0 ad=21.384n pd=0.662m as=21.384n ps=0.662m w=243 l=100
X33 5v0_add_q_sc_1/pti 5v0_add_q_sc_1/ternary_input VSS_3 VSS_3 nfet_06v0 ad=6.336n pd=0.32m as=0 ps=0 w=72 l=578
X34 VDD_3V3_1 5v0_add_q_sc_1/ternary_input 5v0_add_q_sc_1/pti VDD_3V3_1 pfet_06v0 ad=0.47579u pd=0.01354 as=52.704n ps=1.408m w=244 l=100
X35 VDD_3V3_1 5v0_add_q_sc_1/ternary_input 5v0_add_q_sc_1/nti VDD_3V3_1 pfet_06v0 ad=0 pd=0 as=9.696n ps=0.394m w=96 l=150
X36 VSS_3 5v0_add_q_sc_1/ternary_input 5v0_add_q_sc_1/nti VSS_3 nfet_06v0 ad=0 pd=0 as=12.7n ps=0.454m w=127 l=120
X37 5v0_add_q_sc_1/pti 5v0_add_q_sc_1/ternary_input VDD_3V3_1 VDD_3V3_1 pfet_06v0 ad=0 pd=0 as=0 ps=0 w=244 l=100
X38 5v0_add_q_sc_1/pti 5v0_add_q_sc_1/ternary_input VDD_3V3_1 VDD_3V3_1 pfet_06v0 ad=0 pd=0 as=0 ps=0 w=244 l=100
X39 5v0_add_q_sc_1/5v0_half_adder_selector_sc_0/res_stage0 5v0_add_q_sc_1/5v0_half_adder_selector_sc_0/m1_n239_179# 5v0_add_q_sc_1/downstepper_test VSS_3 nfet_06v0 ad=31.489n pd=1.041m as=31.631n ps=1.032m w=164 l=120
X40 5v0_add_q_sc_1/5v0_half_adder_selector_sc_0/res_stage0 5v0_add_q_sc_1/5v0_half_adder_selector_sc_0/m1_n239_179# VSS_3 VDD_3V3_1 pfet_06v0 ad=46.849n pd=1.361m as=0.15934u ps=5.646m w=244 l=100
X41 5v0_add_q_sc_1/5v0_half_adder_selector_sc_0/m1_n239_179# 5v0_add_q_sc_1/ctrl_sign VSS_3 VSS_3 nfet_06v0 ad=14.432n pd=0.504m as=0 ps=0 w=164 l=120
X42 5v0_add_q_sc_1/5v0_half_adder_selector_sc_0/m1_n239_179# 5v0_add_q_sc_1/ctrl_sign VDD_3V3_1 VDD_3V3_1 pfet_06v0 ad=21.472n pd=0.664m as=0 ps=0 w=244 l=100
X43 5v0_add_q_sc_1/5v0_half_adder_selector_sc_0/res_stage0 5v0_add_q_sc_1/ctrl_sign VSS_3 VSS_3 nfet_06v0 ad=0 pd=0 as=0 ps=0 w=164 l=120
X44 5v0_add_q_sc_1/5v0_half_adder_selector_sc_0/res_stage0 5v0_add_q_sc_1/ctrl_sign 5v0_add_q_sc_1/downstepper_test VDD_3V3_1 pfet_06v0 ad=0 pd=0 as=42.856n ps=1.326m w=244 l=100
X45 5v0_add_q_sc_0/ternary_input 5v0_add_q_sc_1/5v0_half_adder_selector_sc_0/m1_n244_n517# 5v0_add_q_sc_1/5v0_half_adder_selector_sc_0/res_stage0 VSS_3 nfet_06v0 ad=0 pd=0 as=0 ps=0 w=164 l=120
X46 5v0_add_q_sc_0/ternary_input 5v0_add_q_sc_1/5v0_half_adder_selector_sc_0/m1_n244_n517# 5v0_add_q_sc_1/ternary_input VDD_3V3_1 pfet_06v0 ad=0 pd=0 as=42.945n ps=1.329m w=244 l=100
X47 5v0_add_q_sc_1/5v0_half_adder_selector_sc_0/m1_n244_n517# 5v0_add_q_sc_1/ctrl_over VSS_3 VSS_3 nfet_06v0 ad=14.432n pd=0.504m as=0 ps=0 w=164 l=120
X48 5v0_add_q_sc_1/5v0_half_adder_selector_sc_0/m1_n244_n517# 5v0_add_q_sc_1/ctrl_over VDD_3V3_1 VDD_3V3_1 pfet_06v0 ad=21.472n pd=0.664m as=0 ps=0 w=244 l=100
X49 5v0_add_q_sc_0/ternary_input 5v0_add_q_sc_1/ctrl_over 5v0_add_q_sc_1/ternary_input VSS_3 nfet_06v0 ad=0 pd=0 as=31.489n ps=1.041m w=164 l=120
X50 5v0_add_q_sc_0/ternary_input 5v0_add_q_sc_1/ctrl_over 5v0_add_q_sc_1/5v0_half_adder_selector_sc_0/res_stage0 VDD_3V3_1 pfet_06v0 ad=0 pd=0 as=0 ps=0 w=244 l=100
X51 5v0_add_q_sc_1/inv_pti 5v0_add_q_sc_1/pti 5v0_add_q_sc_1/not_internal_0/a_36_68# VSS_3 nfet_06v0 ad=14.432n pd=0.504m as=14.432n ps=0.504m w=164 l=120
X52 5v0_add_q_sc_1/inv_pti 5v0_add_q_sc_1/pti 5v0_add_q_sc_1/not_internal_0/a_56_472# VDD_3V3_1 pfet_06v0 ad=21.472n pd=0.664m as=21.472n ps=0.664m w=244 l=100
X53 5v0_add_q_sc_1/a_n1373_n454# 5v0_add_q_sc_1/inv_nti 5v0_add_q_sc_1/downstepper_test VSS_3 nfet_06v0 ad=7.056n pd=0.39m as=0 ps=0 w=147 l=120
X54 VSS_3 5v0_add_q_sc_1/nti 5v0_add_q_sc_1/a_n1205_n937# VDD_3V3_1 pfet_06v0 ad=0 pd=0 as=11.664n ps=0.582m w=243 l=100
X55 5v0_add_q_sc_1/inv_nti 5v0_add_q_sc_1/nti VDD_3V3_1 VDD_3V3_1 pfet_06v0 ad=21.472n pd=0.664m as=0 ps=0 w=244 l=100
X56 VSS_3 5v0_add_q_sc_1/nti 5v0_add_q_sc_1/VDD_1V65 VSS_3 nfet_06v0 ad=0 pd=0 as=21.021n ps=0.58m w=147 l=120
X57 5v0_add_q_sc_1/a_n1205_n937# 5v0_add_q_sc_1/inv_pti VDD_3V3_1 VDD_3V3_1 pfet_06v0 ad=0 pd=0 as=0 ps=0 w=243 l=100
X58 5v0_add_q_sc_1/downstepper_test 5v0_add_q_sc_1/pti 5v0_add_q_sc_1/a_n1778_n454# VSS_3 nfet_06v0 ad=0 pd=0 as=7.056n ps=0.39m w=147 l=120
X59 5v0_add_q_sc_1/inv_nti 5v0_add_q_sc_1/nti VSS_3 VSS_3 nfet_06v0 ad=14.432n pd=0.504m as=0 ps=0 w=164 l=120
X60 5v0_add_q_sc_1/a_n1778_n454# 5v0_add_q_sc_1/inv_nti VSS_3 VSS_3 nfet_06v0 ad=0 pd=0 as=0 ps=0 w=147 l=120
X61 VSS_3 5v0_add_q_sc_1/inv_pti VSS_3 VSS_3 nfet_06v0 ad=0 pd=0 as=0 ps=0 w=164 l=120
X62 5v0_add_q_sc_1/VDD_1V65 5v0_add_q_sc_1/inv_pti 5v0_add_q_sc_1/a_n1373_n454# VSS_3 nfet_06v0 ad=0 pd=0 as=0 ps=0 w=147 l=120
X63 5v0_add_q_sc_1/downstepper_test 5v0_add_q_sc_1/inv_nti VDD_3V3_1 VDD_3V3_1 pfet_06v0 ad=0 pd=0 as=0 ps=0 w=243 l=100
X64 5v0_addh_sc_tile_2/ctrl_over 5v0_addh_sc_tile_2/ctrl_sign 5v0_nter2oter_code_sc_0/gf180mcu_fd_sc_mcu7t5v0__nor2_1_0/a_224_472# VDD_3V3_0 pfet_06v0 ad=21.472n pd=0.664m as=16.348n ps=0.378m w=244 l=100
X65 VSS_3 5v0_addh_sc_tile_2/ctrl_sign 5v0_addh_sc_tile_2/ctrl_over VSS_3 nfet_06v0 ad=9.944n pd=0.402m as=5.876n ps=0.217m w=113 l=120
X66 5v0_nter2oter_code_sc_0/gf180mcu_fd_sc_mcu7t5v0__nor2_1_0/a_224_472# 5v0_nter2oter_code_sc_0/nti VDD_3V3_0 VDD_3V3_0 pfet_06v0 ad=16.348n pd=0.378m as=20.932n ps=0.664m w=244 l=100
X67 5v0_addh_sc_tile_2/ctrl_over 5v0_nter2oter_code_sc_0/nti VSS_3 VSS_3 nfet_06v0 ad=5.876n pd=0.217m as=9.944n ps=0.402m w=113 l=120
X68 5v0_addh_sc_tile_2/ctrl_sign 5v0_nter2oter_code_sc_0/pti 5v0_nter2oter_code_sc_1/not_internal_0/a_36_68# VSS_3 nfet_06v0 ad=14.432n pd=0.504m as=14.433n ps=0.505m w=164 l=120
X69 5v0_addh_sc_tile_2/ctrl_sign 5v0_nter2oter_code_sc_0/pti 5v0_nter2oter_code_sc_1/not_internal_0/a_56_472# VDD_3V3_0 pfet_06v0 ad=21.472n pd=0.664m as=31.233n ps=0.745m w=244 l=100
X70 5v0_nter2oter_code_sc_0/pti 5v0_nter2oter_code_sc_0/in VSS_3 VSS_3 nfet_06v0 ad=6.336n pd=0.32m as=6.478n ps=0.255m w=72 l=578
X71 VDD_3V3_1 5v0_nter2oter_code_sc_0/in 5v0_nter2oter_code_sc_0/pti VDD_3V3_1 pfet_06v0 ad=12.81n pd=0.349m as=12.688n ps=0.348m w=244 l=100
X72 VDD_3V3_1 5v0_nter2oter_code_sc_0/in 5v0_nter2oter_code_sc_0/nti VDD_3V3_1 pfet_06v0 ad=13.616n pd=0.392m as=9.696n ps=0.394m w=96 l=150
X73 VSS_3 5v0_nter2oter_code_sc_0/in 5v0_nter2oter_code_sc_0/nti VSS_3 nfet_06v0 ad=6.478n pd=0.255m as=12.7n ps=0.454m w=127 l=120
X74 5v0_nter2oter_code_sc_0/pti 5v0_nter2oter_code_sc_0/in VDD_3V3_1 VDD_3V3_1 pfet_06v0 ad=12.688n pd=0.348m as=13.616n ps=0.392m w=244 l=100
X75 5v0_nter2oter_code_sc_0/pti 5v0_nter2oter_code_sc_0/in VDD_3V3_1 VDD_3V3_1 pfet_06v0 ad=27.328n pd=0.712m as=12.81n ps=0.349m w=244 l=100
X76 5v0_addh_sc_tile_1/ctrl_sign 5v0_addh_sc_tile_1/ctrl_over 5v0_nter2oter_code_sc_1/gf180mcu_fd_sc_mcu7t5v0__nor2_1_0/a_224_472# VDD_3V3_0 pfet_06v0 ad=21.472n pd=0.664m as=32.696n ps=0.756m w=244 l=100
X77 VSS_3 5v0_addh_sc_tile_1/ctrl_over 5v0_addh_sc_tile_1/ctrl_sign VSS_3 nfet_06v0 ad=0 pd=0 as=11.752n ps=0.434m w=113 l=120
X78 5v0_nter2oter_code_sc_1/gf180mcu_fd_sc_mcu7t5v0__nor2_1_0/a_224_472# 5v0_nter2oter_code_sc_1/nti VDD_3V3_0 VDD_3V3_0 pfet_06v0 ad=0 pd=0 as=0 ps=0 w=244 l=100
X79 5v0_addh_sc_tile_1/ctrl_sign 5v0_nter2oter_code_sc_1/nti VSS_3 VSS_3 nfet_06v0 ad=0 pd=0 as=0 ps=0 w=113 l=120
X80 5v0_addh_sc_tile_1/ctrl_over 5v0_nter2oter_code_sc_1/pti 5v0_nter2oter_code_sc_1/not_internal_0/a_36_68# VSS_3 nfet_06v0 ad=14.432n pd=0.504m as=0 ps=0 w=164 l=120
X81 5v0_addh_sc_tile_1/ctrl_over 5v0_nter2oter_code_sc_1/pti 5v0_nter2oter_code_sc_1/not_internal_0/a_56_472# VDD_3V3_0 pfet_06v0 ad=21.472n pd=0.664m as=0 ps=0 w=244 l=100
X82 5v0_nter2oter_code_sc_1/pti in_2 VSS_3 VSS_3 nfet_06v0 ad=6.336n pd=0.32m as=0 ps=0 w=72 l=578
X83 VDD_3V3_1 in_2 5v0_nter2oter_code_sc_1/pti VDD_3V3_1 pfet_06v0 ad=0 pd=0 as=52.704n ps=1.408m w=244 l=100
X84 VDD_3V3_1 in_2 5v0_nter2oter_code_sc_1/nti VDD_3V3_1 pfet_06v0 ad=0 pd=0 as=9.696n ps=0.394m w=96 l=150
X85 VSS_3 in_2 5v0_nter2oter_code_sc_1/nti VSS_3 nfet_06v0 ad=0 pd=0 as=12.7n ps=0.454m w=127 l=120
X86 5v0_nter2oter_code_sc_1/pti in_2 VDD_3V3_1 VDD_3V3_1 pfet_06v0 ad=0 pd=0 as=0 ps=0 w=244 l=100
X87 5v0_nter2oter_code_sc_1/pti in_2 VDD_3V3_1 VDD_3V3_1 pfet_06v0 ad=0 pd=0 as=0 ps=0 w=244 l=100
X88 m1_n2844_n810# 5v0_addh_sc_tile_0/carry_0_probe VSS_3 VSS_3 nfet_06v0 ad=14.432n pd=0.504m as=0 ps=0 w=164 l=120
X89 m1_n2844_n810# 5v0_addh_sc_tile_0/carry_0_probe VDD_3V3_1 VDD_3V3_1 pfet_06v0 ad=21.472n pd=0.664m as=0 ps=0 w=244 l=100
X90 5v0_addh_sc_tile_0/pti in_1 VSS_3 VSS_3 nfet_06v0 ad=20.768n pd=0.824m as=0 ps=0 w=72 l=578
X91 VDD_3V3_1 in_1 5v0_addh_sc_tile_0/pti VDD_3V3_1 pfet_06v0 ad=0 pd=0 as=74.176n ps=2.072m w=244 l=100
X92 VDD_3V3_1 in_1 5v0_addh_sc_tile_0/nti VDD_3V3_1 pfet_06v0 ad=0 pd=0 as=9.696n ps=0.394m w=96 l=150
X93 VSS_3 in_1 5v0_addh_sc_tile_0/nti VSS_3 nfet_06v0 ad=0 pd=0 as=12.7n ps=0.454m w=127 l=120
X94 5v0_addh_sc_tile_0/pti in_1 VDD_3V3_1 VDD_3V3_1 pfet_06v0 ad=0 pd=0 as=0 ps=0 w=244 l=100
X95 5v0_addh_sc_tile_0/pti in_1 VDD_3V3_1 VDD_3V3_1 pfet_06v0 ad=0 pd=0 as=0 ps=0 w=244 l=100
X96 5v0_addh_sc_tile_0/5v0_half_adder_selector_sc_0/res_stage0 5v0_addh_sc_tile_0/m1_103_293# 5v0_addh_sc_tile_0/downstepper_test VSS_3 nfet_06v0 ad=31.489n pd=1.041m as=31.631n ps=1.032m w=164 l=120
X97 5v0_addh_sc_tile_0/5v0_half_adder_selector_sc_0/res_stage0 5v0_addh_sc_tile_0/m1_103_293# 5v0_addh_sc_tile_0/upstepper_test VDD_3V3_1 pfet_06v0 ad=46.849n pd=1.361m as=42.856n ps=1.326m w=244 l=100
X98 5v0_addh_sc_tile_0/m1_103_293# in_0_sign VSS_3 VSS_3 nfet_06v0 ad=14.432n pd=0.504m as=0 ps=0 w=164 l=120
X99 5v0_addh_sc_tile_0/m1_103_293# in_0_sign VDD_3V3_1 VDD_3V3_1 pfet_06v0 ad=21.472n pd=0.664m as=0 ps=0 w=244 l=100
X100 5v0_addh_sc_tile_0/5v0_half_adder_selector_sc_0/res_stage0 in_0_sign 5v0_addh_sc_tile_0/upstepper_test VSS_3 nfet_06v0 ad=0 pd=0 as=43.711n ps=1.504m w=164 l=120
X101 5v0_addh_sc_tile_0/5v0_half_adder_selector_sc_0/res_stage0 in_0_sign 5v0_addh_sc_tile_0/downstepper_test VDD_3V3_1 pfet_06v0 ad=0 pd=0 as=42.856n ps=1.326m w=244 l=100
X102 5v0_addh_sc_tile_1/ternary_input 5v0_addh_sc_tile_0/a_382_n1095# 5v0_addh_sc_tile_0/5v0_half_adder_selector_sc_0/res_stage0 VSS_3 nfet_06v0 ad=31.489n pd=1.041m as=0 ps=0 w=164 l=120
X103 5v0_addh_sc_tile_1/ternary_input 5v0_addh_sc_tile_0/a_382_n1095# in_1 VDD_3V3_1 pfet_06v0 ad=46.849n pd=1.361m as=21.472n ps=0.664m w=244 l=100
X104 5v0_addh_sc_tile_0/a_382_n1095# in_0_over VSS_3 VSS_3 nfet_06v0 ad=14.432n pd=0.504m as=0 ps=0 w=164 l=120
X105 5v0_addh_sc_tile_0/a_382_n1095# in_0_over VDD_3V3_1 VDD_3V3_1 pfet_06v0 ad=21.472n pd=0.664m as=0 ps=0 w=244 l=100
X106 5v0_addh_sc_tile_1/ternary_input in_0_over in_1 VSS_3 nfet_06v0 ad=0 pd=0 as=14.432n ps=0.504m w=164 l=120
X107 5v0_addh_sc_tile_1/ternary_input in_0_over 5v0_addh_sc_tile_0/5v0_half_adder_selector_sc_0/res_stage0 VDD_3V3_1 pfet_06v0 ad=0 pd=0 as=0 ps=0 w=244 l=100
X108 5v0_addh_sc_tile_0/inv_pti 5v0_addh_sc_tile_0/pti 5v0_addh_sc_tile_0/not_internal_0/a_36_68# VSS_3 nfet_06v0 ad=28.864n pd=1.008m as=14.432n ps=0.504m w=164 l=120
X109 5v0_addh_sc_tile_0/inv_pti 5v0_addh_sc_tile_0/pti 5v0_addh_sc_tile_0/not_internal_0/a_56_472# VDD_3V3_1 pfet_06v0 ad=42.944n pd=1.328m as=21.472n ps=0.664m w=244 l=100
X110 5v0_addh_sc_tile_0/carry_0_probe 5v0_addh_sc_tile_0/a_382_n1095# 5v0_addh_sc_tile_0/m1_843_n857# VSS_3 nfet_06v0 ad=14.432n pd=0.504m as=14.432n ps=0.504m w=164 l=120
X111 5v0_addh_sc_tile_0/carry_0_probe in_0_over 5v0_addh_sc_tile_0/m1_843_n857# VDD_3V3_1 pfet_06v0 ad=21.472n pd=0.664m as=21.472n ps=0.664m w=244 l=100
X112 5v0_addh_sc_tile_0/inv_nti in_0_sign 5v0_addh_sc_tile_0/carry_sign_probe VDD_3V3_1 pfet_06v0 ad=21.472n pd=0.664m as=12.688n ps=0.348m w=244 l=100
X113 5v0_addh_sc_tile_0/carry_sign_probe 5v0_addh_sc_tile_0/m1_103_293# 5v0_addh_sc_tile_0/inv_nti VSS_3 nfet_06v0 ad=8.528n pd=0.268m as=14.432n ps=0.504m w=164 l=120
X114 5v0_addh_sc_tile_0/carry_sign_probe 5v0_addh_sc_tile_0/m1_103_293# 5v0_addh_sc_tile_0/inv_pti VDD_3V3_1 pfet_06v0 ad=12.688n pd=0.348m as=21.472n ps=0.664m w=244 l=100
X115 5v0_addh_sc_tile_0/inv_pti in_0_sign 5v0_addh_sc_tile_0/carry_sign_probe VSS_3 nfet_06v0 ad=14.432n pd=0.504m as=8.528n ps=0.268m w=164 l=120
X116 5v0_addh_sc_tile_0/inv_nti in_0_sign 5v0_addh_sc_tile_0/m1_843_n857# VDD_3V3_1 pfet_06v0 ad=64.416n pd=1.992m as=46.848n ps=1.36m w=244 l=100
X117 5v0_addh_sc_tile_0/m1_843_n857# 5v0_addh_sc_tile_0/m1_103_293# 5v0_addh_sc_tile_0/inv_nti VSS_3 nfet_06v0 ad=31.488n pd=1.04m as=43.296n ps=1.512m w=164 l=120
X118 5v0_addh_sc_tile_0/m1_843_n857# 5v0_addh_sc_tile_0/m1_103_293# 5v0_addh_sc_tile_0/pti VDD_3V3_1 pfet_06v0 ad=0 pd=0 as=0 ps=0 w=244 l=100
X119 5v0_addh_sc_tile_0/pti in_0_sign 5v0_addh_sc_tile_0/m1_843_n857# VSS_3 nfet_06v0 ad=0 pd=0 as=0 ps=0 w=164 l=120
X120 5v0_addh_sc_tile_0/a_n1373_n454# 5v0_addh_sc_tile_0/inv_nti 5v0_addh_sc_tile_0/downstepper_test VSS_3 nfet_06v0 ad=3.528n pd=0.195m as=8.599n ps=0.264m w=147 l=120
X121 5v0_addh_sc_tile_0/upstepper_test 5v0_addh_sc_tile_0/nti 5v0_addh_sc_tile_0/a_n1205_n937# VDD_3V3_1 pfet_06v0 ad=21.384n pd=0.662m as=5.832n ps=0.291m w=243 l=100
X122 5v0_addh_sc_tile_0/inv_nti 5v0_addh_sc_tile_0/nti VDD_3V3_1 VDD_3V3_1 pfet_06v0 ad=21.472n pd=0.664m as=21.472n ps=0.664m w=244 l=100
X123 5v0_addh_sc_tile_0/upstepper_test 5v0_addh_sc_tile_0/nti VDD_1V65_0 VSS_3 nfet_06v0 ad=14.847n pd=0.496m as=10.51n ps=0.29m w=147 l=120
X124 5v0_addh_sc_tile_0/carry_0_probe 5v0_addh_sc_tile_0/a_382_n1095# VDD_3V3_1 VDD_3V3_1 pfet_06v0 ad=21.472n pd=0.664m as=21.472n ps=0.664m w=244 l=100
X125 5v0_addh_sc_tile_0/a_n1205_n937# 5v0_addh_sc_tile_0/inv_pti VDD_3V3_1 VDD_3V3_1 pfet_06v0 ad=5.832n pd=0.291m as=21.384n ps=0.662m w=243 l=100
X126 5v0_addh_sc_tile_0/downstepper_test 5v0_addh_sc_tile_0/pti 5v0_addh_sc_tile_0/a_n1778_n454# VSS_3 nfet_06v0 ad=8.599n pd=0.264m as=3.528n ps=0.195m w=147 l=120
X127 5v0_addh_sc_tile_0/inv_nti 5v0_addh_sc_tile_0/nti VSS_3 VSS_3 nfet_06v0 ad=14.432n pd=0.504m as=14.432n ps=0.504m w=164 l=120
X128 5v0_addh_sc_tile_0/a_n1778_n454# 5v0_addh_sc_tile_0/inv_nti VSS_3 VSS_3 nfet_06v0 ad=3.528n pd=0.195m as=14.847n ps=0.496m w=147 l=120
X129 5v0_addh_sc_tile_0/upstepper_test 5v0_addh_sc_tile_0/inv_pti VSS_3 VSS_3 nfet_06v0 ad=14.432n pd=0.504m as=14.432n ps=0.504m w=164 l=120
X130 VDD_1V65_0 5v0_addh_sc_tile_0/inv_pti 5v0_addh_sc_tile_0/a_n1373_n454# VSS_3 nfet_06v0 ad=10.51n pd=0.29m as=3.528n ps=0.195m w=147 l=120
X131 5v0_addh_sc_tile_0/downstepper_test 5v0_addh_sc_tile_0/inv_nti VDD_3V3_1 VDD_3V3_1 pfet_06v0 ad=21.384n pd=0.662m as=21.384n ps=0.662m w=243 l=100
X132 5v0_addh_sc_tile_1/pti 5v0_addh_sc_tile_1/ternary_input VSS_3 VSS_3 nfet_06v0 ad=20.768n pd=0.824m as=0 ps=0 w=72 l=578
X133 VDD_3V3_1 5v0_addh_sc_tile_1/ternary_input 5v0_addh_sc_tile_1/pti VDD_3V3_1 pfet_06v0 ad=0 pd=0 as=74.176n ps=2.072m w=244 l=100
X134 VDD_3V3_1 5v0_addh_sc_tile_1/ternary_input 5v0_addh_sc_tile_1/nti VDD_3V3_1 pfet_06v0 ad=0 pd=0 as=9.696n ps=0.394m w=96 l=150
X135 VSS_3 5v0_addh_sc_tile_1/ternary_input 5v0_addh_sc_tile_1/nti VSS_3 nfet_06v0 ad=0 pd=0 as=12.7n ps=0.454m w=127 l=120
X136 5v0_addh_sc_tile_1/pti 5v0_addh_sc_tile_1/ternary_input VDD_3V3_1 VDD_3V3_1 pfet_06v0 ad=0 pd=0 as=0 ps=0 w=244 l=100
X137 5v0_addh_sc_tile_1/pti 5v0_addh_sc_tile_1/ternary_input VDD_3V3_1 VDD_3V3_1 pfet_06v0 ad=0 pd=0 as=0 ps=0 w=244 l=100
X138 5v0_addh_sc_tile_1/5v0_half_adder_selector_sc_0/res_stage0 5v0_addh_sc_tile_1/m1_103_293# 5v0_addh_sc_tile_1/downstepper_test VSS_3 nfet_06v0 ad=31.489n pd=1.041m as=31.631n ps=1.032m w=164 l=120
X139 5v0_addh_sc_tile_1/5v0_half_adder_selector_sc_0/res_stage0 5v0_addh_sc_tile_1/m1_103_293# 5v0_addh_sc_tile_1/upstepper_test VDD_3V3_1 pfet_06v0 ad=46.849n pd=1.361m as=42.856n ps=1.326m w=244 l=100
X140 5v0_addh_sc_tile_1/m1_103_293# 5v0_addh_sc_tile_1/ctrl_sign VSS_3 VSS_3 nfet_06v0 ad=14.432n pd=0.504m as=0 ps=0 w=164 l=120
X141 5v0_addh_sc_tile_1/m1_103_293# 5v0_addh_sc_tile_1/ctrl_sign VDD_3V3_1 VDD_3V3_1 pfet_06v0 ad=21.472n pd=0.664m as=0 ps=0 w=244 l=100
X142 5v0_addh_sc_tile_1/5v0_half_adder_selector_sc_0/res_stage0 5v0_addh_sc_tile_1/ctrl_sign 5v0_addh_sc_tile_1/upstepper_test VSS_3 nfet_06v0 ad=0 pd=0 as=43.711n ps=1.504m w=164 l=120
X143 5v0_addh_sc_tile_1/5v0_half_adder_selector_sc_0/res_stage0 5v0_addh_sc_tile_1/ctrl_sign 5v0_addh_sc_tile_1/downstepper_test VDD_3V3_1 pfet_06v0 ad=0 pd=0 as=42.856n ps=1.326m w=244 l=100
X144 5v0_nter2oter_code_sc_0/in 5v0_addh_sc_tile_1/a_382_n1095# 5v0_addh_sc_tile_1/5v0_half_adder_selector_sc_0/res_stage0 VSS_3 nfet_06v0 ad=17.057n pd=0.537m as=0 ps=0 w=164 l=120
X145 5v0_nter2oter_code_sc_0/in 5v0_addh_sc_tile_1/a_382_n1095# 5v0_addh_sc_tile_1/ternary_input VDD_3V3_0 pfet_06v0 ad=25.377n pd=0.697m as=0 ps=0 w=244 l=100
X146 5v0_addh_sc_tile_1/a_382_n1095# 5v0_addh_sc_tile_1/ctrl_over VSS_3 VSS_3 nfet_06v0 ad=14.432n pd=0.504m as=0 ps=0 w=164 l=120
X147 5v0_addh_sc_tile_1/a_382_n1095# 5v0_addh_sc_tile_1/ctrl_over VDD_3V3_0 VDD_3V3_0 pfet_06v0 ad=21.472n pd=0.664m as=0 ps=0 w=244 l=100
X148 5v0_nter2oter_code_sc_0/in 5v0_addh_sc_tile_1/ctrl_over 5v0_addh_sc_tile_1/ternary_input VSS_3 nfet_06v0 ad=0 pd=0 as=0 ps=0 w=164 l=120
X149 5v0_nter2oter_code_sc_0/in 5v0_addh_sc_tile_1/ctrl_over 5v0_addh_sc_tile_1/5v0_half_adder_selector_sc_0/res_stage0 VDD_3V3_0 pfet_06v0 ad=0 pd=0 as=0 ps=0 w=244 l=100
X150 5v0_addh_sc_tile_1/inv_pti 5v0_addh_sc_tile_1/pti 5v0_addh_sc_tile_1/not_internal_0/a_36_68# VSS_3 nfet_06v0 ad=28.864n pd=1.008m as=14.432n ps=0.504m w=164 l=120
X151 5v0_addh_sc_tile_1/inv_pti 5v0_addh_sc_tile_1/pti 5v0_addh_sc_tile_1/not_internal_0/a_56_472# VDD_3V3_1 pfet_06v0 ad=42.944n pd=1.328m as=21.472n ps=0.664m w=244 l=100
X152 5v0_add_q_sc_1/ctrl_over 5v0_addh_sc_tile_1/a_382_n1095# 5v0_addh_sc_tile_1/m1_843_n857# VSS_3 nfet_06v0 ad=14.432n pd=0.504m as=31.488n ps=1.04m w=164 l=120
X153 5v0_add_q_sc_1/ctrl_over 5v0_addh_sc_tile_1/ctrl_over 5v0_addh_sc_tile_1/m1_843_n857# VDD_3V3_0 pfet_06v0 ad=42.944n pd=1.328m as=46.848n ps=1.36m w=244 l=100
X154 5v0_addh_sc_tile_1/inv_nti 5v0_addh_sc_tile_1/ctrl_sign 5v0_add_q_sc_1/ctrl_sign VDD_3V3_1 pfet_06v0 ad=64.416n pd=1.992m as=25.376n ps=0.696m w=244 l=100
X155 5v0_add_q_sc_1/ctrl_sign 5v0_addh_sc_tile_1/m1_103_293# 5v0_addh_sc_tile_1/inv_nti VSS_3 nfet_06v0 ad=17.056n pd=0.536m as=43.296n ps=1.512m w=164 l=120
X156 5v0_add_q_sc_1/ctrl_sign 5v0_addh_sc_tile_1/m1_103_293# 5v0_addh_sc_tile_1/inv_pti VDD_3V3_1 pfet_06v0 ad=0 pd=0 as=0 ps=0 w=244 l=100
X157 5v0_addh_sc_tile_1/inv_pti 5v0_addh_sc_tile_1/ctrl_sign 5v0_add_q_sc_1/ctrl_sign VSS_3 nfet_06v0 ad=0 pd=0 as=0 ps=0 w=164 l=120
X158 5v0_addh_sc_tile_1/inv_nti 5v0_addh_sc_tile_1/ctrl_sign 5v0_addh_sc_tile_1/m1_843_n857# VDD_3V3_0 pfet_06v0 ad=0 pd=0 as=0 ps=0 w=244 l=100
X159 5v0_addh_sc_tile_1/m1_843_n857# 5v0_addh_sc_tile_1/m1_103_293# 5v0_addh_sc_tile_1/inv_nti VSS_3 nfet_06v0 ad=0 pd=0 as=0 ps=0 w=164 l=120
X160 5v0_addh_sc_tile_1/m1_843_n857# 5v0_addh_sc_tile_1/m1_103_293# 5v0_addh_sc_tile_1/pti VDD_3V3_0 pfet_06v0 ad=0 pd=0 as=0 ps=0 w=244 l=100
X161 5v0_addh_sc_tile_1/pti 5v0_addh_sc_tile_1/ctrl_sign 5v0_addh_sc_tile_1/m1_843_n857# VSS_3 nfet_06v0 ad=0 pd=0 as=0 ps=0 w=164 l=120
X162 5v0_addh_sc_tile_1/a_n1373_n454# 5v0_addh_sc_tile_1/inv_nti 5v0_addh_sc_tile_1/downstepper_test VSS_3 nfet_06v0 ad=7.056n pd=0.39m as=0 ps=0 w=147 l=120
X163 5v0_addh_sc_tile_1/upstepper_test 5v0_addh_sc_tile_1/nti 5v0_addh_sc_tile_1/a_n1205_n937# VDD_3V3_0 pfet_06v0 ad=0 pd=0 as=11.664n ps=0.582m w=243 l=100
X164 5v0_addh_sc_tile_1/inv_nti 5v0_addh_sc_tile_1/nti VDD_3V3_0 VDD_3V3_0 pfet_06v0 ad=0 pd=0 as=0 ps=0 w=244 l=100
X165 5v0_addh_sc_tile_1/upstepper_test 5v0_addh_sc_tile_1/nti VDD_1V65_3 VSS_3 nfet_06v0 ad=0 pd=0 as=21.021n ps=0.58m w=147 l=120
X166 5v0_add_q_sc_1/ctrl_over 5v0_addh_sc_tile_1/a_382_n1095# VDD_3V3_0 VDD_3V3_0 pfet_06v0 ad=0 pd=0 as=0 ps=0 w=244 l=100
X167 5v0_addh_sc_tile_1/a_n1205_n937# 5v0_addh_sc_tile_1/inv_pti VDD_3V3_0 VDD_3V3_0 pfet_06v0 ad=0 pd=0 as=0 ps=0 w=243 l=100
X168 5v0_addh_sc_tile_1/downstepper_test 5v0_addh_sc_tile_1/pti 5v0_addh_sc_tile_1/a_n1778_n454# VSS_3 nfet_06v0 ad=0 pd=0 as=7.056n ps=0.39m w=147 l=120
X169 5v0_addh_sc_tile_1/inv_nti 5v0_addh_sc_tile_1/nti VSS_3 VSS_3 nfet_06v0 ad=0 pd=0 as=0 ps=0 w=164 l=120
X170 5v0_addh_sc_tile_1/a_n1778_n454# 5v0_addh_sc_tile_1/inv_nti VSS_3 VSS_3 nfet_06v0 ad=0 pd=0 as=0 ps=0 w=147 l=120
X171 5v0_addh_sc_tile_1/upstepper_test 5v0_addh_sc_tile_1/inv_pti VSS_3 VSS_3 nfet_06v0 ad=0 pd=0 as=0 ps=0 w=164 l=120
X172 VDD_1V65_3 5v0_addh_sc_tile_1/inv_pti 5v0_addh_sc_tile_1/a_n1373_n454# VSS_3 nfet_06v0 ad=0 pd=0 as=0 ps=0 w=147 l=120
X173 5v0_addh_sc_tile_1/downstepper_test 5v0_addh_sc_tile_1/inv_nti VDD_3V3_0 VDD_3V3_0 pfet_06v0 ad=0 pd=0 as=0 ps=0 w=243 l=100
X174 5v0_addh_sc_tile_2/pti in_3 VSS_3 VSS_3 nfet_06v0 ad=20.768n pd=0.824m as=0 ps=0 w=72 l=578
X175 VDD_3V3_0 in_3 5v0_addh_sc_tile_2/pti VDD_3V3_0 pfet_06v0 ad=0 pd=0 as=74.176n ps=2.072m w=244 l=100
X176 VDD_3V3_0 in_3 5v0_addh_sc_tile_2/nti VDD_3V3_0 pfet_06v0 ad=0 pd=0 as=9.696n ps=0.394m w=96 l=150
X177 VSS_3 in_3 5v0_addh_sc_tile_2/nti VSS_3 nfet_06v0 ad=0 pd=0 as=12.7n ps=0.454m w=127 l=120
X178 5v0_addh_sc_tile_2/pti in_3 VDD_3V3_0 VDD_3V3_0 pfet_06v0 ad=0 pd=0 as=0 ps=0 w=244 l=100
X179 5v0_addh_sc_tile_2/pti in_3 VDD_3V3_0 VDD_3V3_0 pfet_06v0 ad=0 pd=0 as=0 ps=0 w=244 l=100
X180 5v0_addh_sc_tile_2/5v0_half_adder_selector_sc_0/res_stage0 5v0_addh_sc_tile_2/m1_103_293# 5v0_addh_sc_tile_2/downstepper_test VSS_3 nfet_06v0 ad=31.489n pd=1.041m as=31.631n ps=1.032m w=164 l=120
X181 5v0_addh_sc_tile_2/5v0_half_adder_selector_sc_0/res_stage0 5v0_addh_sc_tile_2/m1_103_293# 5v0_addh_sc_tile_2/upstepper_test VDD_3V3_0 pfet_06v0 ad=46.849n pd=1.361m as=42.856n ps=1.326m w=244 l=100
X182 5v0_addh_sc_tile_2/m1_103_293# 5v0_addh_sc_tile_2/ctrl_sign VSS_3 VSS_3 nfet_06v0 ad=14.432n pd=0.504m as=0 ps=0 w=164 l=120
X183 5v0_addh_sc_tile_2/m1_103_293# 5v0_addh_sc_tile_2/ctrl_sign VDD_3V3_0 VDD_3V3_0 pfet_06v0 ad=21.472n pd=0.664m as=0 ps=0 w=244 l=100
X184 5v0_addh_sc_tile_2/5v0_half_adder_selector_sc_0/res_stage0 5v0_addh_sc_tile_2/ctrl_sign 5v0_addh_sc_tile_2/upstepper_test VSS_3 nfet_06v0 ad=0 pd=0 as=43.711n ps=1.504m w=164 l=120
X185 5v0_addh_sc_tile_2/5v0_half_adder_selector_sc_0/res_stage0 5v0_addh_sc_tile_2/ctrl_sign 5v0_addh_sc_tile_2/downstepper_test VDD_3V3_0 pfet_06v0 ad=0 pd=0 as=42.856n ps=1.326m w=244 l=100
X186 res_0 5v0_addh_sc_tile_2/a_382_n1095# 5v0_addh_sc_tile_2/5v0_half_adder_selector_sc_0/res_stage0 VSS_3 nfet_06v0 ad=17.057n pd=0.537m as=0 ps=0 w=164 l=120
X187 res_0 5v0_addh_sc_tile_2/a_382_n1095# in_3 VDD_3V3_0 pfet_06v0 ad=25.377n pd=0.697m as=21.472n ps=0.664m w=244 l=100
X188 5v0_addh_sc_tile_2/a_382_n1095# 5v0_addh_sc_tile_2/ctrl_over VSS_3 VSS_3 nfet_06v0 ad=14.432n pd=0.504m as=0 ps=0 w=164 l=120
X189 5v0_addh_sc_tile_2/a_382_n1095# 5v0_addh_sc_tile_2/ctrl_over VDD_3V3_0 VDD_3V3_0 pfet_06v0 ad=21.472n pd=0.664m as=0 ps=0 w=244 l=100
X190 res_0 5v0_addh_sc_tile_2/ctrl_over in_3 VSS_3 nfet_06v0 ad=0 pd=0 as=14.432n ps=0.504m w=164 l=120
X191 res_0 5v0_addh_sc_tile_2/ctrl_over 5v0_addh_sc_tile_2/5v0_half_adder_selector_sc_0/res_stage0 VDD_3V3_0 pfet_06v0 ad=0 pd=0 as=0 ps=0 w=244 l=100
X192 5v0_addh_sc_tile_2/inv_pti 5v0_addh_sc_tile_2/pti 5v0_addh_sc_tile_2/not_internal_0/a_36_68# VSS_3 nfet_06v0 ad=28.864n pd=1.008m as=14.432n ps=0.504m w=164 l=120
X193 5v0_addh_sc_tile_2/inv_pti 5v0_addh_sc_tile_2/pti 5v0_addh_sc_tile_2/not_internal_0/a_56_472# VDD_3V3_0 pfet_06v0 ad=42.944n pd=1.328m as=21.472n ps=0.664m w=244 l=100
X194 5v0_add_q_sc_0/ctrl_over 5v0_addh_sc_tile_2/a_382_n1095# 5v0_addh_sc_tile_2/m1_843_n857# VSS_3 nfet_06v0 ad=14.432n pd=0.504m as=31.488n ps=1.04m w=164 l=120
X195 5v0_add_q_sc_0/ctrl_over 5v0_addh_sc_tile_2/ctrl_over 5v0_addh_sc_tile_2/m1_843_n857# VDD_3V3_0 pfet_06v0 ad=42.944n pd=1.328m as=46.848n ps=1.36m w=244 l=100
X196 5v0_addh_sc_tile_2/inv_nti 5v0_addh_sc_tile_2/ctrl_sign 5v0_add_q_sc_0/ctrl_sign VDD_3V3_0 pfet_06v0 ad=64.416n pd=1.992m as=25.376n ps=0.696m w=244 l=100
X197 5v0_add_q_sc_0/ctrl_sign 5v0_addh_sc_tile_2/m1_103_293# 5v0_addh_sc_tile_2/inv_nti VSS_3 nfet_06v0 ad=17.056n pd=0.536m as=43.296n ps=1.512m w=164 l=120
X198 5v0_add_q_sc_0/ctrl_sign 5v0_addh_sc_tile_2/m1_103_293# 5v0_addh_sc_tile_2/inv_pti VDD_3V3_0 pfet_06v0 ad=0 pd=0 as=0 ps=0 w=244 l=100
X199 5v0_addh_sc_tile_2/inv_pti 5v0_addh_sc_tile_2/ctrl_sign 5v0_add_q_sc_0/ctrl_sign VSS_3 nfet_06v0 ad=0 pd=0 as=0 ps=0 w=164 l=120
X200 5v0_addh_sc_tile_2/inv_nti 5v0_addh_sc_tile_2/ctrl_sign 5v0_addh_sc_tile_2/m1_843_n857# VDD_3V3_0 pfet_06v0 ad=0 pd=0 as=0 ps=0 w=244 l=100
X201 5v0_addh_sc_tile_2/m1_843_n857# 5v0_addh_sc_tile_2/m1_103_293# 5v0_addh_sc_tile_2/inv_nti VSS_3 nfet_06v0 ad=0 pd=0 as=0 ps=0 w=164 l=120
X202 5v0_addh_sc_tile_2/m1_843_n857# 5v0_addh_sc_tile_2/m1_103_293# 5v0_addh_sc_tile_2/pti VDD_3V3_0 pfet_06v0 ad=0 pd=0 as=0 ps=0 w=244 l=100
X203 5v0_addh_sc_tile_2/pti 5v0_addh_sc_tile_2/ctrl_sign 5v0_addh_sc_tile_2/m1_843_n857# VSS_3 nfet_06v0 ad=0 pd=0 as=0 ps=0 w=164 l=120
X204 5v0_addh_sc_tile_2/a_n1373_n454# 5v0_addh_sc_tile_2/inv_nti 5v0_addh_sc_tile_2/downstepper_test VSS_3 nfet_06v0 ad=7.056n pd=0.39m as=0 ps=0 w=147 l=120
X205 5v0_addh_sc_tile_2/upstepper_test 5v0_addh_sc_tile_2/nti 5v0_addh_sc_tile_2/a_n1205_n937# VDD_3V3_0 pfet_06v0 ad=0 pd=0 as=11.664n ps=0.582m w=243 l=100
X206 5v0_addh_sc_tile_2/inv_nti 5v0_addh_sc_tile_2/nti VDD_3V3_0 VDD_3V3_0 pfet_06v0 ad=0 pd=0 as=0 ps=0 w=244 l=100
X207 5v0_addh_sc_tile_2/upstepper_test 5v0_addh_sc_tile_2/nti VDD_1V65_4 VSS_3 nfet_06v0 ad=0 pd=0 as=21.021n ps=0.58m w=147 l=120
X208 5v0_add_q_sc_0/ctrl_over 5v0_addh_sc_tile_2/a_382_n1095# VDD_3V3_0 VDD_3V3_0 pfet_06v0 ad=0 pd=0 as=0 ps=0 w=244 l=100
X209 5v0_addh_sc_tile_2/a_n1205_n937# 5v0_addh_sc_tile_2/inv_pti VDD_3V3_0 VDD_3V3_0 pfet_06v0 ad=0 pd=0 as=0 ps=0 w=243 l=100
X210 5v0_addh_sc_tile_2/downstepper_test 5v0_addh_sc_tile_2/pti 5v0_addh_sc_tile_2/a_n1778_n454# VSS_3 nfet_06v0 ad=0 pd=0 as=7.056n ps=0.39m w=147 l=120
X211 5v0_addh_sc_tile_2/inv_nti 5v0_addh_sc_tile_2/nti VSS_3 VSS_3 nfet_06v0 ad=0 pd=0 as=0 ps=0 w=164 l=120
X212 5v0_addh_sc_tile_2/a_n1778_n454# 5v0_addh_sc_tile_2/inv_nti VSS_3 VSS_3 nfet_06v0 ad=0 pd=0 as=0 ps=0 w=147 l=120
X213 5v0_addh_sc_tile_2/upstepper_test 5v0_addh_sc_tile_2/inv_pti VSS_3 VSS_3 nfet_06v0 ad=0 pd=0 as=0 ps=0 w=164 l=120
X214 VDD_1V65_4 5v0_addh_sc_tile_2/inv_pti 5v0_addh_sc_tile_2/a_n1373_n454# VSS_3 nfet_06v0 ad=0 pd=0 as=0 ps=0 w=147 l=120
X215 5v0_addh_sc_tile_2/downstepper_test 5v0_addh_sc_tile_2/inv_nti VDD_3V3_0 VDD_3V3_0 pfet_06v0 ad=0 pd=0 as=0 ps=0 w=243 l=100
C0 5v0_add_q_sc_1/nti 5v0_add_q_sc_1/a_n1373_n454# 0
C1 5v0_addh_sc_tile_0/upstepper_test 5v0_addh_sc_tile_1/ctrl_sign 0
C2 VDD_1V65_5 5v0_add_q_sc_0/downstepper_test 0.13024f
C3 5v0_addh_sc_tile_0/carry_0_probe 5v0_addh_sc_tile_1/inv_nti 0
C4 5v0_nter2oter_code_sc_1/not_internal_0/a_36_68# 5v0_addh_sc_tile_0/inv_nti 0
C5 5v0_addh_sc_tile_1/m1_843_n857# 5v0_add_q_sc_0/upstepper_test 0.0015f
C6 5v0_addh_sc_tile_0/5v0_half_adder_selector_sc_0/res_stage0 5v0_addh_sc_tile_0/5v0_half_adder_selector_sc_0/5v0_tgate_sel_2_sc_1/input_A 0.00253f
C7 5v0_add_q_sc_0/pti 5v0_add_q_sc_0/a_n1778_n454# 0.00135f
C8 5v0_addh_sc_tile_2/ctrl_sign 5v0_addh_sc_tile_1/downstepper_test 0.00468f
C9 5v0_add_q_sc_0/ternary_input 5v0_add_q_sc_0/a_n1373_n454# 0.00136f
C10 res_c 5v0_add_q_sc_0/5v0_half_adder_selector_sc_0/m1_n244_n517# 0.16119f
C11 5v0_add_q_sc_1/a_n1373_n454# 5v0_add_q_sc_1/downstepper_test 0.00442f
C12 5v0_addh_sc_tile_2/downstepper_test 5v0_nter2oter_code_sc_1/pti 0
C13 5v0_addh_sc_tile_0/carry_sign_probe 5v0_add_q_sc_1/pti 0
C14 5v0_addh_sc_tile_2/a_n1373_n454# 5v0_addh_sc_tile_2/downstepper_test 0.00442f
C15 5v0_add_q_sc_1/ternary_input 5v0_add_q_sc_1/inv_pti 0.08427f
C16 5v0_addh_sc_tile_2/ctrl_sign 5v0_addh_sc_tile_2/m1_843_n857# 0.24363f
C17 5v0_addh_sc_tile_2/downstepper_test 5v0_addh_sc_tile_2/a_382_n1095# 0.00679f
C18 5v0_add_q_sc_0/nti 5v0_addh_sc_tile_1/a_382_n1095# 0
C19 5v0_addh_sc_tile_1/ternary_input VDD_1V65_3 0.01451f
C20 5v0_addh_sc_tile_2/ctrl_sign VDD_3V3_0 1.49327f
C21 5v0_add_q_sc_1/ternary_input 5v0_addh_sc_tile_0/inv_nti 0.001f
C22 5v0_addh_sc_tile_1/ctrl_over in_3 0
C23 5v0_add_q_sc_0/nti 5v0_addh_sc_tile_1/pti 0
C24 5v0_addh_sc_tile_1/inv_nti 5v0_add_q_sc_0/upstepper_test 0.00109f
C25 VDD_3V3_1 5v0_add_q_sc_1/ternary_input 1.22842f
C26 5v0_add_q_sc_1/nti 5v0_addh_sc_tile_1/inv_nti 0
C27 5v0_addh_sc_tile_1/upstepper_test 5v0_addh_sc_tile_1/ctrl_sign 0.10431f
C28 5v0_addh_sc_tile_0/downstepper_test 5v0_addh_sc_tile_0/5v0_half_adder_selector_sc_0/5v0_tgate_sel_2_sc_1/input_A 0
C29 5v0_addh_sc_tile_1/ternary_input 5v0_nter2oter_code_sc_1/nti 0.01205f
C30 5v0_addh_sc_tile_1/inv_nti 5v0_addh_sc_tile_1/a_n1778_n454# 0.00226f
C31 5v0_nter2oter_code_sc_0/pti 5v0_addh_sc_tile_2/pti 0
C32 5v0_add_q_sc_1/ternary_input 5v0_add_q_sc_1/ctrl_over 0.24448f
C33 5v0_nter2oter_code_sc_1/nti in_2 0.2015f
C34 5v0_addh_sc_tile_1/nti 5v0_nter2oter_code_sc_1/pti 0
C35 in_0_over 5v0_addh_sc_tile_0/5v0_half_adder_selector_sc_0/5v0_tgate_sel_2_sc_1/input_A 0.04656f
C36 5v0_addh_sc_tile_2/a_n1778_n454# 5v0_addh_sc_tile_2/downstepper_test 0.0031f
C37 in_3 5v0_addh_sc_tile_2/nti 0.52138f
C38 VDD_1V65_5 5v0_add_q_sc_0/a_n1373_n454# 0.00232f
C39 5v0_add_q_sc_0/pti 5v0_add_q_sc_1/ctrl_over 0.00513f
C40 5v0_addh_sc_tile_1/inv_nti 5v0_add_q_sc_1/downstepper_test 0.00441f
C41 5v0_addh_sc_tile_1/nti 5v0_addh_sc_tile_2/a_382_n1095# 0
C42 5v0_addh_sc_tile_1/upstepper_test 5v0_addh_sc_tile_0/m1_843_n857# 0.00724f
C43 5v0_add_q_sc_0/a_n1205_n937# 5v0_add_q_sc_0/upstepper_test 0.00334f
C44 5v0_addh_sc_tile_0/carry_0_probe 5v0_add_q_sc_1/ternary_input 0.23005f
C45 5v0_addh_sc_tile_1/ternary_input 5v0_addh_sc_tile_0/m1_103_293# 0
C46 5v0_addh_sc_tile_1/a_382_n1095# 5v0_add_q_sc_0/5v0_half_adder_selector_sc_0/res_stage0 0.00175f
C47 5v0_addh_sc_tile_0/pti 5v0_addh_sc_tile_0/m1_103_293# 0.10002f
C48 5v0_addh_sc_tile_1/inv_nti in_0_over 0
C49 5v0_addh_sc_tile_1/ctrl_sign 5v0_add_q_sc_1/inv_nti 0
C50 5v0_addh_sc_tile_1/upstepper_test 5v0_addh_sc_tile_2/ctrl_sign 0
C51 5v0_addh_sc_tile_1/ctrl_over 5v0_addh_sc_tile_0/nti 0
C52 5v0_addh_sc_tile_1/ternary_input 5v0_add_q_sc_0/ctrl_over 0
C53 5v0_addh_sc_tile_0/a_n1205_n937# 5v0_addh_sc_tile_0/upstepper_test 0.00334f
C54 5v0_addh_sc_tile_2/pti 5v0_add_q_sc_0/5v0_half_adder_selector_sc_0/res_stage0 0
C55 5v0_addh_sc_tile_2/upstepper_test VDD_3V3_0 0.46497f
C56 5v0_addh_sc_tile_1/inv_pti 5v0_addh_sc_tile_1/m1_843_n857# 0
C57 5v0_add_q_sc_1/ctrl_sign 5v0_add_q_sc_0/ternary_input 0.00413f
C58 5v0_addh_sc_tile_2/inv_pti 5v0_addh_sc_tile_1/inv_nti 0
C59 5v0_addh_sc_tile_0/downstepper_test 5v0_nter2oter_code_sc_1/not_internal_0/a_36_68# 0
C60 5v0_addh_sc_tile_0/pti 5v0_addh_sc_tile_0/carry_sign_probe 0.01168f
C61 5v0_add_q_sc_0/inv_nti 5v0_add_q_sc_0/ternary_input 0.02537f
C62 m1_n2844_n810# 5v0_addh_sc_tile_1/m1_103_293# 0
C63 5v0_addh_sc_tile_1/inv_nti 5v0_addh_sc_tile_2/m1_103_293# 0.00513f
C64 5v0_add_q_sc_1/nti 5v0_add_q_sc_1/ternary_input 0.68929f
C65 5v0_addh_sc_tile_1/a_382_n1095# 5v0_add_q_sc_0/downstepper_test 0.00203f
C66 VDD_3V3_0 5v0_addh_sc_tile_1/downstepper_test 0.41853f
C67 5v0_add_q_sc_0/pti 5v0_add_q_sc_0/upstepper_test 0
C68 5v0_add_q_sc_0/nti 5v0_addh_sc_tile_2/ctrl_over 0
C69 5v0_addh_sc_tile_2/ctrl_over 5v0_nter2oter_code_sc_0/pti 0.00118f
C70 5v0_nter2oter_code_sc_1/nti 5v0_addh_sc_tile_0/inv_nti 0.00218f
C71 5v0_addh_sc_tile_1/ternary_input 5v0_addh_sc_tile_1/a_n1373_n454# 0.00163f
C72 5v0_addh_sc_tile_0/5v0_half_adder_selector_sc_0/5v0_tgate_sel_2_sc_1/input_A in_0_sign 0
C73 5v0_addh_sc_tile_2/inv_nti 5v0_addh_sc_tile_1/inv_nti 0
C74 5v0_add_q_sc_1/ctrl_sign VDD_1V65_2 0.00149f
C75 5v0_addh_sc_tile_2/m1_843_n857# VDD_3V3_0 0.17677f
C76 VDD_3V3_1 5v0_nter2oter_code_sc_1/nti 0.06976f
C77 5v0_add_q_sc_1/ternary_input 5v0_add_q_sc_1/downstepper_test 0.16195f
C78 m1_n2844_n810# 5v0_addh_sc_tile_0/a_382_n1095# 0.04011f
C79 5v0_addh_sc_tile_1/a_382_n1095# 5v0_add_q_sc_0/5v0_half_adder_selector_sc_0/m1_n244_n517# 0
C80 5v0_addh_sc_tile_1/ctrl_sign 5v0_add_q_sc_1/pti 0
C81 5v0_addh_sc_tile_1/inv_nti 5v0_addh_sc_tile_1/inv_pti 0.26136f
C82 5v0_add_q_sc_1/5v0_half_adder_selector_sc_0/m1_n239_179# 5v0_add_q_sc_1/inv_pti 0
C83 5v0_addh_sc_tile_1/ternary_input 5v0_add_q_sc_0/5v0_half_adder_selector_sc_0/m1_n239_179# 0
C84 5v0_addh_sc_tile_2/pti 5v0_add_q_sc_0/downstepper_test 0
C85 5v0_addh_sc_tile_0/inv_nti 5v0_addh_sc_tile_0/m1_103_293# 0.35313f
C86 VDD_3V3_1 5v0_addh_sc_tile_0/m1_103_293# 0.73472f
C87 in_3 5v0_addh_sc_tile_2/ctrl_sign 0.0072f
C88 5v0_add_q_sc_1/5v0_half_adder_selector_sc_0/res_stage0 5v0_add_q_sc_1/ctrl_sign 0.22434f
C89 5v0_addh_sc_tile_1/ctrl_sign 5v0_addh_sc_tile_0/nti 0
C90 5v0_add_q_sc_0/downstepper_test 5v0_addh_sc_tile_1/m1_103_293# 0
C91 5v0_addh_sc_tile_1/ctrl_over 5v0_addh_sc_tile_1/ternary_input 0.25963f
C92 5v0_add_q_sc_1/5v0_half_adder_selector_sc_0/m1_n239_179# VDD_3V3_1 0.29031f
C93 5v0_addh_sc_tile_2/pti 5v0_add_q_sc_0/5v0_half_adder_selector_sc_0/m1_n244_n517# 0
C94 5v0_add_q_sc_0/inv_nti VDD_1V65_5 0.01114f
C95 5v0_add_q_sc_0/inv_pti 5v0_add_q_sc_0/nti 0.21873f
C96 5v0_addh_sc_tile_1/ctrl_over in_2 0.0235f
C97 5v0_add_q_sc_1/5v0_half_adder_selector_sc_0/m1_n239_179# 5v0_add_q_sc_1/ctrl_over 0.00258f
C98 5v0_addh_sc_tile_2/ctrl_over 5v0_add_q_sc_0/5v0_half_adder_selector_sc_0/res_stage0 0.00474f
C99 5v0_addh_sc_tile_1/upstepper_test 5v0_addh_sc_tile_1/downstepper_test 0.38867f
C100 5v0_addh_sc_tile_0/carry_0_probe 5v0_addh_sc_tile_0/m1_103_293# 0.01488f
C101 VDD_1V65_3 5v0_addh_sc_tile_1/a_n1778_n454# 0
C102 5v0_addh_sc_tile_0/carry_sign_probe 5v0_addh_sc_tile_0/inv_nti 0.17527f
C103 VDD_3V3_1 5v0_addh_sc_tile_0/carry_sign_probe 0.17781f
C104 5v0_addh_sc_tile_1/upstepper_test VDD_3V3_0 0.13286f
C105 5v0_addh_sc_tile_1/inv_pti 5v0_add_q_sc_1/ternary_input 0.00686f
C106 5v0_addh_sc_tile_0/5v0_half_adder_selector_sc_0/res_stage0 5v0_addh_sc_tile_0/m1_103_293# 0.18549f
C107 5v0_add_q_sc_0/inv_pti 5v0_add_q_sc_0/5v0_half_adder_selector_sc_0/res_stage0 0
C108 5v0_addh_sc_tile_0/inv_pti 5v0_add_q_sc_1/ternary_input 0.00639f
C109 5v0_addh_sc_tile_2/ctrl_over 5v0_add_q_sc_0/downstepper_test 0.01272f
C110 5v0_addh_sc_tile_1/ternary_input 5v0_add_q_sc_0/ctrl_sign 0.00787f
C111 5v0_addh_sc_tile_0/carry_0_probe 5v0_addh_sc_tile_0/carry_sign_probe 0.0594f
C112 in_3 5v0_addh_sc_tile_2/upstepper_test 0.01616f
C113 5v0_add_q_sc_1/ternary_input in_0_sign 0
C114 5v0_addh_sc_tile_1/inv_nti 5v0_nter2oter_code_sc_1/pti 0
C115 5v0_addh_sc_tile_1/ctrl_sign 5v0_addh_sc_tile_1/ternary_input 0.1752f
C116 5v0_addh_sc_tile_0/downstepper_test 5v0_nter2oter_code_sc_1/nti 0
C117 5v0_addh_sc_tile_1/ctrl_sign 5v0_addh_sc_tile_0/pti 0.00125f
C118 5v0_addh_sc_tile_2/ctrl_over 5v0_add_q_sc_0/5v0_half_adder_selector_sc_0/m1_n244_n517# 0.00443f
C119 5v0_addh_sc_tile_1/ctrl_over 5v0_addh_sc_tile_0/inv_nti 0
C120 5v0_addh_sc_tile_1/ctrl_sign in_2 0.16969f
C121 5v0_add_q_sc_0/5v0_half_adder_selector_sc_0/5v0_tgate_sel_2_sc_1/input_A 5v0_add_q_sc_0/ctrl_over 0.04656f
C122 res_c 5v0_add_q_sc_0/ternary_input 0.167f
C123 5v0_addh_sc_tile_1/ctrl_over VDD_3V3_1 0.0281f
C124 5v0_add_q_sc_1/5v0_half_adder_selector_sc_0/res_stage0 5v0_add_q_sc_0/ternary_input 0.17113f
C125 5v0_add_q_sc_0/ctrl_over 5v0_add_q_sc_0/upstepper_test 0.00167f
C126 5v0_addh_sc_tile_0/5v0_half_adder_selector_sc_0/res_stage0 5v0_addh_sc_tile_0/carry_sign_probe 0
C127 VDD_1V65_5 5v0_add_q_sc_0/ternary_input 0.03394f
C128 5v0_addh_sc_tile_1/ternary_input 5v0_addh_sc_tile_0/m1_843_n857# 0
C129 5v0_add_q_sc_1/5v0_half_adder_selector_sc_0/m1_n239_179# 5v0_add_q_sc_1/downstepper_test 0.09961f
C130 5v0_addh_sc_tile_1/ctrl_over 5v0_add_q_sc_1/ctrl_over 0.12383f
C131 5v0_addh_sc_tile_0/downstepper_test 5v0_addh_sc_tile_0/m1_103_293# 0.10533f
C132 in_3 5v0_addh_sc_tile_2/m1_843_n857# 0
C133 5v0_addh_sc_tile_0/pti 5v0_addh_sc_tile_0/m1_843_n857# 0.11666f
C134 5v0_add_q_sc_0/nti 5v0_add_q_sc_0/not_internal_0/a_56_472# 0.0036f
C135 5v0_add_q_sc_0/inv_pti 5v0_add_q_sc_0/downstepper_test 0.07797f
C136 5v0_nter2oter_code_sc_1/nti VDD_1V65_0 0
C137 5v0_addh_sc_tile_0/a_n1205_n937# 5v0_addh_sc_tile_0/nti 0
C138 5v0_addh_sc_tile_2/inv_pti 5v0_nter2oter_code_sc_1/nti 0
C139 5v0_add_q_sc_1/nti 5v0_addh_sc_tile_0/carry_sign_probe 0
C140 in_0_over 5v0_addh_sc_tile_0/m1_103_293# 0.02633f
C141 5v0_nter2oter_code_sc_1/not_internal_0/a_36_68# 5v0_nter2oter_code_sc_1/pti 0.00274f
C142 in_3 VDD_3V3_0 1.10015f
C143 5v0_addh_sc_tile_1/ctrl_over 5v0_nter2oter_code_sc_0/nti 0
C144 5v0_nter2oter_code_sc_0/in in_1 0.00145f
C145 5v0_addh_sc_tile_1/ctrl_over 5v0_addh_sc_tile_0/carry_0_probe 0
C146 5v0_addh_sc_tile_0/nti 5v0_addh_sc_tile_0/not_internal_0/a_36_68# 0.00259f
C147 VDD_1V65_3 5v0_addh_sc_tile_1/inv_pti 0.14775f
C148 5v0_addh_sc_tile_1/ternary_input 5v0_addh_sc_tile_2/ctrl_sign 0
C149 5v0_addh_sc_tile_1/a_382_n1095# 5v0_add_q_sc_1/ctrl_sign 0.00155f
C150 5v0_addh_sc_tile_1/ctrl_over VDD_1V65_4 0
C151 5v0_addh_sc_tile_2/ctrl_sign in_2 0.00446f
C152 5v0_addh_sc_tile_2/nti 5v0_nter2oter_code_sc_0/nti 0.00237f
C153 VDD_1V65_3 in_0_sign 0
C154 5v0_addh_sc_tile_0/downstepper_test 5v0_addh_sc_tile_0/carry_sign_probe 0
C155 5v0_add_q_sc_0/5v0_half_adder_selector_sc_0/m1_n239_179# 5v0_add_q_sc_0/upstepper_test 0.07502f
C156 5v0_add_q_sc_1/ctrl_sign 5v0_addh_sc_tile_1/pti 0.01108f
C157 5v0_addh_sc_tile_1/ctrl_over 5v0_addh_sc_tile_0/5v0_half_adder_selector_sc_0/res_stage0 0
C158 VDD_1V65_4 5v0_addh_sc_tile_2/nti 0.21326f
C159 in_0_over 5v0_addh_sc_tile_0/carry_sign_probe 0.00413f
C160 5v0_nter2oter_code_sc_0/in 5v0_addh_sc_tile_1/a_382_n1095# 0.16245f
C161 5v0_addh_sc_tile_1/ctrl_sign 5v0_addh_sc_tile_0/inv_nti 0.02852f
C162 5v0_addh_sc_tile_1/ctrl_over 5v0_add_q_sc_0/upstepper_test 0.00229f
C163 5v0_addh_sc_tile_1/ctrl_sign 5v0_addh_sc_tile_1/not_internal_0/a_36_68# 0
C164 5v0_addh_sc_tile_1/ctrl_over 5v0_addh_sc_tile_1/5v0_half_adder_selector_sc_0/5v0_tgate_sel_2_sc_1/input_A 0.04656f
C165 5v0_addh_sc_tile_1/ctrl_sign VDD_3V3_1 0.86223f
C166 5v0_addh_sc_tile_1/ctrl_over 5v0_add_q_sc_1/nti 0
C167 5v0_add_q_sc_0/ctrl_over 5v0_addh_sc_tile_2/m1_103_293# 0.01398f
C168 5v0_addh_sc_tile_0/nti VDD_3V3_0 0
C169 5v0_addh_sc_tile_1/inv_pti 5v0_addh_sc_tile_0/m1_103_293# 0.00205f
C170 5v0_add_q_sc_0/inv_pti 5v0_add_q_sc_0/a_n1373_n454# 0.00135f
C171 5v0_addh_sc_tile_1/ctrl_sign 5v0_add_q_sc_1/ctrl_over 0.01552f
C172 5v0_add_q_sc_1/ctrl_sign 5v0_addh_sc_tile_1/m1_103_293# 0.22665f
C173 5v0_nter2oter_code_sc_0/in 5v0_addh_sc_tile_1/pti 0
C174 5v0_addh_sc_tile_0/upstepper_test 5v0_addh_sc_tile_0/nti 0.11981f
C175 5v0_addh_sc_tile_0/inv_pti 5v0_addh_sc_tile_0/m1_103_293# 0.17653f
C176 5v0_addh_sc_tile_2/not_internal_0/a_36_68# 5v0_addh_sc_tile_2/nti 0.00259f
C177 5v0_addh_sc_tile_0/inv_nti 5v0_addh_sc_tile_0/m1_843_n857# 0.36668f
C178 5v0_nter2oter_code_sc_0/in 5v0_addh_sc_tile_2/pti 0.00286f
C179 5v0_addh_sc_tile_2/inv_nti 5v0_add_q_sc_0/ctrl_over 0.01791f
C180 VDD_3V3_1 5v0_addh_sc_tile_0/m1_843_n857# 0.22222f
C181 5v0_addh_sc_tile_0/m1_103_293# in_0_sign 0.60072f
C182 5v0_addh_sc_tile_1/ctrl_sign 5v0_nter2oter_code_sc_0/nti 0
C183 5v0_addh_sc_tile_1/ctrl_sign 5v0_addh_sc_tile_0/carry_0_probe 0.02298f
C184 5v0_addh_sc_tile_1/ternary_input 5v0_addh_sc_tile_2/upstepper_test 0
C185 5v0_addh_sc_tile_0/a_382_n1095# 5v0_add_q_sc_1/ctrl_sign 0
C186 5v0_addh_sc_tile_1/ctrl_over 5v0_addh_sc_tile_0/downstepper_test 0.00267f
C187 5v0_addh_sc_tile_2/5v0_half_adder_selector_sc_0/5v0_tgate_sel_2_sc_1/input_A 5v0_add_q_sc_0/ctrl_over 0
C188 5v0_addh_sc_tile_0/pti 5v0_addh_sc_tile_0/not_internal_0/a_36_68# 0.01664f
C189 5v0_nter2oter_code_sc_0/gf180mcu_fd_sc_mcu7t5v0__nor2_1_0/a_224_472# 5v0_addh_sc_tile_2/nti 0
C190 5v0_add_q_sc_0/downstepper_test 5v0_add_q_sc_0/not_internal_0/a_56_472# 0.00134f
C191 5v0_add_q_sc_0/nti 5v0_addh_sc_tile_1/m1_843_n857# 0
C192 5v0_addh_sc_tile_1/ctrl_over in_0_over 0
C193 5v0_addh_sc_tile_2/ctrl_sign 5v0_addh_sc_tile_0/inv_nti 0
C194 5v0_addh_sc_tile_2/inv_pti 5v0_add_q_sc_0/5v0_half_adder_selector_sc_0/m1_n239_179# 0.00128f
C195 5v0_addh_sc_tile_1/ternary_input 5v0_addh_sc_tile_1/downstepper_test 0.18203f
C196 5v0_addh_sc_tile_0/carry_0_probe 5v0_addh_sc_tile_0/m1_843_n857# 0.18376f
C197 VDD_3V3_1 5v0_addh_sc_tile_2/ctrl_sign 0.00525f
C198 5v0_addh_sc_tile_0/inv_pti 5v0_addh_sc_tile_0/carry_sign_probe 0.17523f
C199 5v0_add_q_sc_0/5v0_half_adder_selector_sc_0/5v0_tgate_sel_2_sc_1/input_A 5v0_add_q_sc_0/ctrl_sign 0
C200 5v0_addh_sc_tile_1/a_382_n1095# 5v0_add_q_sc_0/ternary_input 0.00603f
C201 5v0_add_q_sc_0/ctrl_sign 5v0_add_q_sc_0/upstepper_test 0.08746f
C202 5v0_addh_sc_tile_1/5v0_half_adder_selector_sc_0/res_stage0 5v0_add_q_sc_1/ctrl_sign 0
C203 5v0_addh_sc_tile_1/ctrl_sign 5v0_addh_sc_tile_0/5v0_half_adder_selector_sc_0/res_stage0 0.00758f
C204 5v0_addh_sc_tile_1/ctrl_over VDD_1V65_0 0
C205 5v0_addh_sc_tile_0/carry_sign_probe in_0_sign 0.24834f
C206 5v0_addh_sc_tile_2/inv_pti 5v0_addh_sc_tile_1/ctrl_over 0.00855f
C207 5v0_addh_sc_tile_1/inv_pti 5v0_addh_sc_tile_1/a_n1373_n454# 0.00135f
C208 5v0_addh_sc_tile_1/ctrl_sign 5v0_add_q_sc_0/upstepper_test 0
C209 5v0_addh_sc_tile_2/inv_nti 5v0_add_q_sc_0/5v0_half_adder_selector_sc_0/m1_n239_179# 0
C210 5v0_addh_sc_tile_1/ctrl_over 5v0_addh_sc_tile_2/m1_103_293# 0
C211 5v0_addh_sc_tile_1/ctrl_sign 5v0_addh_sc_tile_1/5v0_half_adder_selector_sc_0/5v0_tgate_sel_2_sc_1/input_A 0
C212 5v0_addh_sc_tile_2/ctrl_sign 5v0_nter2oter_code_sc_0/nti 0.03693f
C213 5v0_add_q_sc_0/ternary_input 5v0_addh_sc_tile_1/pti 0
C214 5v0_addh_sc_tile_1/ctrl_sign 5v0_add_q_sc_1/nti 0.00138f
C215 5v0_addh_sc_tile_1/ternary_input VDD_3V3_0 0.0901f
C216 5v0_nter2oter_code_sc_1/nti 5v0_nter2oter_code_sc_1/pti 0.00569f
C217 in_2 VDD_3V3_0 0.013f
C218 5v0_add_q_sc_1/inv_nti 5v0_add_q_sc_1/pti 0.10916f
C219 5v0_add_q_sc_0/nti 5v0_addh_sc_tile_1/inv_nti 0
C220 5v0_addh_sc_tile_2/pti 5v0_add_q_sc_0/ternary_input 0.00188f
C221 5v0_addh_sc_tile_2/inv_pti 5v0_addh_sc_tile_2/nti 0.24025f
C222 5v0_nter2oter_code_sc_0/in 5v0_addh_sc_tile_1/5v0_half_adder_selector_sc_0/res_stage0 0.1871f
C223 5v0_addh_sc_tile_0/upstepper_test in_2 0
C224 5v0_addh_sc_tile_0/upstepper_test 5v0_addh_sc_tile_0/pti 0.02442f
C225 VDD_1V65_4 5v0_addh_sc_tile_2/ctrl_sign 0
C226 5v0_addh_sc_tile_2/inv_nti 5v0_addh_sc_tile_1/ctrl_over 0
C227 5v0_addh_sc_tile_1/ctrl_sign 5v0_add_q_sc_1/downstepper_test 0.00227f
C228 5v0_addh_sc_tile_2/ctrl_over 5v0_nter2oter_code_sc_0/in 1.77045f
C229 5v0_addh_sc_tile_1/ctrl_over 5v0_addh_sc_tile_1/inv_pti 0.0052f
C230 5v0_addh_sc_tile_0/a_n1205_n937# 5v0_addh_sc_tile_0/inv_nti 0
C231 5v0_add_q_sc_0/ternary_input 5v0_addh_sc_tile_1/m1_103_293# 0
C232 5v0_addh_sc_tile_1/ctrl_sign 5v0_addh_sc_tile_0/downstepper_test 0.016f
C233 5v0_addh_sc_tile_0/inv_pti 5v0_addh_sc_tile_1/ctrl_over 0
C234 5v0_addh_sc_tile_0/a_n1205_n937# VDD_3V3_1 0.00891f
C235 5v0_add_q_sc_0/not_internal_0/a_36_68# 5v0_add_q_sc_0/nti 0.00259f
C236 5v0_add_q_sc_0/nti 5v0_add_q_sc_0/a_n1205_n937# 0
C237 5v0_addh_sc_tile_2/inv_nti 5v0_addh_sc_tile_2/nti 0.22786f
C238 5v0_addh_sc_tile_1/ctrl_sign in_0_over 0.03467f
C239 5v0_nter2oter_code_sc_1/not_internal_0/a_36_68# 5v0_nter2oter_code_sc_0/pti 0.00274f
C240 5v0_add_q_sc_0/inv_pti 5v0_add_q_sc_0/inv_nti 0.08256f
C241 5v0_addh_sc_tile_2/inv_pti 5v0_add_q_sc_0/ctrl_sign 0.10221f
C242 5v0_addh_sc_tile_2/pti res_c 0
C243 VDD_1V65_2 5v0_addh_sc_tile_1/m1_103_293# 0
C244 5v0_addh_sc_tile_1/not_internal_0/a_56_472# 5v0_addh_sc_tile_1/ctrl_sign 0.00471f
C245 5v0_add_q_sc_0/ctrl_sign 5v0_addh_sc_tile_2/m1_103_293# 0.21173f
C246 5v0_addh_sc_tile_1/ctrl_sign VDD_1V65_0 0
C247 5v0_addh_sc_tile_1/not_internal_0/a_36_68# 5v0_addh_sc_tile_1/downstepper_test 0.00136f
C248 5v0_addh_sc_tile_2/a_382_n1095# 5v0_add_q_sc_0/ctrl_over 0.06871f
C249 5v0_addh_sc_tile_1/upstepper_test 5v0_addh_sc_tile_1/ternary_input 0.01616f
C250 VDD_3V3_1 5v0_addh_sc_tile_1/downstepper_test 0.09159f
C251 5v0_nter2oter_code_sc_0/gf180mcu_fd_sc_mcu7t5v0__nor2_1_0/a_224_472# 5v0_addh_sc_tile_2/ctrl_sign 0
C252 5v0_addh_sc_tile_2/inv_pti 5v0_addh_sc_tile_1/ctrl_sign 0.00197f
C253 in_0_over 5v0_addh_sc_tile_0/m1_843_n857# 0.09998f
C254 5v0_add_q_sc_1/ctrl_over 5v0_addh_sc_tile_1/downstepper_test 0
C255 5v0_addh_sc_tile_1/ctrl_over 5v0_nter2oter_code_sc_1/not_internal_0/a_56_472# 0.01014f
C256 5v0_addh_sc_tile_2/inv_nti 5v0_add_q_sc_0/ctrl_sign 0.12058f
C257 5v0_add_q_sc_1/inv_nti 5v0_add_q_sc_1/VDD_1V65 0.01114f
C258 5v0_addh_sc_tile_1/inv_pti 5v0_add_q_sc_0/ctrl_sign 0
C259 VDD_1V65_4 5v0_addh_sc_tile_2/upstepper_test 0.16859f
C260 5v0_add_q_sc_0/a_n1205_n937# 5v0_add_q_sc_0/5v0_half_adder_selector_sc_0/res_stage0 0
C261 5v0_addh_sc_tile_2/ctrl_over 5v0_add_q_sc_0/ternary_input 0.0068f
C262 5v0_addh_sc_tile_0/a_n1205_n937# 5v0_addh_sc_tile_0/5v0_half_adder_selector_sc_0/res_stage0 0
C263 5v0_addh_sc_tile_0/carry_0_probe 5v0_addh_sc_tile_1/downstepper_test 0.01317f
C264 VDD_3V3_1 VDD_3V3_0 0.00212f
C265 5v0_addh_sc_tile_0/upstepper_test 5v0_addh_sc_tile_0/inv_nti 0.00736f
C266 5v0_add_q_sc_0/nti 5v0_add_q_sc_0/pti 0.1782f
C267 5v0_addh_sc_tile_2/nti 5v0_nter2oter_code_sc_1/not_internal_0/a_56_472# 0
C268 5v0_addh_sc_tile_2/a_n1205_n937# 5v0_addh_sc_tile_2/nti 0
C269 5v0_addh_sc_tile_0/upstepper_test VDD_3V3_1 0.45657f
C270 5v0_addh_sc_tile_1/ctrl_sign 5v0_addh_sc_tile_1/inv_pti 0.41961f
C271 5v0_add_q_sc_1/ctrl_over VDD_3V3_0 0.329f
C272 5v0_addh_sc_tile_1/inv_nti 5v0_add_q_sc_0/downstepper_test 0
C273 5v0_addh_sc_tile_1/a_n1205_n937# 5v0_addh_sc_tile_1/5v0_half_adder_selector_sc_0/res_stage0 0
C274 5v0_addh_sc_tile_0/pti 5v0_add_q_sc_1/inv_nti 0.00104f
C275 5v0_addh_sc_tile_2/inv_pti 5v0_addh_sc_tile_2/ctrl_sign 0.28426f
C276 VDD_3V3_0 5v0_nter2oter_code_sc_0/nti 0.3158f
C277 5v0_addh_sc_tile_0/carry_0_probe VDD_3V3_0 0
C278 5v0_addh_sc_tile_1/ctrl_sign in_0_sign 0
C279 5v0_nter2oter_code_sc_0/in 5v0_addh_sc_tile_1/nti 0.00446f
C280 5v0_addh_sc_tile_1/inv_pti 5v0_addh_sc_tile_0/m1_843_n857# 0.00739f
C281 5v0_addh_sc_tile_2/ctrl_sign 5v0_addh_sc_tile_2/m1_103_293# 0.61512f
C282 5v0_addh_sc_tile_1/ctrl_over 5v0_nter2oter_code_sc_1/pti 0.20737f
C283 5v0_addh_sc_tile_0/upstepper_test 5v0_addh_sc_tile_0/carry_0_probe 0
C284 5v0_addh_sc_tile_0/inv_pti 5v0_addh_sc_tile_0/m1_843_n857# 0
C285 5v0_add_q_sc_0/inv_pti 5v0_add_q_sc_0/ternary_input 0.08665f
C286 m1_n2844_n810# 5v0_add_q_sc_1/ternary_input 0.11751f
C287 5v0_add_q_sc_0/not_internal_0/a_36_68# 5v0_add_q_sc_0/downstepper_test 0.00136f
C288 5v0_addh_sc_tile_1/ctrl_over 5v0_addh_sc_tile_2/a_382_n1095# 0
C289 VDD_1V65_4 VDD_3V3_0 0.0468f
C290 5v0_add_q_sc_0/a_n1205_n937# 5v0_add_q_sc_0/downstepper_test 0.00453f
C291 5v0_addh_sc_tile_2/ctrl_over res_c 0.00127f
C292 5v0_add_q_sc_1/VDD_1V65 5v0_add_q_sc_1/pti 0.00115f
C293 5v0_addh_sc_tile_1/5v0_half_adder_selector_sc_0/5v0_tgate_sel_2_sc_1/input_A 5v0_addh_sc_tile_1/downstepper_test 0
C294 5v0_addh_sc_tile_0/a_n1205_n937# 5v0_addh_sc_tile_0/downstepper_test 0.00453f
C295 5v0_add_q_sc_1/not_internal_0/a_36_68# 5v0_add_q_sc_1/ternary_input 0.00301f
C296 5v0_addh_sc_tile_0/m1_843_n857# in_0_sign 0.24363f
C297 5v0_addh_sc_tile_2/ctrl_over VDD_1V65_5 0
C298 5v0_addh_sc_tile_2/inv_nti 5v0_addh_sc_tile_2/ctrl_sign 0.24905f
C299 5v0_addh_sc_tile_1/a_n1778_n454# 5v0_addh_sc_tile_1/downstepper_test 0.0031f
C300 5v0_addh_sc_tile_2/nti 5v0_nter2oter_code_sc_1/pti 0
C301 5v0_addh_sc_tile_2/a_n1373_n454# 5v0_addh_sc_tile_2/nti 0
C302 5v0_addh_sc_tile_0/downstepper_test 5v0_addh_sc_tile_0/not_internal_0/a_36_68# 0.00136f
C303 5v0_addh_sc_tile_0/a_n1205_n937# in_0_over 0
C304 5v0_addh_sc_tile_1/inv_pti 5v0_addh_sc_tile_2/ctrl_sign 0
C305 5v0_addh_sc_tile_1/upstepper_test VDD_3V3_1 0.39437f
C306 5v0_addh_sc_tile_2/5v0_half_adder_selector_sc_0/5v0_tgate_sel_2_sc_1/input_A 5v0_addh_sc_tile_2/ctrl_sign 0
C307 5v0_addh_sc_tile_2/nti 5v0_addh_sc_tile_2/a_382_n1095# 0
C308 5v0_addh_sc_tile_0/upstepper_test 5v0_addh_sc_tile_0/5v0_half_adder_selector_sc_0/res_stage0 0.27475f
C309 5v0_add_q_sc_0/5v0_half_adder_selector_sc_0/5v0_tgate_sel_2_sc_1/input_A VDD_3V3_0 0.02871f
C310 VDD_3V3_0 5v0_add_q_sc_0/upstepper_test 0.55758f
C311 VDD_3V3_0 5v0_addh_sc_tile_1/5v0_half_adder_selector_sc_0/5v0_tgate_sel_2_sc_1/input_A 0.02871f
C312 5v0_addh_sc_tile_0/a_n1205_n937# VDD_1V65_0 0.00354f
C313 5v0_add_q_sc_1/inv_nti 5v0_add_q_sc_1/inv_pti 0.08256f
C314 5v0_addh_sc_tile_2/5v0_half_adder_selector_sc_0/res_stage0 5v0_addh_sc_tile_2/pti 0.00979f
C315 5v0_add_q_sc_1/ctrl_sign 5v0_add_q_sc_1/5v0_half_adder_selector_sc_0/m1_n244_n517# 0
C316 5v0_add_q_sc_1/ctrl_sign 5v0_add_q_sc_1/a_n1778_n454# 0
C317 in_0_over 5v0_addh_sc_tile_1/downstepper_test 0
C318 5v0_addh_sc_tile_1/upstepper_test 5v0_addh_sc_tile_0/carry_0_probe 0.02787f
C319 5v0_nter2oter_code_sc_0/gf180mcu_fd_sc_mcu7t5v0__nor2_1_0/a_224_472# VDD_3V3_0 0.01379f
C320 5v0_addh_sc_tile_2/inv_pti 5v0_addh_sc_tile_2/upstepper_test 0.07254f
C321 5v0_addh_sc_tile_0/a_n1778_n454# 5v0_addh_sc_tile_0/upstepper_test 0
C322 5v0_add_q_sc_0/inv_pti VDD_1V65_5 0.14775f
C323 5v0_addh_sc_tile_1/a_382_n1095# 5v0_addh_sc_tile_1/pti 0.12627f
C324 5v0_addh_sc_tile_1/ternary_input 5v0_addh_sc_tile_0/nti 0
C325 5v0_addh_sc_tile_0/pti 5v0_addh_sc_tile_0/nti 0.24563f
C326 5v0_add_q_sc_1/inv_nti 5v0_addh_sc_tile_0/inv_nti 0
C327 5v0_addh_sc_tile_0/nti in_2 0.0018f
C328 5v0_addh_sc_tile_2/upstepper_test 5v0_addh_sc_tile_2/m1_103_293# 0.07773f
C329 5v0_add_q_sc_0/ctrl_sign 5v0_addh_sc_tile_2/a_382_n1095# 0.00651f
C330 5v0_add_q_sc_0/pti 5v0_add_q_sc_0/downstepper_test 0.0825f
C331 5v0_addh_sc_tile_2/a_n1778_n454# 5v0_addh_sc_tile_2/nti 0.00142f
C332 5v0_addh_sc_tile_0/a_382_n1095# in_1 0.09307f
C333 5v0_addh_sc_tile_0/downstepper_test VDD_3V3_0 0
C334 5v0_addh_sc_tile_1/not_internal_0/a_56_472# 5v0_addh_sc_tile_1/downstepper_test 0
C335 5v0_addh_sc_tile_1/ctrl_sign 5v0_nter2oter_code_sc_1/pti 0.06025f
C336 VDD_3V3_1 5v0_add_q_sc_1/inv_nti 0.56252f
C337 5v0_addh_sc_tile_2/ctrl_sign 5v0_nter2oter_code_sc_1/not_internal_0/a_56_472# 0.0242f
C338 5v0_addh_sc_tile_2/inv_pti 5v0_addh_sc_tile_1/downstepper_test 0.01675f
C339 5v0_addh_sc_tile_0/upstepper_test 5v0_addh_sc_tile_0/downstepper_test 0.38867f
C340 5v0_add_q_sc_1/inv_nti 5v0_add_q_sc_1/ctrl_over 0.00311f
C341 in_0_over VDD_3V3_0 0
C342 5v0_addh_sc_tile_2/m1_103_293# 5v0_addh_sc_tile_1/downstepper_test 0.00921f
C343 5v0_addh_sc_tile_2/inv_nti 5v0_addh_sc_tile_2/upstepper_test 0.00736f
C344 5v0_addh_sc_tile_1/a_382_n1095# 5v0_addh_sc_tile_1/m1_103_293# 0.07764f
C345 5v0_addh_sc_tile_2/pti 5v0_addh_sc_tile_1/pti 0
C346 5v0_addh_sc_tile_0/upstepper_test in_0_over 0.00168f
C347 5v0_addh_sc_tile_2/inv_pti 5v0_addh_sc_tile_2/m1_843_n857# 0
C348 5v0_addh_sc_tile_2/5v0_half_adder_selector_sc_0/5v0_tgate_sel_2_sc_1/input_A 5v0_addh_sc_tile_2/upstepper_test 0
C349 5v0_addh_sc_tile_1/nti 5v0_addh_sc_tile_1/a_n1205_n937# 0
C350 5v0_addh_sc_tile_0/carry_0_probe 5v0_add_q_sc_1/inv_nti 0.00204f
C351 5v0_addh_sc_tile_0/inv_pti 5v0_addh_sc_tile_0/not_internal_0/a_36_68# 0.00668f
C352 5v0_add_q_sc_0/nti 5v0_add_q_sc_0/ctrl_over 0.00167f
C353 5v0_addh_sc_tile_1/upstepper_test 5v0_addh_sc_tile_1/5v0_half_adder_selector_sc_0/5v0_tgate_sel_2_sc_1/input_A 0
C354 5v0_add_q_sc_1/inv_pti 5v0_add_q_sc_1/pti 0.21601f
C355 5v0_add_q_sc_0/ternary_input 5v0_add_q_sc_0/not_internal_0/a_56_472# 0.00446f
C356 5v0_addh_sc_tile_2/m1_843_n857# 5v0_addh_sc_tile_2/m1_103_293# 0.20659f
C357 5v0_addh_sc_tile_2/inv_nti 5v0_addh_sc_tile_1/downstepper_test 0.00392f
C358 5v0_addh_sc_tile_2/inv_pti VDD_3V3_0 1.05506f
C359 5v0_addh_sc_tile_1/upstepper_test 5v0_addh_sc_tile_1/a_n1778_n454# 0
C360 res_0 5v0_addh_sc_tile_2/5v0_half_adder_selector_sc_0/res_stage0 0.08533f
C361 5v0_addh_sc_tile_1/pti 5v0_addh_sc_tile_1/m1_103_293# 0.10002f
C362 5v0_add_q_sc_1/ctrl_sign 5v0_addh_sc_tile_1/m1_843_n857# 0.0069f
C363 5v0_addh_sc_tile_0/upstepper_test VDD_1V65_0 0.16859f
C364 5v0_addh_sc_tile_2/m1_103_293# VDD_3V3_0 0.75958f
C365 5v0_addh_sc_tile_1/inv_pti 5v0_addh_sc_tile_1/downstepper_test 0.1369f
C366 in_3 5v0_nter2oter_code_sc_0/nti 0.00251f
C367 5v0_addh_sc_tile_2/ctrl_sign 5v0_nter2oter_code_sc_1/pti 0.04254f
C368 m1_n2844_n810# 5v0_addh_sc_tile_0/m1_103_293# 0
C369 5v0_addh_sc_tile_2/inv_nti 5v0_addh_sc_tile_2/m1_843_n857# 0.36668f
C370 VDD_3V3_1 5v0_add_q_sc_1/pti 0.51637f
C371 5v0_addh_sc_tile_0/a_382_n1095# 5v0_addh_sc_tile_1/pti 0.00485f
C372 5v0_addh_sc_tile_2/ctrl_over 5v0_addh_sc_tile_2/5v0_half_adder_selector_sc_0/res_stage0 0.09179f
C373 5v0_addh_sc_tile_1/inv_pti 5v0_addh_sc_tile_2/m1_843_n857# 0
C374 5v0_add_q_sc_1/ctrl_over 5v0_add_q_sc_1/pti 0
C375 5v0_addh_sc_tile_2/inv_nti VDD_3V3_0 0.88452f
C376 5v0_addh_sc_tile_2/ctrl_sign 5v0_addh_sc_tile_2/a_382_n1095# 0.07412f
C377 5v0_add_q_sc_0/pti 5v0_add_q_sc_0/a_n1373_n454# 0
C378 in_3 VDD_1V65_4 0.01451f
C379 5v0_addh_sc_tile_1/5v0_half_adder_selector_sc_0/res_stage0 5v0_addh_sc_tile_1/a_382_n1095# 0.08951f
C380 5v0_addh_sc_tile_1/ternary_input in_2 0.02442f
C381 5v0_addh_sc_tile_1/inv_pti VDD_3V3_0 0.1766f
C382 5v0_addh_sc_tile_1/ternary_input 5v0_addh_sc_tile_0/pti 0
C383 5v0_addh_sc_tile_1/upstepper_test in_0_over 0.01202f
C384 5v0_addh_sc_tile_2/5v0_half_adder_selector_sc_0/5v0_tgate_sel_2_sc_1/input_A VDD_3V3_0 0.02871f
C385 5v0_addh_sc_tile_0/nti 5v0_addh_sc_tile_0/inv_nti 0.22786f
C386 5v0_addh_sc_tile_0/pti in_2 0
C387 5v0_addh_sc_tile_2/a_n1205_n937# 5v0_addh_sc_tile_2/upstepper_test 0.00334f
C388 5v0_add_q_sc_1/5v0_half_adder_selector_sc_0/m1_n244_n517# 5v0_add_q_sc_0/ternary_input 0.16119f
C389 5v0_add_q_sc_1/nti 5v0_add_q_sc_1/inv_nti 0.20056f
C390 VDD_3V3_1 5v0_addh_sc_tile_0/nti 0.73732f
C391 5v0_add_q_sc_0/5v0_half_adder_selector_sc_0/res_stage0 5v0_add_q_sc_0/ctrl_over 0.09159f
C392 5v0_addh_sc_tile_0/carry_0_probe 5v0_add_q_sc_1/pti 0
C393 5v0_addh_sc_tile_1/inv_nti 5v0_add_q_sc_1/ctrl_sign 0.05407f
C394 5v0_nter2oter_code_sc_1/nti 5v0_nter2oter_code_sc_1/gf180mcu_fd_sc_mcu7t5v0__nor2_1_0/a_224_472# 0.00898f
C395 5v0_add_q_sc_1/5v0_half_adder_selector_sc_0/res_stage0 5v0_add_q_sc_1/a_n1205_n937# 0
C396 res_0 5v0_addh_sc_tile_2/pti 0
C397 5v0_addh_sc_tile_0/inv_pti 5v0_addh_sc_tile_0/upstepper_test 0.07282f
C398 in_0_sign VDD_3V3_0 0
C399 5v0_addh_sc_tile_1/5v0_half_adder_selector_sc_0/res_stage0 5v0_addh_sc_tile_1/pti 0.01078f
C400 5v0_addh_sc_tile_2/not_internal_0/a_36_68# in_3 0
C401 5v0_addh_sc_tile_1/not_internal_0/a_56_472# 5v0_addh_sc_tile_1/upstepper_test 0
C402 m1_n2844_n810# 5v0_addh_sc_tile_0/carry_sign_probe 0.12483f
C403 5v0_addh_sc_tile_2/pti 5v0_addh_sc_tile_2/not_internal_0/a_56_472# 0.01506f
C404 5v0_addh_sc_tile_0/upstepper_test in_0_sign 0.08746f
C405 5v0_addh_sc_tile_2/ctrl_over 5v0_addh_sc_tile_1/pti 0
C406 5v0_add_q_sc_1/inv_nti 5v0_add_q_sc_1/downstepper_test 0.17947f
C407 5v0_add_q_sc_1/not_internal_0/a_56_472# 5v0_add_q_sc_1/ternary_input 0.00175f
C408 5v0_addh_sc_tile_1/ctrl_over 5v0_add_q_sc_0/nti 0
C409 5v0_addh_sc_tile_1/ctrl_over 5v0_nter2oter_code_sc_0/pti 0.01034f
C410 5v0_addh_sc_tile_0/nti 5v0_nter2oter_code_sc_0/nti 0.00276f
C411 5v0_add_q_sc_1/VDD_1V65 5v0_add_q_sc_1/inv_pti 0.14775f
C412 5v0_addh_sc_tile_2/ctrl_over 5v0_addh_sc_tile_2/pti 0.16185f
C413 5v0_addh_sc_tile_0/carry_0_probe 5v0_addh_sc_tile_0/nti 0
C414 5v0_addh_sc_tile_2/downstepper_test 5v0_addh_sc_tile_2/5v0_half_adder_selector_sc_0/res_stage0 0.24494f
C415 5v0_nter2oter_code_sc_0/in 5v0_addh_sc_tile_1/inv_nti 0.01488f
C416 5v0_addh_sc_tile_1/5v0_half_adder_selector_sc_0/res_stage0 5v0_addh_sc_tile_1/m1_103_293# 0.18549f
C417 5v0_add_q_sc_0/inv_nti 5v0_add_q_sc_0/a_n1205_n937# 0
C418 5v0_add_q_sc_0/inv_pti 5v0_addh_sc_tile_1/a_382_n1095# 0
C419 in_0_over 5v0_add_q_sc_1/inv_nti 0.00113f
C420 VDD_3V3_0 5v0_nter2oter_code_sc_1/not_internal_0/a_56_472# 0.01369f
C421 5v0_nter2oter_code_sc_0/pti 5v0_addh_sc_tile_2/nti 0
C422 5v0_addh_sc_tile_2/a_n1373_n454# 5v0_addh_sc_tile_2/upstepper_test 0
C423 5v0_addh_sc_tile_2/a_n1205_n937# VDD_3V3_0 0.00891f
C424 VDD_3V3_1 5v0_add_q_sc_1/VDD_1V65 0.0427f
C425 5v0_add_q_sc_0/downstepper_test 5v0_add_q_sc_0/ctrl_over 0.02328f
C426 5v0_add_q_sc_1/5v0_half_adder_selector_sc_0/res_stage0 5v0_add_q_sc_1/5v0_half_adder_selector_sc_0/m1_n244_n517# 0.08646f
C427 5v0_add_q_sc_1/nti 5v0_add_q_sc_1/pti 0.15563f
C428 5v0_add_q_sc_0/5v0_half_adder_selector_sc_0/res_stage0 5v0_add_q_sc_0/5v0_half_adder_selector_sc_0/m1_n239_179# 0.18379f
C429 5v0_addh_sc_tile_1/upstepper_test 5v0_addh_sc_tile_1/inv_pti 0.06901f
C430 5v0_add_q_sc_0/ternary_input 5v0_addh_sc_tile_1/m1_843_n857# 0.00836f
C431 5v0_addh_sc_tile_1/5v0_half_adder_selector_sc_0/res_stage0 5v0_addh_sc_tile_0/a_382_n1095# 0
C432 5v0_addh_sc_tile_1/nti in_1 0.00579f
C433 5v0_addh_sc_tile_0/5v0_half_adder_selector_sc_0/res_stage0 5v0_addh_sc_tile_0/nti 0.00372f
C434 5v0_add_q_sc_1/ctrl_over 5v0_add_q_sc_1/VDD_1V65 0.04751f
C435 5v0_add_q_sc_0/inv_pti 5v0_addh_sc_tile_1/pti 0
C436 5v0_add_q_sc_0/5v0_half_adder_selector_sc_0/m1_n244_n517# 5v0_add_q_sc_0/ctrl_over 0.35346f
C437 5v0_addh_sc_tile_1/ternary_input 5v0_addh_sc_tile_0/inv_nti 0.0179f
C438 5v0_addh_sc_tile_0/pti 5v0_addh_sc_tile_0/inv_nti 0.42096f
C439 5v0_add_q_sc_1/downstepper_test 5v0_add_q_sc_1/pti 0.08084f
C440 5v0_addh_sc_tile_1/ctrl_over 5v0_add_q_sc_0/5v0_half_adder_selector_sc_0/res_stage0 0
C441 5v0_addh_sc_tile_2/a_382_n1095# 5v0_addh_sc_tile_1/downstepper_test 0.0018f
C442 5v0_addh_sc_tile_0/inv_nti in_2 0.01466f
C443 5v0_addh_sc_tile_1/ternary_input 5v0_addh_sc_tile_1/not_internal_0/a_36_68# 0
C444 5v0_addh_sc_tile_1/nti 5v0_addh_sc_tile_2/5v0_half_adder_selector_sc_0/res_stage0 0
C445 5v0_addh_sc_tile_1/ternary_input VDD_3V3_1 1.22087f
C446 5v0_add_q_sc_1/ternary_input 5v0_add_q_sc_1/ctrl_sign 0.20638f
C447 VDD_3V3_1 5v0_addh_sc_tile_0/pti 0.6297f
C448 5v0_addh_sc_tile_2/downstepper_test 5v0_addh_sc_tile_2/pti 0.20149f
C449 VDD_3V3_1 in_2 0.90866f
C450 5v0_add_q_sc_0/nti 5v0_add_q_sc_0/ctrl_sign 0
C451 5v0_addh_sc_tile_2/inv_pti in_3 0.05631f
C452 5v0_addh_sc_tile_2/ctrl_over res_0 0.20137f
C453 5v0_addh_sc_tile_1/ternary_input 5v0_add_q_sc_1/ctrl_over 0.00136f
C454 5v0_addh_sc_tile_0/a_n1778_n454# 5v0_addh_sc_tile_0/nti 0.00142f
C455 5v0_addh_sc_tile_2/m1_843_n857# 5v0_addh_sc_tile_2/a_382_n1095# 0.05013f
C456 VDD_3V3_0 5v0_nter2oter_code_sc_1/pti 0.17547f
C457 5v0_addh_sc_tile_2/a_n1778_n454# 5v0_addh_sc_tile_2/upstepper_test 0
C458 5v0_addh_sc_tile_2/a_n1373_n454# VDD_3V3_0 0.00122f
C459 5v0_addh_sc_tile_2/ctrl_over 5v0_addh_sc_tile_1/5v0_half_adder_selector_sc_0/res_stage0 0.00478f
C460 in_3 5v0_addh_sc_tile_2/m1_103_293# 0
C461 5v0_addh_sc_tile_1/ctrl_sign 5v0_add_q_sc_0/nti 0
C462 5v0_addh_sc_tile_1/ctrl_sign 5v0_nter2oter_code_sc_0/pti 0.00376f
C463 5v0_addh_sc_tile_1/inv_pti 5v0_add_q_sc_1/inv_nti 0.00455f
C464 5v0_addh_sc_tile_1/nti 5v0_addh_sc_tile_1/a_382_n1095# 0
C465 5v0_add_q_sc_0/pti 5v0_add_q_sc_0/inv_nti 0.11055f
C466 5v0_addh_sc_tile_1/inv_nti 5v0_add_q_sc_0/ternary_input 0.0263f
C467 5v0_addh_sc_tile_2/a_382_n1095# VDD_3V3_0 0.66129f
C468 5v0_add_q_sc_0/downstepper_test 5v0_add_q_sc_0/5v0_half_adder_selector_sc_0/m1_n239_179# 0.09961f
C469 5v0_addh_sc_tile_1/ternary_input 5v0_addh_sc_tile_0/carry_0_probe 0.00236f
C470 in_2 5v0_nter2oter_code_sc_0/nti 0
C471 5v0_addh_sc_tile_0/carry_0_probe 5v0_addh_sc_tile_0/pti 0.14486f
C472 5v0_addh_sc_tile_0/downstepper_test 5v0_addh_sc_tile_0/nti 0.06935f
C473 5v0_addh_sc_tile_2/inv_nti in_3 0.28245f
C474 5v0_addh_sc_tile_1/nti 5v0_addh_sc_tile_1/pti 0.24193f
C475 in_0_over 5v0_addh_sc_tile_0/nti 0.00162f
C476 5v0_addh_sc_tile_1/ctrl_over 5v0_add_q_sc_0/downstepper_test 0
C477 5v0_add_q_sc_0/5v0_half_adder_selector_sc_0/m1_n244_n517# 5v0_add_q_sc_0/5v0_half_adder_selector_sc_0/m1_n239_179# 0.00585f
C478 5v0_addh_sc_tile_1/ctrl_over 5v0_nter2oter_code_sc_1/gf180mcu_fd_sc_mcu7t5v0__nor2_1_0/a_224_472# 0.0039f
C479 5v0_add_q_sc_0/not_internal_0/a_36_68# 5v0_add_q_sc_0/ternary_input 0.00301f
C480 5v0_add_q_sc_1/nti 5v0_add_q_sc_1/VDD_1V65 0.21326f
C481 5v0_add_q_sc_0/a_n1205_n937# 5v0_add_q_sc_0/ternary_input 0
C482 5v0_addh_sc_tile_1/nti 5v0_addh_sc_tile_2/pti 0
C483 5v0_addh_sc_tile_1/inv_nti 5v0_addh_sc_tile_1/a_n1205_n937# 0
C484 5v0_add_q_sc_0/ctrl_sign 5v0_add_q_sc_0/5v0_half_adder_selector_sc_0/res_stage0 0.22359f
C485 5v0_addh_sc_tile_0/5v0_half_adder_selector_sc_0/res_stage0 5v0_addh_sc_tile_1/ternary_input 0.0902f
C486 5v0_addh_sc_tile_0/nti VDD_1V65_0 0.21326f
C487 5v0_addh_sc_tile_0/5v0_half_adder_selector_sc_0/res_stage0 5v0_addh_sc_tile_0/pti 0.01078f
C488 5v0_addh_sc_tile_2/downstepper_test res_0 0.00302f
C489 VDD_3V3_1 5v0_add_q_sc_1/inv_pti 0.37621f
C490 5v0_addh_sc_tile_1/ctrl_sign m1_n2844_n810# 0.00105f
C491 5v0_add_q_sc_1/downstepper_test 5v0_add_q_sc_1/VDD_1V65 0.13024f
C492 5v0_add_q_sc_0/inv_pti 5v0_addh_sc_tile_2/ctrl_over 0
C493 5v0_addh_sc_tile_2/downstepper_test 5v0_addh_sc_tile_2/not_internal_0/a_56_472# 0
C494 5v0_nter2oter_code_sc_0/pti 5v0_addh_sc_tile_2/ctrl_sign 0.23269f
C495 5v0_add_q_sc_1/ctrl_over 5v0_add_q_sc_1/inv_pti 0.0024f
C496 5v0_addh_sc_tile_1/inv_pti 5v0_add_q_sc_1/pti 0
C497 5v0_add_q_sc_1/nti 5v0_addh_sc_tile_0/pti 0.00264f
C498 5v0_addh_sc_tile_1/ternary_input 5v0_addh_sc_tile_1/a_n1778_n454# 0.00182f
C499 5v0_addh_sc_tile_2/ctrl_over 5v0_addh_sc_tile_2/downstepper_test 0.02378f
C500 VDD_3V3_1 5v0_addh_sc_tile_0/inv_nti 0.85199f
C501 5v0_addh_sc_tile_1/nti 5v0_addh_sc_tile_0/a_382_n1095# 0.01157f
C502 m1_n2844_n810# 5v0_addh_sc_tile_0/m1_843_n857# 0.00191f
C503 5v0_addh_sc_tile_0/a_n1778_n454# 5v0_addh_sc_tile_0/pti 0.00135f
C504 in_3 5v0_nter2oter_code_sc_1/not_internal_0/a_56_472# 0
C505 5v0_add_q_sc_1/ternary_input 5v0_add_q_sc_0/ternary_input 0.17661f
C506 VDD_3V3_1 5v0_add_q_sc_1/ctrl_over 0.6465f
C507 VDD_1V65_5 5v0_add_q_sc_0/a_n1205_n937# 0.00354f
C508 5v0_add_q_sc_0/ctrl_sign 5v0_add_q_sc_0/downstepper_test 0.14564f
C509 5v0_addh_sc_tile_0/inv_nti 5v0_nter2oter_code_sc_0/nti 0
C510 5v0_addh_sc_tile_0/inv_pti 5v0_addh_sc_tile_0/nti 0.24025f
C511 5v0_addh_sc_tile_0/downstepper_test 5v0_addh_sc_tile_1/ternary_input 0.00308f
C512 5v0_add_q_sc_1/5v0_half_adder_selector_sc_0/5v0_tgate_sel_2_sc_1/input_A VDD_3V3_1 0.02871f
C513 res_0 5v0_addh_sc_tile_1/nti 0
C514 5v0_addh_sc_tile_0/carry_0_probe 5v0_addh_sc_tile_0/inv_nti 0.03001f
C515 5v0_addh_sc_tile_0/downstepper_test 5v0_addh_sc_tile_0/pti 0.20149f
C516 5v0_add_q_sc_0/a_n1778_n454# 5v0_add_q_sc_0/upstepper_test 0
C517 5v0_add_q_sc_0/pti 5v0_add_q_sc_0/ternary_input 0.6113f
C518 5v0_addh_sc_tile_0/downstepper_test in_2 0.01423f
C519 VDD_3V3_1 5v0_nter2oter_code_sc_0/nti 0.09294f
C520 5v0_add_q_sc_1/5v0_half_adder_selector_sc_0/5v0_tgate_sel_2_sc_1/input_A 5v0_add_q_sc_1/ctrl_over 0.04656f
C521 5v0_addh_sc_tile_0/carry_0_probe VDD_3V3_1 0.81833f
C522 5v0_addh_sc_tile_0/nti in_0_sign 0
C523 5v0_addh_sc_tile_1/ternary_input in_0_over 0.21152f
C524 5v0_add_q_sc_1/ctrl_sign 5v0_addh_sc_tile_0/m1_103_293# 0
C525 5v0_addh_sc_tile_1/nti 5v0_addh_sc_tile_1/5v0_half_adder_selector_sc_0/res_stage0 0.00372f
C526 5v0_addh_sc_tile_0/pti in_0_over 0.10966f
C527 5v0_addh_sc_tile_1/ctrl_sign 5v0_nter2oter_code_sc_1/gf180mcu_fd_sc_mcu7t5v0__nor2_1_0/a_224_472# 0.02563f
C528 5v0_nter2oter_code_sc_0/in 5v0_nter2oter_code_sc_1/nti 0.00222f
C529 5v0_addh_sc_tile_0/carry_0_probe 5v0_add_q_sc_1/ctrl_over 0
C530 5v0_add_q_sc_0/ctrl_sign 5v0_add_q_sc_0/5v0_half_adder_selector_sc_0/m1_n244_n517# 0
C531 5v0_add_q_sc_1/a_n1778_n454# 5v0_addh_sc_tile_1/pti 0
C532 5v0_add_q_sc_1/ternary_input VDD_1V65_2 0.02356f
C533 5v0_addh_sc_tile_2/ctrl_over 5v0_addh_sc_tile_1/nti 0.00207f
C534 5v0_add_q_sc_1/5v0_half_adder_selector_sc_0/m1_n239_179# 5v0_add_q_sc_1/ctrl_sign 0.30422f
C535 5v0_addh_sc_tile_1/not_internal_0/a_56_472# 5v0_addh_sc_tile_1/ternary_input 0.00117f
C536 5v0_addh_sc_tile_2/inv_pti 5v0_addh_sc_tile_1/ternary_input 0
C537 5v0_addh_sc_tile_0/a_n1373_n454# 5v0_addh_sc_tile_0/upstepper_test 0
C538 5v0_addh_sc_tile_0/pti VDD_1V65_0 0.00234f
C539 5v0_addh_sc_tile_0/5v0_half_adder_selector_sc_0/res_stage0 5v0_addh_sc_tile_0/inv_nti 0.02878f
C540 5v0_add_q_sc_1/nti 5v0_add_q_sc_1/inv_pti 0.21255f
C541 VDD_1V65_0 in_2 0
C542 in_3 5v0_nter2oter_code_sc_1/pti 0
C543 5v0_addh_sc_tile_2/inv_pti in_2 0
C544 5v0_addh_sc_tile_2/a_n1373_n454# in_3 0.00163f
C545 5v0_addh_sc_tile_0/5v0_half_adder_selector_sc_0/res_stage0 VDD_3V3_1 0.16177f
C546 5v0_addh_sc_tile_1/ternary_input 5v0_addh_sc_tile_2/m1_103_293# 0
C547 5v0_add_q_sc_1/5v0_half_adder_selector_sc_0/res_stage0 5v0_add_q_sc_1/ternary_input 0.27251f
C548 in_3 5v0_addh_sc_tile_2/a_382_n1095# 0.09307f
C549 VDD_3V3_1 5v0_add_q_sc_0/upstepper_test 0
C550 5v0_add_q_sc_1/ctrl_sign 5v0_addh_sc_tile_0/carry_sign_probe 0.00205f
C551 5v0_add_q_sc_1/downstepper_test 5v0_add_q_sc_1/inv_pti 0.07669f
C552 5v0_add_q_sc_1/nti VDD_3V3_1 0.53132f
C553 5v0_add_q_sc_0/pti VDD_1V65_5 0.00115f
C554 5v0_addh_sc_tile_1/a_382_n1095# 5v0_addh_sc_tile_1/m1_843_n857# 0.05013f
C555 5v0_add_q_sc_1/ctrl_over 5v0_add_q_sc_0/upstepper_test 0.01814f
C556 5v0_addh_sc_tile_0/a_n1778_n454# 5v0_addh_sc_tile_0/inv_nti 0.00226f
C557 5v0_addh_sc_tile_2/ctrl_sign 5v0_nter2oter_code_sc_1/gf180mcu_fd_sc_mcu7t5v0__nor2_1_0/a_224_472# 0.00643f
C558 5v0_add_q_sc_1/ctrl_over 5v0_addh_sc_tile_1/5v0_half_adder_selector_sc_0/5v0_tgate_sel_2_sc_1/input_A 0
C559 5v0_add_q_sc_1/nti 5v0_add_q_sc_1/ctrl_over 0.00725f
C560 5v0_addh_sc_tile_1/ternary_input 5v0_addh_sc_tile_1/inv_pti 0.05503f
C561 5v0_addh_sc_tile_0/pti 5v0_addh_sc_tile_1/inv_pti 0.00107f
C562 5v0_addh_sc_tile_2/downstepper_test 5v0_addh_sc_tile_1/nti 0
C563 5v0_addh_sc_tile_1/inv_pti in_2 0
C564 VDD_3V3_1 5v0_add_q_sc_1/downstepper_test 0.5246f
C565 5v0_addh_sc_tile_1/pti 5v0_addh_sc_tile_1/m1_843_n857# 0.11666f
C566 5v0_addh_sc_tile_0/inv_pti 5v0_addh_sc_tile_0/pti 0.46086f
C567 5v0_addh_sc_tile_0/inv_pti in_2 0.00153f
C568 5v0_addh_sc_tile_0/downstepper_test 5v0_addh_sc_tile_0/inv_nti 0.29989f
C569 5v0_nter2oter_code_sc_0/pti VDD_3V3_0 0.16094f
C570 5v0_add_q_sc_0/nti VDD_3V3_0 0.63243f
C571 5v0_add_q_sc_1/nti 5v0_addh_sc_tile_0/carry_0_probe 0.11163f
C572 5v0_addh_sc_tile_1/ternary_input in_0_sign 0
C573 5v0_add_q_sc_1/ctrl_over 5v0_add_q_sc_1/downstepper_test 0.12191f
C574 5v0_addh_sc_tile_2/a_n1778_n454# in_3 0.00182f
C575 5v0_addh_sc_tile_0/downstepper_test VDD_3V3_1 0.51272f
C576 5v0_addh_sc_tile_0/nti 5v0_nter2oter_code_sc_1/pti 0
C577 5v0_addh_sc_tile_0/pti in_0_sign 0.27027f
C578 VDD_1V65_3 5v0_addh_sc_tile_1/a_n1205_n937# 0.00354f
C579 in_0_over 5v0_addh_sc_tile_0/inv_nti 0.21462f
C580 5v0_nter2oter_code_sc_0/gf180mcu_fd_sc_mcu7t5v0__nor2_1_0/a_224_472# 5v0_nter2oter_code_sc_0/nti 0.00842f
C581 5v0_add_q_sc_1/5v0_half_adder_selector_sc_0/5v0_tgate_sel_2_sc_1/input_A 5v0_add_q_sc_1/downstepper_test 0
C582 VDD_3V3_1 in_0_over 0.64036f
C583 m1_n2844_n810# 5v0_addh_sc_tile_1/downstepper_test 0
C584 5v0_addh_sc_tile_1/inv_nti 5v0_addh_sc_tile_1/a_382_n1095# 0.28394f
C585 5v0_add_q_sc_0/inv_pti 5v0_add_q_sc_0/not_internal_0/a_56_472# 0.00721f
C586 5v0_addh_sc_tile_1/m1_843_n857# 5v0_addh_sc_tile_1/m1_103_293# 0.20659f
C587 5v0_addh_sc_tile_1/ctrl_over 5v0_add_q_sc_1/ctrl_sign 0
C588 5v0_addh_sc_tile_0/inv_nti VDD_1V65_0 0.08611f
C589 5v0_addh_sc_tile_1/ctrl_over 5v0_add_q_sc_0/inv_nti 0
C590 5v0_addh_sc_tile_1/not_internal_0/a_56_472# VDD_3V3_1 0.00965f
C591 VDD_3V3_1 VDD_1V65_0 0.04264f
C592 5v0_addh_sc_tile_1/inv_nti 5v0_addh_sc_tile_1/pti 0.42149f
C593 5v0_add_q_sc_0/5v0_half_adder_selector_sc_0/5v0_tgate_sel_2_sc_1/input_A 5v0_add_q_sc_0/upstepper_test 0
C594 5v0_addh_sc_tile_0/carry_0_probe in_0_over 0.12282f
C595 5v0_addh_sc_tile_1/inv_nti 5v0_addh_sc_tile_2/pti 0
C596 5v0_add_q_sc_0/ternary_input 5v0_add_q_sc_0/ctrl_over 0.15554f
C597 5v0_add_q_sc_0/5v0_half_adder_selector_sc_0/res_stage0 VDD_3V3_0 0.16909f
C598 5v0_addh_sc_tile_1/ctrl_over 5v0_nter2oter_code_sc_0/in 0.27181f
C599 5v0_addh_sc_tile_0/a_382_n1095# 5v0_addh_sc_tile_0/5v0_half_adder_selector_sc_0/5v0_tgate_sel_2_sc_1/input_A 0.02928f
C600 5v0_addh_sc_tile_1/not_internal_0/a_56_472# 5v0_addh_sc_tile_0/carry_0_probe 0.00281f
C601 5v0_addh_sc_tile_0/downstepper_test 5v0_addh_sc_tile_0/5v0_half_adder_selector_sc_0/res_stage0 0.25483f
C602 5v0_addh_sc_tile_1/inv_pti 5v0_addh_sc_tile_0/inv_nti 0
C603 5v0_addh_sc_tile_1/inv_nti 5v0_addh_sc_tile_1/m1_103_293# 0.35313f
C604 5v0_nter2oter_code_sc_1/gf180mcu_fd_sc_mcu7t5v0__nor2_1_0/a_224_472# 5v0_addh_sc_tile_1/downstepper_test 0
C605 5v0_add_q_sc_1/nti 5v0_add_q_sc_1/downstepper_test 0.06596f
C606 5v0_addh_sc_tile_1/inv_pti 5v0_addh_sc_tile_1/not_internal_0/a_36_68# 0.00668f
C607 VDD_3V3_1 5v0_addh_sc_tile_1/inv_pti 0.78076f
C608 5v0_addh_sc_tile_0/inv_pti 5v0_addh_sc_tile_0/inv_nti 0.25737f
C609 5v0_addh_sc_tile_0/5v0_half_adder_selector_sc_0/res_stage0 in_0_over 0.09179f
C610 5v0_nter2oter_code_sc_0/in 5v0_addh_sc_tile_2/nti 0.00515f
C611 5v0_nter2oter_code_sc_1/not_internal_0/a_36_68# 5v0_addh_sc_tile_2/pti 0
C612 5v0_addh_sc_tile_2/inv_pti VDD_1V65_4 0.14775f
C613 5v0_addh_sc_tile_0/inv_pti VDD_3V3_1 1.01941f
C614 5v0_addh_sc_tile_1/inv_pti 5v0_add_q_sc_1/ctrl_over 0.01474f
C615 5v0_addh_sc_tile_1/ternary_input 5v0_nter2oter_code_sc_1/pti 0
C616 5v0_addh_sc_tile_0/inv_nti in_0_sign 0.24892f
C617 5v0_addh_sc_tile_1/inv_nti 5v0_addh_sc_tile_0/a_382_n1095# 0
C618 5v0_addh_sc_tile_0/pti 5v0_nter2oter_code_sc_1/pti 0
C619 in_2 5v0_nter2oter_code_sc_1/pti 0.46287f
C620 5v0_add_q_sc_1/5v0_half_adder_selector_sc_0/res_stage0 5v0_add_q_sc_1/5v0_half_adder_selector_sc_0/m1_n239_179# 0.18379f
C621 5v0_add_q_sc_1/nti in_0_over 0.00117f
C622 5v0_addh_sc_tile_0/a_n1778_n454# 5v0_addh_sc_tile_0/downstepper_test 0.0031f
C623 VDD_3V3_1 in_0_sign 0.65887f
C624 5v0_addh_sc_tile_1/ternary_input 5v0_addh_sc_tile_2/a_382_n1095# 0
C625 5v0_add_q_sc_0/downstepper_test VDD_3V3_0 0.55734f
C626 5v0_nter2oter_code_sc_1/gf180mcu_fd_sc_mcu7t5v0__nor2_1_0/a_224_472# VDD_3V3_0 0.01562f
C627 res_c 5v0_add_q_sc_0/ctrl_over 0.20178f
C628 5v0_addh_sc_tile_1/ctrl_sign 5v0_add_q_sc_1/ctrl_sign 0.24986f
C629 5v0_add_q_sc_0/ternary_input 5v0_add_q_sc_0/5v0_half_adder_selector_sc_0/m1_n239_179# 0.00189f
C630 5v0_addh_sc_tile_0/carry_0_probe 5v0_addh_sc_tile_1/inv_pti 0.01474f
C631 5v0_add_q_sc_0/pti 5v0_addh_sc_tile_1/a_382_n1095# 0
C632 5v0_addh_sc_tile_2/inv_pti 5v0_addh_sc_tile_2/not_internal_0/a_36_68# 0.00668f
C633 VDD_1V65_5 5v0_add_q_sc_0/ctrl_over 0
C634 5v0_addh_sc_tile_1/upstepper_test m1_n2844_n810# 0.00447f
C635 5v0_addh_sc_tile_0/inv_pti 5v0_addh_sc_tile_0/carry_0_probe 0.01451f
C636 5v0_addh_sc_tile_2/inv_nti VDD_1V65_4 0.08611f
C637 5v0_addh_sc_tile_2/inv_pti 5v0_add_q_sc_0/upstepper_test 0
C638 in_0_over 5v0_add_q_sc_1/downstepper_test 0
C639 5v0_nter2oter_code_sc_0/in 5v0_add_q_sc_0/ctrl_sign 0.01026f
C640 5v0_addh_sc_tile_1/inv_nti 5v0_addh_sc_tile_1/5v0_half_adder_selector_sc_0/res_stage0 0.02399f
C641 5v0_add_q_sc_0/5v0_half_adder_selector_sc_0/m1_n244_n517# VDD_3V3_0 0.29978f
C642 5v0_addh_sc_tile_1/ctrl_over 5v0_add_q_sc_0/ternary_input 0.01695f
C643 5v0_addh_sc_tile_0/a_n1778_n454# VDD_1V65_0 0
C644 5v0_addh_sc_tile_0/carry_0_probe in_0_sign 0.01013f
C645 5v0_add_q_sc_1/ctrl_sign 5v0_addh_sc_tile_0/m1_843_n857# 0
C646 5v0_addh_sc_tile_0/downstepper_test in_0_over 0.02344f
C647 5v0_add_q_sc_0/inv_pti 5v0_addh_sc_tile_1/m1_843_n857# 0
C648 5v0_addh_sc_tile_2/ctrl_over 5v0_addh_sc_tile_1/inv_nti 0.00155f
C649 in_3 5v0_nter2oter_code_sc_0/pti 0.00239f
C650 5v0_addh_sc_tile_0/a_n1373_n454# 5v0_addh_sc_tile_0/nti 0
C651 5v0_addh_sc_tile_1/ctrl_sign 5v0_nter2oter_code_sc_0/in 0.00797f
C652 5v0_add_q_sc_1/ternary_input 5v0_addh_sc_tile_1/m1_103_293# 0
C653 5v0_addh_sc_tile_0/downstepper_test VDD_1V65_0 0.13024f
C654 5v0_addh_sc_tile_0/inv_pti 5v0_addh_sc_tile_0/5v0_half_adder_selector_sc_0/res_stage0 0.01365f
C655 5v0_nter2oter_code_sc_1/nti in_1 0
C656 5v0_addh_sc_tile_0/5v0_half_adder_selector_sc_0/res_stage0 in_0_sign 0.22359f
C657 5v0_add_q_sc_1/nti 5v0_addh_sc_tile_1/inv_pti 0.00413f
C658 5v0_addh_sc_tile_1/not_internal_0/a_56_472# in_0_over 0
C659 m1_n2844_n810# 5v0_add_q_sc_1/inv_nti 0.00427f
C660 5v0_addh_sc_tile_1/ctrl_over 5v0_addh_sc_tile_1/a_n1205_n937# 0.00169f
C661 in_0_over VDD_1V65_0 0.00145f
C662 5v0_addh_sc_tile_0/inv_pti 5v0_add_q_sc_1/nti 0
C663 5v0_addh_sc_tile_0/inv_nti 5v0_nter2oter_code_sc_1/pti 0.00572f
C664 5v0_add_q_sc_0/a_n1373_n454# VDD_3V3_0 0.00122f
C665 5v0_add_q_sc_0/inv_pti 5v0_addh_sc_tile_1/inv_nti 0
C666 5v0_add_q_sc_1/nti in_0_sign 0
C667 5v0_addh_sc_tile_1/ctrl_over res_c 0
C668 5v0_addh_sc_tile_2/a_n1205_n937# VDD_1V65_4 0.00354f
C669 5v0_addh_sc_tile_1/inv_pti 5v0_add_q_sc_1/downstepper_test 0.00756f
C670 in_1 5v0_addh_sc_tile_0/m1_103_293# 0
C671 VDD_3V3_1 5v0_nter2oter_code_sc_1/pti 0.29125f
C672 5v0_addh_sc_tile_1/ctrl_over VDD_1V65_5 0
C673 5v0_nter2oter_code_sc_0/in 5v0_addh_sc_tile_2/ctrl_sign 0.30412f
C674 5v0_add_q_sc_0/ctrl_sign 5v0_add_q_sc_0/ternary_input 0.00264f
C675 5v0_nter2oter_code_sc_0/pti 5v0_addh_sc_tile_0/nti 0
C676 VDD_1V65_3 5v0_addh_sc_tile_1/pti 0.00234f
C677 5v0_addh_sc_tile_2/inv_pti 5v0_addh_sc_tile_2/m1_103_293# 0.17639f
C678 5v0_addh_sc_tile_0/inv_pti 5v0_addh_sc_tile_0/downstepper_test 0.14186f
C679 5v0_add_q_sc_0/inv_pti 5v0_add_q_sc_0/not_internal_0/a_36_68# 0.00668f
C680 5v0_addh_sc_tile_1/inv_pti in_0_over 0.00926f
C681 5v0_addh_sc_tile_1/ctrl_sign 5v0_add_q_sc_0/ternary_input 0
C682 5v0_addh_sc_tile_0/downstepper_test in_0_sign 0.14463f
C683 5v0_addh_sc_tile_0/inv_pti in_0_over 0
C684 5v0_addh_sc_tile_2/inv_pti 5v0_addh_sc_tile_2/inv_nti 0.2615f
C685 5v0_addh_sc_tile_0/a_n1373_n454# 5v0_addh_sc_tile_0/pti 0
C686 5v0_nter2oter_code_sc_1/nti 5v0_addh_sc_tile_1/pti 0
C687 5v0_addh_sc_tile_1/not_internal_0/a_56_472# 5v0_addh_sc_tile_1/inv_pti 0.0108f
C688 in_0_over in_0_sign 0.05861f
C689 5v0_addh_sc_tile_2/5v0_half_adder_selector_sc_0/res_stage0 5v0_add_q_sc_0/ctrl_over 0
C690 5v0_add_q_sc_1/not_internal_0/a_36_68# 5v0_add_q_sc_1/pti 0.01356f
C691 5v0_addh_sc_tile_2/inv_pti 5v0_addh_sc_tile_1/inv_pti 0
C692 5v0_addh_sc_tile_2/a_n1373_n454# VDD_1V65_4 0.00232f
C693 5v0_addh_sc_tile_2/inv_nti 5v0_addh_sc_tile_2/m1_103_293# 0.35313f
C694 5v0_nter2oter_code_sc_1/nti 5v0_addh_sc_tile_2/pti 0
C695 5v0_addh_sc_tile_0/inv_pti VDD_1V65_0 0.14775f
C696 5v0_addh_sc_tile_1/inv_pti 5v0_addh_sc_tile_2/m1_103_293# 0
C697 5v0_addh_sc_tile_1/nti 5v0_addh_sc_tile_1/inv_nti 0.22702f
C698 5v0_addh_sc_tile_1/pti 5v0_addh_sc_tile_0/m1_103_293# 0.00135f
C699 5v0_add_q_sc_0/ctrl_sign res_c 0
C700 5v0_addh_sc_tile_1/a_382_n1095# 5v0_add_q_sc_0/ctrl_over 0
C701 5v0_add_q_sc_1/ctrl_sign 5v0_addh_sc_tile_1/downstepper_test 0
C702 5v0_addh_sc_tile_2/inv_nti 5v0_addh_sc_tile_1/inv_pti 0
C703 5v0_addh_sc_tile_2/ctrl_sign 5v0_add_q_sc_0/ternary_input 0
C704 5v0_add_q_sc_0/inv_pti 5v0_add_q_sc_0/pti 0.21601f
C705 5v0_addh_sc_tile_2/a_382_n1095# 5v0_add_q_sc_0/upstepper_test 0
C706 5v0_addh_sc_tile_1/ternary_input 5v0_nter2oter_code_sc_0/pti 0
C707 5v0_nter2oter_code_sc_0/pti in_2 0.00216f
C708 5v0_addh_sc_tile_2/a_n1778_n454# VDD_1V65_4 0
C709 5v0_addh_sc_tile_2/pti 5v0_add_q_sc_0/ctrl_over 0.1334f
C710 5v0_addh_sc_tile_1/ctrl_over in_1 0
C711 5v0_nter2oter_code_sc_0/in 5v0_addh_sc_tile_1/downstepper_test 0.03365f
C712 5v0_addh_sc_tile_1/inv_pti in_0_sign 0.00171f
C713 5v0_addh_sc_tile_0/inv_pti in_0_sign 0.23041f
C714 5v0_add_q_sc_0/inv_nti VDD_3V3_0 0.56479f
C715 5v0_addh_sc_tile_0/downstepper_test 5v0_nter2oter_code_sc_1/pti 0.00869f
C716 5v0_addh_sc_tile_0/a_382_n1095# 5v0_addh_sc_tile_0/m1_103_293# 0.07764f
C717 5v0_addh_sc_tile_0/a_n1373_n454# 5v0_addh_sc_tile_0/inv_nti 0
C718 5v0_addh_sc_tile_1/a_382_n1095# 5v0_add_q_sc_0/5v0_half_adder_selector_sc_0/m1_n239_179# 0.0035f
C719 5v0_addh_sc_tile_1/a_n1373_n454# 5v0_addh_sc_tile_1/pti 0
C720 5v0_addh_sc_tile_0/a_n1373_n454# VDD_3V3_1 0.00122f
C721 5v0_add_q_sc_0/nti 5v0_add_q_sc_0/a_n1778_n454# 0.00142f
C722 5v0_addh_sc_tile_2/ctrl_over 5v0_nter2oter_code_sc_1/nti 0
C723 5v0_addh_sc_tile_2/inv_nti 5v0_addh_sc_tile_2/a_n1205_n937# 0
C724 5v0_nter2oter_code_sc_0/in VDD_3V3_0 2.39752f
C725 5v0_addh_sc_tile_1/pti 5v0_add_q_sc_0/5v0_half_adder_selector_sc_0/m1_n239_179# 0
C726 5v0_addh_sc_tile_1/ctrl_over 5v0_addh_sc_tile_1/a_382_n1095# 0.70472f
C727 m1_n2844_n810# 5v0_addh_sc_tile_0/pti 0.00645f
C728 5v0_addh_sc_tile_2/5v0_half_adder_selector_sc_0/res_stage0 5v0_addh_sc_tile_2/nti 0.00372f
C729 5v0_addh_sc_tile_2/pti 5v0_add_q_sc_0/5v0_half_adder_selector_sc_0/m1_n239_179# 0
C730 5v0_addh_sc_tile_2/inv_pti 5v0_addh_sc_tile_2/a_n1373_n454# 0.00135f
C731 5v0_addh_sc_tile_0/a_382_n1095# 5v0_addh_sc_tile_0/carry_sign_probe 0.02324f
C732 res_0 5v0_add_q_sc_0/ctrl_over 0
C733 5v0_addh_sc_tile_2/inv_pti 5v0_addh_sc_tile_2/a_382_n1095# 0.00129f
C734 5v0_addh_sc_tile_1/ctrl_over 5v0_addh_sc_tile_1/pti 0.11567f
C735 5v0_addh_sc_tile_1/upstepper_test 5v0_add_q_sc_1/ctrl_sign 0
C736 5v0_add_q_sc_0/5v0_half_adder_selector_sc_0/m1_n239_179# 5v0_addh_sc_tile_1/m1_103_293# 0
C737 5v0_addh_sc_tile_2/a_382_n1095# 5v0_addh_sc_tile_2/m1_103_293# 0.07764f
C738 5v0_addh_sc_tile_1/ctrl_over 5v0_addh_sc_tile_2/pti 0.0015f
C739 5v0_add_q_sc_1/ternary_input 5v0_add_q_sc_1/a_n1205_n937# 0
C740 5v0_nter2oter_code_sc_0/pti 5v0_addh_sc_tile_0/inv_nti 0.00544f
C741 5v0_addh_sc_tile_1/ctrl_sign in_1 0.01394f
C742 5v0_addh_sc_tile_2/ctrl_over 5v0_add_q_sc_0/ctrl_over 0.14755f
C743 5v0_addh_sc_tile_2/inv_nti 5v0_addh_sc_tile_2/a_n1373_n454# 0
C744 VDD_3V3_1 5v0_nter2oter_code_sc_0/pti 0.29117f
C745 5v0_addh_sc_tile_2/m1_843_n857# 5v0_add_q_sc_0/ternary_input 0
C746 5v0_add_q_sc_0/pti 5v0_add_q_sc_0/not_internal_0/a_56_472# 0.01309f
C747 5v0_addh_sc_tile_2/inv_nti 5v0_addh_sc_tile_2/a_382_n1095# 0.28654f
C748 5v0_addh_sc_tile_1/ctrl_over 5v0_addh_sc_tile_1/m1_103_293# 0.02786f
C749 5v0_add_q_sc_0/nti 5v0_add_q_sc_1/ctrl_over 0.01581f
C750 5v0_addh_sc_tile_1/upstepper_test 5v0_nter2oter_code_sc_0/in 0.00268f
C751 5v0_addh_sc_tile_0/inv_pti 5v0_nter2oter_code_sc_1/pti 0
C752 5v0_addh_sc_tile_2/pti 5v0_addh_sc_tile_2/nti 0.24563f
C753 5v0_addh_sc_tile_1/inv_pti 5v0_addh_sc_tile_2/a_382_n1095# 0
C754 5v0_addh_sc_tile_2/5v0_half_adder_selector_sc_0/5v0_tgate_sel_2_sc_1/input_A 5v0_addh_sc_tile_2/a_382_n1095# 0.02928f
C755 5v0_addh_sc_tile_0/m1_843_n857# in_1 0
C756 5v0_add_q_sc_0/ternary_input VDD_3V3_0 1.58144f
C757 5v0_add_q_sc_0/ctrl_sign 5v0_addh_sc_tile_1/a_382_n1095# 0.0169f
C758 5v0_addh_sc_tile_1/a_n1205_n937# 5v0_addh_sc_tile_1/downstepper_test 0.00453f
C759 5v0_addh_sc_tile_1/nti VDD_1V65_3 0.21326f
C760 5v0_addh_sc_tile_1/inv_nti 5v0_addh_sc_tile_1/m1_843_n857# 0.36668f
C761 5v0_add_q_sc_1/not_internal_0/a_56_472# 5v0_add_q_sc_1/pti 0.01309f
C762 5v0_nter2oter_code_sc_0/pti 5v0_nter2oter_code_sc_0/nti 0.00242f
C763 5v0_add_q_sc_1/inv_nti 5v0_add_q_sc_1/ctrl_sign 0.10099f
C764 5v0_addh_sc_tile_1/ctrl_over 5v0_addh_sc_tile_0/a_382_n1095# 0
C765 5v0_add_q_sc_1/not_internal_0/a_36_68# 5v0_add_q_sc_1/inv_pti 0.00668f
C766 5v0_addh_sc_tile_1/ctrl_sign 5v0_addh_sc_tile_1/a_382_n1095# 0.07412f
C767 5v0_add_q_sc_1/ternary_input 5v0_add_q_sc_1/5v0_half_adder_selector_sc_0/m1_n244_n517# 0.07888f
C768 5v0_add_q_sc_1/ternary_input 5v0_add_q_sc_1/a_n1778_n454# 0.00116f
C769 5v0_add_q_sc_0/inv_pti 5v0_add_q_sc_0/ctrl_over 0
C770 5v0_add_q_sc_0/ctrl_sign 5v0_addh_sc_tile_1/pti 0
C771 m1_n2844_n810# 5v0_addh_sc_tile_0/inv_nti 0.02458f
C772 5v0_addh_sc_tile_2/inv_nti 5v0_addh_sc_tile_2/a_n1778_n454# 0.00226f
C773 5v0_addh_sc_tile_2/ctrl_over 5v0_add_q_sc_0/5v0_half_adder_selector_sc_0/m1_n239_179# 0.00716f
C774 5v0_addh_sc_tile_1/nti 5v0_nter2oter_code_sc_1/nti 0.20023f
C775 5v0_add_q_sc_0/a_n1778_n454# 5v0_add_q_sc_0/downstepper_test 0.0031f
C776 5v0_add_q_sc_0/ctrl_sign 5v0_addh_sc_tile_2/pti 0.011f
C777 5v0_addh_sc_tile_1/a_n1205_n937# VDD_3V3_0 0.00891f
C778 m1_n2844_n810# VDD_3V3_1 0.14975f
C779 5v0_addh_sc_tile_0/a_n1373_n454# 5v0_addh_sc_tile_0/downstepper_test 0.00442f
C780 5v0_nter2oter_code_sc_1/pti 5v0_nter2oter_code_sc_1/not_internal_0/a_56_472# 0
C781 5v0_addh_sc_tile_1/ctrl_sign 5v0_addh_sc_tile_1/pti 0.48502f
C782 5v0_addh_sc_tile_1/ctrl_over 5v0_addh_sc_tile_1/5v0_half_adder_selector_sc_0/res_stage0 0.11033f
C783 5v0_addh_sc_tile_1/ctrl_sign 5v0_addh_sc_tile_2/pti 0
C784 5v0_addh_sc_tile_2/5v0_half_adder_selector_sc_0/res_stage0 5v0_addh_sc_tile_2/ctrl_sign 0.25152f
C785 res_c VDD_3V3_0 0.09697f
C786 5v0_addh_sc_tile_1/ctrl_over 5v0_addh_sc_tile_2/ctrl_over 0.02299f
C787 5v0_addh_sc_tile_1/nti 5v0_addh_sc_tile_0/m1_103_293# 0
C788 res_0 5v0_addh_sc_tile_2/nti 0
C789 VDD_1V65_5 VDD_3V3_0 0.04709f
C790 5v0_add_q_sc_0/nti 5v0_add_q_sc_0/upstepper_test 0.11981f
C791 m1_n2844_n810# 5v0_addh_sc_tile_0/carry_0_probe 0.42968f
C792 5v0_addh_sc_tile_0/m1_843_n857# 5v0_addh_sc_tile_1/pti 0
C793 5v0_addh_sc_tile_2/nti 5v0_addh_sc_tile_2/not_internal_0/a_56_472# 0.0036f
C794 in_3 5v0_nter2oter_code_sc_0/in 0.01006f
C795 5v0_addh_sc_tile_0/a_n1373_n454# VDD_1V65_0 0.00232f
C796 5v0_add_q_sc_1/ctrl_sign 5v0_add_q_sc_1/pti 0.15382f
C797 5v0_addh_sc_tile_1/ctrl_sign 5v0_addh_sc_tile_1/m1_103_293# 0.60951f
C798 5v0_add_q_sc_1/ternary_input 5v0_add_q_sc_1/a_n1373_n454# 0.00136f
C799 5v0_addh_sc_tile_2/ctrl_over 5v0_addh_sc_tile_2/nti 0.00653f
C800 5v0_add_q_sc_0/inv_pti 5v0_add_q_sc_0/5v0_half_adder_selector_sc_0/m1_n239_179# 0
C801 5v0_addh_sc_tile_2/ctrl_sign 5v0_addh_sc_tile_1/pti 0
C802 5v0_addh_sc_tile_1/ctrl_sign 5v0_addh_sc_tile_0/a_382_n1095# 0.01186f
C803 5v0_add_q_sc_0/pti 5v0_addh_sc_tile_1/m1_843_n857# 0.00111f
C804 5v0_add_q_sc_1/ctrl_over 5v0_add_q_sc_0/downstepper_test 0.0085f
C805 5v0_addh_sc_tile_0/downstepper_test 5v0_nter2oter_code_sc_0/pti 0.00301f
C806 5v0_addh_sc_tile_1/ctrl_over 5v0_add_q_sc_0/inv_pti 0.00152f
C807 5v0_addh_sc_tile_1/upstepper_test 5v0_addh_sc_tile_1/a_n1205_n937# 0.00334f
C808 in_1 5v0_addh_sc_tile_0/not_internal_0/a_36_68# 0
C809 5v0_addh_sc_tile_2/ctrl_sign 5v0_addh_sc_tile_2/pti 0.28212f
C810 5v0_add_q_sc_0/ctrl_sign 5v0_addh_sc_tile_1/5v0_half_adder_selector_sc_0/res_stage0 0
C811 5v0_add_q_sc_0/5v0_half_adder_selector_sc_0/5v0_tgate_sel_2_sc_1/input_A 5v0_add_q_sc_0/5v0_half_adder_selector_sc_0/res_stage0 0.00253f
C812 5v0_add_q_sc_0/5v0_half_adder_selector_sc_0/res_stage0 5v0_add_q_sc_0/upstepper_test 0.27475f
C813 m1_n2844_n810# 5v0_add_q_sc_1/nti 0.00573f
C814 5v0_addh_sc_tile_2/ctrl_over 5v0_add_q_sc_0/ctrl_sign 0.2177f
C815 5v0_addh_sc_tile_0/a_n1373_n454# 5v0_addh_sc_tile_0/inv_pti 0.00135f
C816 5v0_addh_sc_tile_0/a_382_n1095# 5v0_addh_sc_tile_0/m1_843_n857# 0.05013f
C817 5v0_addh_sc_tile_1/nti 5v0_addh_sc_tile_1/a_n1373_n454# 0
C818 5v0_add_q_sc_1/not_internal_0/a_36_68# 5v0_add_q_sc_1/nti 0.00259f
C819 5v0_nter2oter_code_sc_0/in 5v0_addh_sc_tile_0/nti 0.0033f
C820 5v0_addh_sc_tile_2/5v0_half_adder_selector_sc_0/res_stage0 5v0_addh_sc_tile_2/upstepper_test 0.27475f
C821 5v0_addh_sc_tile_1/ctrl_sign 5v0_addh_sc_tile_1/5v0_half_adder_selector_sc_0/res_stage0 0.22639f
C822 5v0_addh_sc_tile_1/inv_nti 5v0_add_q_sc_1/ternary_input 0
C823 5v0_addh_sc_tile_2/downstepper_test 5v0_addh_sc_tile_2/nti 0.06935f
C824 5v0_add_q_sc_1/not_internal_0/a_36_68# 5v0_add_q_sc_1/downstepper_test 0.00136f
C825 5v0_addh_sc_tile_0/downstepper_test m1_n2844_n810# 0
C826 5v0_add_q_sc_1/ctrl_sign 5v0_add_q_sc_1/VDD_1V65 0
C827 5v0_add_q_sc_1/5v0_half_adder_selector_sc_0/m1_n239_179# 5v0_add_q_sc_1/5v0_half_adder_selector_sc_0/m1_n244_n517# 0.00585f
C828 m1_n2844_n810# in_0_over 0.00329f
C829 5v0_addh_sc_tile_1/ctrl_over 5v0_addh_sc_tile_1/nti 0.0764f
C830 5v0_add_q_sc_0/5v0_half_adder_selector_sc_0/5v0_tgate_sel_2_sc_1/input_A 5v0_add_q_sc_0/downstepper_test 0
C831 5v0_add_q_sc_0/inv_pti 5v0_add_q_sc_0/ctrl_sign 0.00263f
C832 5v0_addh_sc_tile_0/upstepper_test in_1 0.01616f
C833 5v0_add_q_sc_0/downstepper_test 5v0_add_q_sc_0/upstepper_test 0.38867f
C834 5v0_addh_sc_tile_1/a_382_n1095# 5v0_addh_sc_tile_1/downstepper_test 0.00679f
C835 5v0_add_q_sc_0/not_internal_0/a_36_68# 5v0_add_q_sc_0/pti 0.01356f
C836 5v0_addh_sc_tile_2/ctrl_sign 5v0_addh_sc_tile_2/not_internal_0/a_56_472# 0.00299f
C837 5v0_addh_sc_tile_2/downstepper_test 5v0_add_q_sc_0/ctrl_sign 0
C838 5v0_addh_sc_tile_2/pti 5v0_addh_sc_tile_2/upstepper_test 0.02442f
C839 5v0_addh_sc_tile_2/5v0_half_adder_selector_sc_0/res_stage0 VDD_3V3_0 0.16541f
C840 5v0_addh_sc_tile_1/ctrl_sign 5v0_add_q_sc_0/inv_pti 0
C841 5v0_addh_sc_tile_0/pti 5v0_add_q_sc_1/ctrl_sign 0.00768f
C842 5v0_add_q_sc_0/5v0_half_adder_selector_sc_0/5v0_tgate_sel_2_sc_1/input_A 5v0_add_q_sc_0/5v0_half_adder_selector_sc_0/m1_n244_n517# 0.02928f
C843 5v0_add_q_sc_1/not_internal_0/a_56_472# 5v0_add_q_sc_1/inv_pti 0.00721f
C844 5v0_addh_sc_tile_2/ctrl_over 5v0_addh_sc_tile_2/ctrl_sign 0.6329f
C845 5v0_addh_sc_tile_1/pti 5v0_addh_sc_tile_1/downstepper_test 0.19626f
C846 5v0_addh_sc_tile_1/a_382_n1095# VDD_3V3_0 0.61113f
C847 5v0_addh_sc_tile_1/ctrl_over 5v0_add_q_sc_0/not_internal_0/a_56_472# 0.00121f
C848 5v0_addh_sc_tile_1/ternary_input 5v0_nter2oter_code_sc_0/in 0.17192f
C849 5v0_addh_sc_tile_1/inv_nti VDD_1V65_3 0.08611f
C850 VDD_3V3_1 5v0_add_q_sc_1/not_internal_0/a_56_472# 0.00965f
C851 5v0_nter2oter_code_sc_0/in in_2 0.00885f
C852 5v0_addh_sc_tile_2/inv_nti 5v0_add_q_sc_0/5v0_half_adder_selector_sc_0/res_stage0 0
C853 5v0_addh_sc_tile_2/pti 5v0_addh_sc_tile_2/m1_843_n857# 0.11666f
C854 5v0_addh_sc_tile_1/pti VDD_3V3_0 0.08682f
C855 5v0_addh_sc_tile_1/downstepper_test 5v0_addh_sc_tile_1/m1_103_293# 0.10533f
C856 m1_n2844_n810# 5v0_addh_sc_tile_1/inv_pti 0
C857 5v0_add_q_sc_0/inv_nti 5v0_add_q_sc_0/a_n1778_n454# 0.00214f
C858 5v0_addh_sc_tile_1/nti 5v0_add_q_sc_0/ctrl_sign 0
C859 5v0_nter2oter_code_sc_0/pti 5v0_nter2oter_code_sc_1/not_internal_0/a_56_472# 0
C860 5v0_addh_sc_tile_0/inv_pti m1_n2844_n810# 0.00753f
C861 5v0_addh_sc_tile_2/pti VDD_3V3_0 0.65511f
C862 5v0_addh_sc_tile_1/inv_nti 5v0_nter2oter_code_sc_1/nti 0.00252f
C863 5v0_addh_sc_tile_2/inv_pti 5v0_nter2oter_code_sc_1/gf180mcu_fd_sc_mcu7t5v0__nor2_1_0/a_224_472# 0
C864 5v0_add_q_sc_0/a_n1373_n454# 5v0_add_q_sc_0/upstepper_test 0
C865 m1_n2844_n810# in_0_sign 0.0018f
C866 5v0_addh_sc_tile_1/ctrl_sign 5v0_addh_sc_tile_1/nti 0.14567f
C867 5v0_addh_sc_tile_2/downstepper_test 5v0_addh_sc_tile_2/ctrl_sign 0.20835f
C868 5v0_add_q_sc_1/ctrl_sign 5v0_add_q_sc_1/inv_pti 0.06012f
C869 5v0_addh_sc_tile_2/upstepper_test 5v0_addh_sc_tile_2/not_internal_0/a_56_472# 0
C870 VDD_3V3_0 5v0_addh_sc_tile_1/m1_103_293# 0.14668f
C871 5v0_addh_sc_tile_2/ctrl_over 5v0_addh_sc_tile_2/upstepper_test 0.16997f
C872 5v0_add_q_sc_1/ctrl_sign 5v0_addh_sc_tile_0/inv_nti 0.00142f
C873 5v0_addh_sc_tile_1/nti 5v0_addh_sc_tile_0/m1_843_n857# 0
C874 5v0_addh_sc_tile_2/inv_nti 5v0_add_q_sc_0/downstepper_test 0
C875 VDD_3V3_1 5v0_add_q_sc_1/ctrl_sign 1.06824f
C876 5v0_addh_sc_tile_0/a_382_n1095# VDD_3V3_0 0
C877 5v0_addh_sc_tile_1/5v0_half_adder_selector_sc_0/res_stage0 5v0_addh_sc_tile_1/downstepper_test 0.25483f
C878 5v0_nter2oter_code_sc_0/pti 5v0_nter2oter_code_sc_1/pti 0.24182f
C879 5v0_add_q_sc_1/ctrl_sign 5v0_add_q_sc_1/ctrl_over 0.02923f
C880 5v0_addh_sc_tile_2/ctrl_over 5v0_addh_sc_tile_1/downstepper_test 0.01399f
C881 5v0_addh_sc_tile_1/upstepper_test 5v0_addh_sc_tile_1/pti 0.02177f
C882 5v0_add_q_sc_0/inv_nti 5v0_add_q_sc_1/ctrl_over 0
C883 5v0_add_q_sc_0/nti 5v0_addh_sc_tile_2/a_382_n1095# 0
C884 5v0_addh_sc_tile_2/inv_nti 5v0_add_q_sc_0/5v0_half_adder_selector_sc_0/m1_n244_n517# 0
C885 5v0_add_q_sc_1/5v0_half_adder_selector_sc_0/5v0_tgate_sel_2_sc_1/input_A 5v0_add_q_sc_1/ctrl_sign 0
C886 5v0_add_q_sc_1/nti 5v0_add_q_sc_1/not_internal_0/a_56_472# 0
C887 5v0_addh_sc_tile_1/nti 5v0_addh_sc_tile_2/ctrl_sign 0.01236f
C888 5v0_nter2oter_code_sc_0/in 5v0_addh_sc_tile_0/inv_nti 0.00631f
C889 res_0 VDD_3V3_0 0.09575f
C890 5v0_addh_sc_tile_0/carry_0_probe 5v0_add_q_sc_1/ctrl_sign 0.01576f
C891 5v0_addh_sc_tile_2/ctrl_over 5v0_addh_sc_tile_2/m1_843_n857# 0.10619f
C892 VDD_3V3_0 5v0_addh_sc_tile_2/not_internal_0/a_56_472# 0.00965f
C893 5v0_nter2oter_code_sc_0/in VDD_3V3_1 0.92139f
C894 5v0_addh_sc_tile_1/5v0_half_adder_selector_sc_0/res_stage0 VDD_3V3_0 0.11354f
C895 5v0_nter2oter_code_sc_0/in 5v0_add_q_sc_1/ctrl_over 0
C896 5v0_addh_sc_tile_2/ctrl_over VDD_3V3_0 2.01214f
C897 5v0_add_q_sc_1/not_internal_0/a_56_472# 5v0_add_q_sc_1/downstepper_test 0
C898 5v0_addh_sc_tile_0/pti VDD_1V65_2 0
C899 5v0_addh_sc_tile_1/ctrl_over 5v0_addh_sc_tile_1/m1_843_n857# 0.10251f
C900 5v0_addh_sc_tile_1/upstepper_test 5v0_addh_sc_tile_1/m1_103_293# 0.07773f
C901 in_3 5v0_addh_sc_tile_2/5v0_half_adder_selector_sc_0/res_stage0 0.26626f
C902 5v0_add_q_sc_0/a_n1778_n454# 5v0_add_q_sc_0/ternary_input 0.00116f
C903 5v0_addh_sc_tile_2/downstepper_test 5v0_addh_sc_tile_2/upstepper_test 0.38555f
C904 5v0_addh_sc_tile_1/inv_nti 5v0_addh_sc_tile_1/a_n1373_n454# 0
C905 5v0_nter2oter_code_sc_0/in 5v0_nter2oter_code_sc_0/nti 0.23801f
C906 5v0_add_q_sc_1/inv_nti 5v0_addh_sc_tile_1/pti 0.00257f
C907 5v0_addh_sc_tile_1/upstepper_test 5v0_addh_sc_tile_0/a_382_n1095# 0.00208f
C908 5v0_add_q_sc_1/ternary_input 5v0_addh_sc_tile_0/m1_103_293# 0
C909 5v0_add_q_sc_0/5v0_half_adder_selector_sc_0/res_stage0 5v0_addh_sc_tile_2/a_382_n1095# 0.0013f
C910 5v0_addh_sc_tile_1/inv_nti 5v0_add_q_sc_0/5v0_half_adder_selector_sc_0/m1_n239_179# 0
C911 5v0_add_q_sc_1/5v0_half_adder_selector_sc_0/m1_n239_179# 5v0_add_q_sc_1/ternary_input 0.00189f
C912 5v0_addh_sc_tile_0/nti in_1 0.52138f
C913 5v0_add_q_sc_1/nti 5v0_add_q_sc_1/ctrl_sign 0.2845f
C914 5v0_add_q_sc_0/inv_nti 5v0_add_q_sc_0/upstepper_test 0.0011f
C915 5v0_add_q_sc_0/inv_pti VDD_3V3_0 0.38011f
C916 5v0_addh_sc_tile_1/ctrl_over 5v0_addh_sc_tile_1/inv_nti 0.46829f
C917 5v0_add_q_sc_1/inv_nti 5v0_addh_sc_tile_1/m1_103_293# 0.00334f
C918 5v0_addh_sc_tile_1/nti 5v0_addh_sc_tile_2/upstepper_test 0.00102f
C919 5v0_addh_sc_tile_1/upstepper_test 5v0_addh_sc_tile_1/5v0_half_adder_selector_sc_0/res_stage0 0.27475f
C920 in_3 5v0_addh_sc_tile_2/pti 0.66374f
C921 5v0_addh_sc_tile_2/downstepper_test VDD_3V3_0 0.52402f
C922 VDD_3V3_1 5v0_add_q_sc_0/ternary_input 0.20806f
C923 5v0_add_q_sc_1/ctrl_sign 5v0_add_q_sc_1/downstepper_test 0.25694f
C924 VDD_1V65_5 5v0_add_q_sc_0/a_n1778_n454# 0
C925 5v0_add_q_sc_0/pti 5v0_add_q_sc_0/ctrl_over 0
C926 5v0_addh_sc_tile_1/upstepper_test 5v0_addh_sc_tile_2/ctrl_over 0
C927 5v0_add_q_sc_1/ternary_input 5v0_addh_sc_tile_0/carry_sign_probe 0.05455f
C928 5v0_add_q_sc_1/ctrl_over 5v0_add_q_sc_0/ternary_input 0.30261f
C929 5v0_addh_sc_tile_0/a_382_n1095# 5v0_add_q_sc_1/inv_nti 0
C930 5v0_addh_sc_tile_1/nti 5v0_addh_sc_tile_1/downstepper_test 0.06935f
C931 5v0_addh_sc_tile_0/upstepper_test 5v0_addh_sc_tile_0/not_internal_0/a_56_472# 0
C932 5v0_addh_sc_tile_1/pti 5v0_add_q_sc_1/pti 0
C933 5v0_add_q_sc_0/downstepper_test 5v0_addh_sc_tile_2/a_382_n1095# 0.00139f
C934 5v0_addh_sc_tile_1/ctrl_sign 5v0_addh_sc_tile_1/m1_843_n857# 0.24363f
C935 in_0_over 5v0_add_q_sc_1/ctrl_sign 0.00327f
C936 5v0_addh_sc_tile_1/ctrl_over 5v0_nter2oter_code_sc_1/not_internal_0/a_36_68# 0.00411f
C937 VDD_3V3_1 VDD_1V65_2 0.01209f
C938 5v0_add_q_sc_1/5v0_half_adder_selector_sc_0/res_stage0 5v0_add_q_sc_1/inv_pti 0
C939 5v0_add_q_sc_0/5v0_half_adder_selector_sc_0/m1_n244_n517# 5v0_addh_sc_tile_2/a_382_n1095# 0
C940 5v0_addh_sc_tile_1/nti VDD_3V3_0 0.4444f
C941 5v0_addh_sc_tile_1/inv_nti 5v0_add_q_sc_0/ctrl_sign 0
C942 in_3 res_0 0.16326f
C943 5v0_add_q_sc_1/5v0_half_adder_selector_sc_0/res_stage0 VDD_3V3_1 0.14945f
C944 5v0_addh_sc_tile_1/ternary_input in_1 0.18462f
C945 5v0_addh_sc_tile_0/carry_0_probe VDD_1V65_2 0.03841f
C946 5v0_addh_sc_tile_0/pti in_1 0.66374f
C947 in_1 in_2 0
C948 5v0_addh_sc_tile_1/ctrl_sign 5v0_addh_sc_tile_1/inv_nti 0.2505f
C949 5v0_add_q_sc_1/5v0_half_adder_selector_sc_0/res_stage0 5v0_add_q_sc_1/ctrl_over 0.11645f
C950 5v0_addh_sc_tile_0/a_382_n1095# 5v0_add_q_sc_1/pti 0
C951 5v0_addh_sc_tile_2/inv_pti 5v0_nter2oter_code_sc_0/in 0.00498f
C952 5v0_addh_sc_tile_1/a_382_n1095# 5v0_add_q_sc_1/VDD_1V65 0
C953 5v0_add_q_sc_1/5v0_half_adder_selector_sc_0/res_stage0 5v0_add_q_sc_1/5v0_half_adder_selector_sc_0/5v0_tgate_sel_2_sc_1/input_A 0.00253f
C954 5v0_add_q_sc_0/ternary_input 5v0_add_q_sc_0/upstepper_test 0.02595f
C955 5v0_addh_sc_tile_1/ctrl_over 5v0_add_q_sc_0/pti 0.00209f
C956 5v0_addh_sc_tile_2/ctrl_over in_3 0.15512f
C957 5v0_addh_sc_tile_1/ternary_input 5v0_addh_sc_tile_2/5v0_half_adder_selector_sc_0/res_stage0 0
C958 5v0_add_q_sc_1/nti 5v0_add_q_sc_0/ternary_input 0
C959 5v0_nter2oter_code_sc_0/in 5v0_addh_sc_tile_2/m1_103_293# 0.00332f
C960 5v0_addh_sc_tile_1/inv_pti 5v0_add_q_sc_1/ctrl_sign 0.12531f
C961 5v0_add_q_sc_0/not_internal_0/a_56_472# VDD_3V3_0 0.00965f
C962 5v0_addh_sc_tile_0/inv_pti 5v0_add_q_sc_1/ctrl_sign 0
C963 5v0_addh_sc_tile_0/a_382_n1095# 5v0_addh_sc_tile_0/nti 0
C964 5v0_add_q_sc_0/ternary_input 5v0_add_q_sc_1/downstepper_test 0.00477f
C965 5v0_add_q_sc_1/ctrl_sign in_0_sign 0
C966 VDD_1V65_3 5v0_addh_sc_tile_1/a_n1373_n454# 0.00232f
C967 5v0_addh_sc_tile_1/ternary_input 5v0_addh_sc_tile_1/a_382_n1095# 0.09307f
C968 5v0_addh_sc_tile_2/inv_nti 5v0_nter2oter_code_sc_0/in 0
C969 5v0_add_q_sc_1/nti VDD_1V65_2 0.02331f
C970 5v0_addh_sc_tile_1/upstepper_test 5v0_addh_sc_tile_1/nti 0.11981f
C971 5v0_nter2oter_code_sc_0/in 5v0_addh_sc_tile_1/inv_pti 0.00119f
C972 5v0_addh_sc_tile_1/inv_nti 5v0_addh_sc_tile_2/ctrl_sign 0.00386f
C973 5v0_addh_sc_tile_1/ternary_input 5v0_addh_sc_tile_1/pti 0.67369f
C974 5v0_addh_sc_tile_0/pti 5v0_addh_sc_tile_1/pti 0
C975 5v0_addh_sc_tile_0/carry_sign_probe 5v0_addh_sc_tile_0/m1_103_293# 0.21008f
C976 in_3 5v0_addh_sc_tile_2/downstepper_test 0.18203f
C977 VDD_1V65_5 5v0_add_q_sc_0/upstepper_test 0.16859f
C978 5v0_addh_sc_tile_2/pti in_2 0
C979 5v0_addh_sc_tile_1/ctrl_over VDD_1V65_3 0.02438f
C980 5v0_add_q_sc_1/5v0_half_adder_selector_sc_0/res_stage0 5v0_add_q_sc_1/nti 0.00372f
C981 5v0_add_q_sc_0/nti 5v0_add_q_sc_0/5v0_half_adder_selector_sc_0/res_stage0 0.00372f
C982 5v0_add_q_sc_0/pti 5v0_add_q_sc_0/ctrl_sign 0
C983 5v0_addh_sc_tile_1/ctrl_sign 5v0_add_q_sc_1/ternary_input 0
C984 5v0_addh_sc_tile_0/inv_nti in_1 0.28245f
C985 5v0_addh_sc_tile_1/ternary_input 5v0_addh_sc_tile_1/m1_103_293# 0
C986 VDD_3V3_1 in_1 0.99979f
C987 5v0_nter2oter_code_sc_1/not_internal_0/a_36_68# 5v0_addh_sc_tile_2/ctrl_sign 0.00601f
C988 5v0_add_q_sc_1/5v0_half_adder_selector_sc_0/res_stage0 5v0_add_q_sc_1/downstepper_test 0.25483f
C989 5v0_nter2oter_code_sc_0/in 5v0_nter2oter_code_sc_1/not_internal_0/a_56_472# 0.00191f
C990 5v0_addh_sc_tile_1/ctrl_over 5v0_nter2oter_code_sc_1/nti 0.08839f
C991 5v0_addh_sc_tile_1/a_382_n1095# 5v0_add_q_sc_1/inv_pti 0
C992 5v0_addh_sc_tile_1/ternary_input 5v0_addh_sc_tile_0/a_382_n1095# 0.17536f
C993 5v0_addh_sc_tile_2/inv_nti 5v0_add_q_sc_0/ternary_input 0
C994 5v0_addh_sc_tile_0/pti 5v0_addh_sc_tile_0/a_382_n1095# 0.12627f
C995 5v0_addh_sc_tile_0/carry_0_probe in_1 0.00136f
C996 5v0_addh_sc_tile_1/inv_pti 5v0_add_q_sc_0/ternary_input 0.00157f
C997 5v0_add_q_sc_0/nti 5v0_add_q_sc_0/downstepper_test 0.07205f
C998 5v0_add_q_sc_0/ctrl_over 5v0_add_q_sc_0/5v0_half_adder_selector_sc_0/m1_n239_179# 0.00258f
C999 VDD_3V3_1 5v0_addh_sc_tile_1/a_382_n1095# 0.02507f
C1000 5v0_addh_sc_tile_1/m1_843_n857# VDD_3V3_0 0.20528f
C1001 5v0_add_q_sc_1/inv_nti 5v0_add_q_sc_1/a_n1205_n937# 0
C1002 5v0_addh_sc_tile_0/nti 5v0_addh_sc_tile_0/not_internal_0/a_56_472# 0.0036f
C1003 5v0_addh_sc_tile_1/ternary_input 5v0_addh_sc_tile_1/5v0_half_adder_selector_sc_0/res_stage0 0.26626f
C1004 5v0_addh_sc_tile_1/a_382_n1095# 5v0_add_q_sc_1/ctrl_over 0.08702f
C1005 5v0_addh_sc_tile_0/inv_nti 5v0_addh_sc_tile_1/pti 0
C1006 5v0_add_q_sc_0/nti 5v0_add_q_sc_0/5v0_half_adder_selector_sc_0/m1_n244_n517# 0
C1007 5v0_addh_sc_tile_1/ternary_input 5v0_addh_sc_tile_2/ctrl_over 0.00181f
C1008 5v0_addh_sc_tile_1/inv_nti 5v0_addh_sc_tile_1/downstepper_test 0.29493f
C1009 5v0_addh_sc_tile_1/ctrl_over 5v0_add_q_sc_0/ctrl_over 0
C1010 5v0_addh_sc_tile_1/not_internal_0/a_36_68# 5v0_addh_sc_tile_1/pti 0.01664f
C1011 VDD_3V3_1 5v0_addh_sc_tile_1/pti 0.51703f
C1012 5v0_addh_sc_tile_0/5v0_half_adder_selector_sc_0/res_stage0 in_1 0.2646f
C1013 5v0_nter2oter_code_sc_0/in 5v0_nter2oter_code_sc_1/pti 0.00503f
C1014 5v0_addh_sc_tile_2/ctrl_over in_2 0
C1015 5v0_addh_sc_tile_0/upstepper_test 5v0_addh_sc_tile_0/5v0_half_adder_selector_sc_0/5v0_tgate_sel_2_sc_1/input_A 0
C1016 5v0_addh_sc_tile_0/carry_0_probe 5v0_addh_sc_tile_1/a_382_n1095# 0
C1017 5v0_add_q_sc_1/ctrl_over 5v0_addh_sc_tile_1/pti 0.16959f
C1018 5v0_nter2oter_code_sc_0/in 5v0_addh_sc_tile_2/a_382_n1095# 0
C1019 5v0_addh_sc_tile_2/nti 5v0_add_q_sc_0/ctrl_over 0
C1020 5v0_addh_sc_tile_1/inv_nti VDD_3V3_0 0.66969f
C1021 5v0_add_q_sc_0/downstepper_test 5v0_add_q_sc_0/5v0_half_adder_selector_sc_0/res_stage0 0.25483f
C1022 5v0_addh_sc_tile_0/carry_0_probe 5v0_addh_sc_tile_1/pti 0.0051f
C1023 VDD_3V3_1 5v0_addh_sc_tile_1/m1_103_293# 0.62378f
C1024 5v0_addh_sc_tile_0/a_n1778_n454# in_1 0.00182f
C1025 5v0_addh_sc_tile_1/ctrl_sign 5v0_nter2oter_code_sc_1/nti 0.34424f
C1026 5v0_add_q_sc_1/inv_nti 5v0_add_q_sc_1/a_n1778_n454# 0.00214f
C1027 5v0_add_q_sc_1/ctrl_over 5v0_addh_sc_tile_1/m1_103_293# 0.01922f
C1028 5v0_addh_sc_tile_0/a_382_n1095# 5v0_addh_sc_tile_0/inv_nti 0.28672f
C1029 5v0_add_q_sc_0/nti 5v0_add_q_sc_0/a_n1373_n454# 0
C1030 5v0_addh_sc_tile_0/downstepper_test in_1 0.18203f
C1031 5v0_add_q_sc_0/5v0_half_adder_selector_sc_0/res_stage0 5v0_add_q_sc_0/5v0_half_adder_selector_sc_0/m1_n244_n517# 0.08646f
C1032 VDD_3V3_1 5v0_addh_sc_tile_0/a_382_n1095# 0.63349f
C1033 5v0_addh_sc_tile_1/ctrl_over 5v0_add_q_sc_0/5v0_half_adder_selector_sc_0/m1_n239_179# 0.00107f
C1034 5v0_addh_sc_tile_1/ctrl_sign 5v0_addh_sc_tile_0/m1_103_293# 0.00101f
C1035 VDD_1V65_4 5v0_addh_sc_tile_2/pti 0.00234f
C1036 5v0_add_q_sc_0/a_n1205_n937# VDD_3V3_0 0.00891f
C1037 VDD_1V65_3 5v0_addh_sc_tile_2/ctrl_sign 0
C1038 5v0_addh_sc_tile_1/a_382_n1095# 5v0_add_q_sc_0/upstepper_test 0.0104f
C1039 5v0_addh_sc_tile_0/carry_0_probe 5v0_addh_sc_tile_1/m1_103_293# 0.002f
C1040 5v0_add_q_sc_1/nti 5v0_addh_sc_tile_1/a_382_n1095# 0
C1041 5v0_addh_sc_tile_1/a_382_n1095# 5v0_addh_sc_tile_1/5v0_half_adder_selector_sc_0/5v0_tgate_sel_2_sc_1/input_A 0.02928f
C1042 in_0_over in_1 0.13684f
C1043 5v0_nter2oter_code_sc_1/not_internal_0/a_36_68# VDD_3V3_0 0.0013f
C1044 5v0_add_q_sc_0/ctrl_sign 5v0_add_q_sc_0/ctrl_over 0.02568f
C1045 5v0_addh_sc_tile_0/pti 5v0_addh_sc_tile_0/not_internal_0/a_56_472# 0.01506f
C1046 5v0_addh_sc_tile_1/pti 5v0_add_q_sc_0/upstepper_test 0.0029f
C1047 5v0_addh_sc_tile_0/m1_843_n857# 5v0_addh_sc_tile_0/m1_103_293# 0.20659f
C1048 5v0_addh_sc_tile_2/not_internal_0/a_36_68# 5v0_addh_sc_tile_2/pti 0.01664f
C1049 5v0_nter2oter_code_sc_1/nti 5v0_addh_sc_tile_2/ctrl_sign 0.01595f
C1050 5v0_addh_sc_tile_1/a_382_n1095# 5v0_add_q_sc_1/downstepper_test 0.00433f
C1051 5v0_add_q_sc_1/nti 5v0_addh_sc_tile_1/pti 0
C1052 VDD_3V3_1 5v0_addh_sc_tile_1/5v0_half_adder_selector_sc_0/res_stage0 0.01812f
C1053 VDD_1V65_0 in_1 0.01451f
C1054 5v0_addh_sc_tile_0/carry_0_probe 5v0_addh_sc_tile_0/a_382_n1095# 0.08241f
C1055 5v0_add_q_sc_1/inv_nti 5v0_add_q_sc_1/a_n1373_n454# 0
C1056 5v0_add_q_sc_0/ternary_input 5v0_addh_sc_tile_2/a_382_n1095# 0.0013f
C1057 5v0_addh_sc_tile_1/a_n1778_n454# 5v0_addh_sc_tile_1/pti 0.00135f
C1058 5v0_addh_sc_tile_2/pti 5v0_add_q_sc_0/upstepper_test 0
C1059 5v0_add_q_sc_1/a_n1778_n454# 5v0_add_q_sc_1/pti 0.00135f
C1060 5v0_addh_sc_tile_2/ctrl_over VDD_3V3_1 0.00156f
C1061 5v0_addh_sc_tile_1/5v0_half_adder_selector_sc_0/res_stage0 5v0_add_q_sc_1/ctrl_over 0
C1062 5v0_addh_sc_tile_1/upstepper_test 5v0_addh_sc_tile_1/inv_nti 0.00736f
C1063 5v0_addh_sc_tile_1/ctrl_over 5v0_addh_sc_tile_2/nti 0
C1064 5v0_addh_sc_tile_1/pti 5v0_add_q_sc_1/downstepper_test 0.00147f
C1065 5v0_add_q_sc_0/downstepper_test 5v0_add_q_sc_0/5v0_half_adder_selector_sc_0/m1_n244_n517# 0.00507f
C1066 5v0_addh_sc_tile_1/ternary_input 5v0_addh_sc_tile_1/nti 0.54752f
C1067 5v0_add_q_sc_0/upstepper_test 5v0_addh_sc_tile_1/m1_103_293# 0.00268f
C1068 5v0_addh_sc_tile_2/inv_pti 5v0_addh_sc_tile_2/5v0_half_adder_selector_sc_0/res_stage0 0.01003f
C1069 5v0_addh_sc_tile_1/nti 5v0_addh_sc_tile_0/pti 0
C1070 5v0_addh_sc_tile_1/nti in_2 0.0059f
C1071 5v0_add_q_sc_1/nti 5v0_addh_sc_tile_1/m1_103_293# 0.00685f
C1072 5v0_addh_sc_tile_0/carry_0_probe 5v0_addh_sc_tile_1/5v0_half_adder_selector_sc_0/res_stage0 0.00121f
C1073 5v0_addh_sc_tile_0/5v0_half_adder_selector_sc_0/res_stage0 5v0_addh_sc_tile_0/a_382_n1095# 0.08951f
C1074 res_0 VDD_1V65_4 0
C1075 5v0_addh_sc_tile_2/5v0_half_adder_selector_sc_0/res_stage0 5v0_addh_sc_tile_2/m1_103_293# 0.18487f
C1076 5v0_addh_sc_tile_2/ctrl_over 5v0_nter2oter_code_sc_0/nti 0.22878f
C1077 5v0_add_q_sc_1/a_n1205_n937# 5v0_add_q_sc_1/VDD_1V65 0.00354f
C1078 5v0_add_q_sc_0/ctrl_sign 5v0_add_q_sc_0/5v0_half_adder_selector_sc_0/m1_n239_179# 0.307f
C1079 5v0_add_q_sc_0/pti VDD_3V3_0 0.52584f
C1080 5v0_addh_sc_tile_0/carry_sign_probe 5v0_addh_sc_tile_0/m1_843_n857# 0.00703f
C1081 in_0_over 5v0_addh_sc_tile_1/pti 0.00417f
C1082 5v0_add_q_sc_1/nti 5v0_addh_sc_tile_0/a_382_n1095# 0
C1083 5v0_addh_sc_tile_2/ctrl_sign 5v0_add_q_sc_0/ctrl_over 0.00758f
C1084 5v0_addh_sc_tile_0/inv_pti in_1 0.05631f
C1085 5v0_addh_sc_tile_1/ctrl_sign 5v0_add_q_sc_0/5v0_half_adder_selector_sc_0/m1_n239_179# 0
C1086 5v0_addh_sc_tile_2/ctrl_over VDD_1V65_4 0.00145f
C1087 5v0_addh_sc_tile_2/inv_nti 5v0_addh_sc_tile_2/5v0_half_adder_selector_sc_0/res_stage0 0.02878f
C1088 5v0_add_q_sc_1/a_n1373_n454# 5v0_add_q_sc_1/pti 0
C1089 5v0_addh_sc_tile_1/ctrl_over 5v0_add_q_sc_0/ctrl_sign 0.00366f
C1090 5v0_addh_sc_tile_1/inv_nti 5v0_add_q_sc_1/inv_nti 0
C1091 5v0_addh_sc_tile_1/not_internal_0/a_56_472# 5v0_addh_sc_tile_1/pti 0.01309f
C1092 in_1 in_0_sign 0
C1093 5v0_add_q_sc_0/inv_pti 5v0_add_q_sc_1/ctrl_over 0.00278f
C1094 5v0_addh_sc_tile_2/inv_pti 5v0_addh_sc_tile_1/pti 0
C1095 5v0_addh_sc_tile_2/5v0_half_adder_selector_sc_0/res_stage0 5v0_addh_sc_tile_2/5v0_half_adder_selector_sc_0/5v0_tgate_sel_2_sc_1/input_A 0.00253f
C1096 VDD_1V65_3 5v0_addh_sc_tile_1/downstepper_test 0.13024f
C1097 5v0_add_q_sc_0/downstepper_test 5v0_add_q_sc_0/a_n1373_n454# 0.00442f
C1098 5v0_nter2oter_code_sc_1/nti 5v0_addh_sc_tile_2/upstepper_test 0
C1099 5v0_addh_sc_tile_1/ctrl_over 5v0_addh_sc_tile_1/ctrl_sign 0.48053f
C1100 5v0_addh_sc_tile_2/inv_pti 5v0_addh_sc_tile_2/pti 0.46086f
C1101 5v0_addh_sc_tile_1/pti 5v0_addh_sc_tile_2/m1_103_293# 0
C1102 VDD_3V3_1 5v0_addh_sc_tile_0/not_internal_0/a_56_472# 0.00965f
C1103 5v0_addh_sc_tile_1/5v0_half_adder_selector_sc_0/res_stage0 5v0_addh_sc_tile_1/5v0_half_adder_selector_sc_0/5v0_tgate_sel_2_sc_1/input_A 0.00253f
C1104 5v0_addh_sc_tile_0/downstepper_test 5v0_addh_sc_tile_0/a_382_n1095# 0.00679f
C1105 5v0_add_q_sc_0/nti 5v0_add_q_sc_0/inv_nti 0.20874f
C1106 5v0_addh_sc_tile_1/inv_pti 5v0_addh_sc_tile_1/a_382_n1095# 0.00129f
C1107 5v0_add_q_sc_1/a_n1778_n454# 5v0_add_q_sc_1/VDD_1V65 0
C1108 5v0_addh_sc_tile_2/ctrl_over 5v0_add_q_sc_0/upstepper_test 0.00252f
C1109 5v0_addh_sc_tile_2/pti 5v0_addh_sc_tile_2/m1_103_293# 0.10002f
C1110 5v0_nter2oter_code_sc_1/nti 5v0_addh_sc_tile_1/downstepper_test 0
C1111 in_0_over 5v0_addh_sc_tile_0/a_382_n1095# 0.63576f
C1112 5v0_addh_sc_tile_1/ctrl_sign 5v0_addh_sc_tile_2/nti 0
C1113 VDD_1V65_3 VDD_3V3_0 0.04264f
C1114 5v0_nter2oter_code_sc_0/in 5v0_nter2oter_code_sc_0/pti 0.57369f
C1115 5v0_addh_sc_tile_2/ctrl_over 5v0_nter2oter_code_sc_0/gf180mcu_fd_sc_mcu7t5v0__nor2_1_0/a_224_472# 0.03274f
C1116 5v0_addh_sc_tile_2/inv_nti 5v0_addh_sc_tile_2/pti 0.42149f
C1117 5v0_addh_sc_tile_1/inv_pti 5v0_addh_sc_tile_1/pti 0.3933f
C1118 5v0_addh_sc_tile_1/nti 5v0_addh_sc_tile_0/inv_nti 0
C1119 5v0_addh_sc_tile_1/inv_nti 5v0_add_q_sc_1/pti 0
C1120 5v0_addh_sc_tile_2/downstepper_test VDD_1V65_4 0.13024f
C1121 5v0_addh_sc_tile_1/inv_pti 5v0_addh_sc_tile_2/pti 0
C1122 5v0_addh_sc_tile_1/nti 5v0_addh_sc_tile_1/not_internal_0/a_36_68# 0.00259f
C1123 5v0_addh_sc_tile_1/nti VDD_3V3_1 0.1351f
C1124 5v0_nter2oter_code_sc_1/not_internal_0/a_36_68# in_3 0
C1125 5v0_addh_sc_tile_2/a_n1205_n937# 5v0_addh_sc_tile_2/5v0_half_adder_selector_sc_0/res_stage0 0
C1126 in_0_over 5v0_addh_sc_tile_1/5v0_half_adder_selector_sc_0/res_stage0 0
C1127 m1_n2844_n810# 5v0_add_q_sc_1/ctrl_sign 0.00441f
C1128 5v0_addh_sc_tile_1/pti in_0_sign 0
C1129 5v0_addh_sc_tile_1/nti 5v0_add_q_sc_1/ctrl_over 0
C1130 5v0_nter2oter_code_sc_1/nti VDD_3V3_0 0.31499f
C1131 5v0_addh_sc_tile_1/ctrl_over 5v0_addh_sc_tile_2/ctrl_sign 0.06869f
C1132 5v0_addh_sc_tile_0/upstepper_test 5v0_nter2oter_code_sc_1/nti 0
C1133 5v0_add_q_sc_0/inv_pti 5v0_add_q_sc_0/upstepper_test 0.0467f
C1134 5v0_add_q_sc_1/not_internal_0/a_36_68# 5v0_add_q_sc_1/ctrl_sign 0
C1135 5v0_addh_sc_tile_1/inv_pti 5v0_addh_sc_tile_1/m1_103_293# 0.17653f
C1136 5v0_add_q_sc_1/a_n1373_n454# 5v0_add_q_sc_1/VDD_1V65 0.00232f
C1137 5v0_addh_sc_tile_1/ctrl_sign 5v0_add_q_sc_0/ctrl_sign 0
C1138 5v0_add_q_sc_1/ternary_input 5v0_add_q_sc_1/inv_nti 0.02537f
C1139 5v0_addh_sc_tile_2/not_internal_0/a_36_68# 5v0_addh_sc_tile_2/downstepper_test 0.00136f
C1140 5v0_addh_sc_tile_0/carry_0_probe 5v0_addh_sc_tile_1/nti 0.013f
C1141 5v0_addh_sc_tile_2/inv_pti 5v0_addh_sc_tile_2/not_internal_0/a_56_472# 0.01162f
C1142 5v0_addh_sc_tile_2/ctrl_sign 5v0_addh_sc_tile_2/nti 0.01897f
C1143 5v0_addh_sc_tile_0/upstepper_test 5v0_addh_sc_tile_0/m1_103_293# 0.07773f
C1144 VDD_3V3_1 5v0_add_q_sc_1/a_n1205_n937# 0.00891f
C1145 5v0_addh_sc_tile_1/inv_pti 5v0_addh_sc_tile_0/a_382_n1095# 0
C1146 5v0_addh_sc_tile_2/inv_pti 5v0_addh_sc_tile_2/ctrl_over 0.0554f
C1147 5v0_addh_sc_tile_2/m1_843_n857# 5v0_add_q_sc_0/ctrl_over 0.17868f
C1148 5v0_addh_sc_tile_1/upstepper_test VDD_1V65_3 0.16859f
C1149 5v0_addh_sc_tile_0/inv_pti 5v0_addh_sc_tile_0/a_382_n1095# 0.00129f
C1150 5v0_add_q_sc_1/a_n1205_n937# 5v0_add_q_sc_1/ctrl_over 0
C1151 5v0_add_q_sc_1/ctrl_over 5v0_add_q_sc_0/not_internal_0/a_56_472# 0.00236f
C1152 5v0_addh_sc_tile_2/pti 5v0_nter2oter_code_sc_1/not_internal_0/a_56_472# 0
C1153 5v0_addh_sc_tile_2/inv_nti res_0 0.01449f
C1154 5v0_addh_sc_tile_2/ctrl_over 5v0_addh_sc_tile_2/m1_103_293# 0.05856f
C1155 5v0_addh_sc_tile_1/ternary_input 5v0_addh_sc_tile_1/m1_843_n857# 0
C1156 5v0_addh_sc_tile_0/a_382_n1095# in_0_sign 0.07412f
C1157 5v0_add_q_sc_0/ctrl_over VDD_3V3_0 0.96278f
C1158 5v0_addh_sc_tile_1/ctrl_sign 5v0_addh_sc_tile_0/m1_843_n857# 0
C1159 5v0_add_q_sc_0/nti 5v0_add_q_sc_0/ternary_input 0.62238f
C1160 5v0_addh_sc_tile_2/5v0_half_adder_selector_sc_0/res_stage0 5v0_addh_sc_tile_2/a_382_n1095# 0.08951f
C1161 5v0_addh_sc_tile_1/a_n1373_n454# 5v0_addh_sc_tile_1/downstepper_test 0.00442f
C1162 5v0_addh_sc_tile_0/a_n1205_n937# 5v0_addh_sc_tile_1/ctrl_over 0
C1163 5v0_addh_sc_tile_2/inv_nti 5v0_addh_sc_tile_2/ctrl_over 0.26006f
C1164 5v0_addh_sc_tile_1/inv_pti 5v0_addh_sc_tile_1/5v0_half_adder_selector_sc_0/res_stage0 0.01365f
C1165 5v0_add_q_sc_0/inv_nti 5v0_add_q_sc_0/downstepper_test 0.1819f
C1166 5v0_add_q_sc_0/ctrl_sign 5v0_addh_sc_tile_2/ctrl_sign 0.27145f
C1167 5v0_addh_sc_tile_0/downstepper_test 5v0_addh_sc_tile_0/not_internal_0/a_56_472# 0
C1168 5v0_add_q_sc_1/ternary_input 5v0_add_q_sc_1/pti 0.54174f
C1169 5v0_addh_sc_tile_2/ctrl_over 5v0_addh_sc_tile_1/inv_pti 0
C1170 5v0_addh_sc_tile_1/ctrl_over 5v0_addh_sc_tile_2/upstepper_test 0
C1171 5v0_addh_sc_tile_0/upstepper_test 5v0_addh_sc_tile_0/carry_sign_probe 0
C1172 5v0_addh_sc_tile_2/ctrl_over 5v0_addh_sc_tile_2/5v0_half_adder_selector_sc_0/5v0_tgate_sel_2_sc_1/input_A 0.04656f
C1173 5v0_addh_sc_tile_1/nti 5v0_addh_sc_tile_1/a_n1778_n454# 0.00142f
C1174 VDD_3V3_1 5v0_add_q_sc_1/5v0_half_adder_selector_sc_0/m1_n244_n517# 0.28925f
C1175 5v0_addh_sc_tile_1/ctrl_sign 5v0_addh_sc_tile_2/ctrl_sign 0.0136f
C1176 5v0_nter2oter_code_sc_0/in 5v0_nter2oter_code_sc_1/gf180mcu_fd_sc_mcu7t5v0__nor2_1_0/a_224_472# 0
C1177 5v0_addh_sc_tile_1/a_n1373_n454# VDD_3V3_0 0.00122f
C1178 5v0_add_q_sc_1/ctrl_over 5v0_add_q_sc_1/5v0_half_adder_selector_sc_0/m1_n244_n517# 0.34508f
C1179 5v0_addh_sc_tile_2/inv_pti 5v0_addh_sc_tile_2/downstepper_test 0.13388f
C1180 5v0_addh_sc_tile_2/pti 5v0_nter2oter_code_sc_1/pti 0.00134f
C1181 5v0_addh_sc_tile_2/a_n1373_n454# 5v0_addh_sc_tile_2/pti 0
C1182 5v0_addh_sc_tile_2/upstepper_test 5v0_addh_sc_tile_2/nti 0.11981f
C1183 5v0_addh_sc_tile_1/ternary_input 5v0_addh_sc_tile_1/inv_nti 0.28104f
C1184 5v0_addh_sc_tile_1/ctrl_over 5v0_addh_sc_tile_1/downstepper_test 0.16009f
C1185 5v0_add_q_sc_1/5v0_half_adder_selector_sc_0/5v0_tgate_sel_2_sc_1/input_A 5v0_add_q_sc_1/5v0_half_adder_selector_sc_0/m1_n244_n517# 0.02928f
C1186 5v0_addh_sc_tile_1/inv_nti 5v0_addh_sc_tile_0/pti 0
C1187 5v0_addh_sc_tile_2/downstepper_test 5v0_addh_sc_tile_2/m1_103_293# 0.0934f
C1188 5v0_add_q_sc_0/nti res_c 0
C1189 5v0_addh_sc_tile_2/pti 5v0_addh_sc_tile_2/a_382_n1095# 0.12254f
C1190 5v0_add_q_sc_1/a_n1373_n454# 5v0_add_q_sc_1/inv_pti 0.00135f
C1191 5v0_add_q_sc_0/5v0_half_adder_selector_sc_0/res_stage0 5v0_add_q_sc_0/ternary_input 0.27792f
C1192 5v0_add_q_sc_0/5v0_half_adder_selector_sc_0/m1_n239_179# VDD_3V3_0 0.30519f
C1193 5v0_add_q_sc_1/nti 5v0_add_q_sc_1/a_n1205_n937# 0
C1194 5v0_add_q_sc_0/nti VDD_1V65_5 0.21326f
C1195 5v0_add_q_sc_0/not_internal_0/a_56_472# 5v0_add_q_sc_0/upstepper_test 0
C1196 5v0_addh_sc_tile_1/nti in_0_over 0.00205f
C1197 5v0_addh_sc_tile_1/m1_843_n857# 5v0_add_q_sc_1/inv_pti 0
C1198 5v0_addh_sc_tile_2/inv_nti 5v0_addh_sc_tile_2/downstepper_test 0.29987f
C1199 5v0_addh_sc_tile_2/a_n1205_n937# 5v0_addh_sc_tile_2/ctrl_over 0
C1200 5v0_addh_sc_tile_1/ctrl_over VDD_3V3_0 1.3463f
C1201 5v0_addh_sc_tile_1/upstepper_test 5v0_addh_sc_tile_0/carry_sign_probe 0
C1202 VDD_3V3_1 5v0_add_q_sc_1/a_n1373_n454# 0.00122f
C1203 5v0_add_q_sc_1/a_n1205_n937# 5v0_add_q_sc_1/downstepper_test 0.00453f
C1204 5v0_addh_sc_tile_1/ctrl_over 5v0_addh_sc_tile_0/upstepper_test 0
C1205 m1_n2844_n810# VDD_1V65_2 0.00448f
C1206 5v0_addh_sc_tile_2/downstepper_test 5v0_addh_sc_tile_2/5v0_half_adder_selector_sc_0/5v0_tgate_sel_2_sc_1/input_A 0
C1207 5v0_addh_sc_tile_1/not_internal_0/a_56_472# 5v0_addh_sc_tile_1/nti 0.0036f
C1208 5v0_add_q_sc_0/inv_nti 5v0_add_q_sc_0/a_n1373_n454# 0
C1209 in_3 5v0_nter2oter_code_sc_1/nti 0
C1210 5v0_addh_sc_tile_2/inv_pti 5v0_addh_sc_tile_1/nti 0
C1211 VDD_3V3_1 5v0_addh_sc_tile_1/m1_843_n857# 0.00388f
C1212 5v0_addh_sc_tile_0/inv_pti 5v0_addh_sc_tile_0/not_internal_0/a_56_472# 0.01162f
C1213 5v0_add_q_sc_1/ternary_input 5v0_add_q_sc_1/VDD_1V65 0.03394f
C1214 5v0_addh_sc_tile_1/nti 5v0_addh_sc_tile_2/m1_103_293# 0.00116f
C1215 5v0_addh_sc_tile_2/a_n1778_n454# 5v0_addh_sc_tile_2/pti 0.00135f
C1216 5v0_addh_sc_tile_2/nti VDD_3V3_0 0.74705f
C1217 5v0_addh_sc_tile_0/a_n1373_n454# in_1 0.00163f
C1218 5v0_addh_sc_tile_1/upstepper_test 5v0_addh_sc_tile_1/a_n1373_n454# 0
C1219 5v0_add_q_sc_1/ctrl_over 5v0_addh_sc_tile_1/m1_843_n857# 0.18406f
C1220 5v0_add_q_sc_0/downstepper_test 5v0_add_q_sc_0/ternary_input 0.17146f
C1221 5v0_add_q_sc_0/5v0_half_adder_selector_sc_0/res_stage0 res_c 0.08533f
C1222 5v0_add_q_sc_0/ctrl_sign 5v0_addh_sc_tile_1/downstepper_test 0.00426f
C1223 VDD_3V3_1 5v0_addh_sc_tile_0/5v0_half_adder_selector_sc_0/5v0_tgate_sel_2_sc_1/input_A 0.02871f
C1224 5v0_add_q_sc_1/nti 5v0_add_q_sc_1/5v0_half_adder_selector_sc_0/m1_n244_n517# 0
C1225 5v0_add_q_sc_1/nti 5v0_add_q_sc_1/a_n1778_n454# 0
C1226 res_0 5v0_addh_sc_tile_2/a_382_n1095# 0.16245f
C1227 5v0_addh_sc_tile_2/inv_nti 5v0_addh_sc_tile_1/nti 0
C1228 5v0_add_q_sc_1/not_internal_0/a_56_472# 5v0_add_q_sc_1/ctrl_sign 0.00555f
C1229 5v0_addh_sc_tile_2/ctrl_over 5v0_nter2oter_code_sc_1/pti 0
C1230 5v0_addh_sc_tile_0/pti 5v0_add_q_sc_1/ternary_input 0.00103f
C1231 5v0_add_q_sc_0/ctrl_sign 5v0_addh_sc_tile_2/m1_843_n857# 0.00871f
C1232 5v0_addh_sc_tile_1/ctrl_sign 5v0_addh_sc_tile_1/downstepper_test 0.20124f
C1233 5v0_add_q_sc_0/ternary_input 5v0_add_q_sc_0/5v0_half_adder_selector_sc_0/m1_n244_n517# 0.07888f
C1234 5v0_addh_sc_tile_1/5v0_half_adder_selector_sc_0/res_stage0 5v0_addh_sc_tile_2/a_382_n1095# 0
C1235 5v0_addh_sc_tile_1/nti 5v0_addh_sc_tile_1/inv_pti 0.23171f
C1236 5v0_add_q_sc_1/5v0_half_adder_selector_sc_0/m1_n244_n517# 5v0_add_q_sc_1/downstepper_test 0.00507f
C1237 5v0_add_q_sc_1/a_n1778_n454# 5v0_add_q_sc_1/downstepper_test 0.0031f
C1238 5v0_addh_sc_tile_2/a_n1205_n937# 5v0_addh_sc_tile_2/downstepper_test 0.00453f
C1239 in_3 5v0_add_q_sc_0/ctrl_over 0.00136f
C1240 5v0_addh_sc_tile_2/ctrl_over 5v0_addh_sc_tile_2/a_382_n1095# 0.69037f
C1241 5v0_addh_sc_tile_1/upstepper_test 5v0_addh_sc_tile_1/ctrl_over 0.0043f
C1242 5v0_addh_sc_tile_1/inv_nti VDD_3V3_1 0.11473f
C1243 5v0_addh_sc_tile_0/carry_0_probe 5v0_addh_sc_tile_0/5v0_half_adder_selector_sc_0/5v0_tgate_sel_2_sc_1/input_A 0
C1244 5v0_add_q_sc_0/ctrl_sign VDD_3V3_0 0.8077f
C1245 5v0_addh_sc_tile_1/nti in_0_sign 0
C1246 5v0_nter2oter_code_sc_1/nti 5v0_addh_sc_tile_0/nti 0
C1247 5v0_addh_sc_tile_0/m1_843_n857# 5v0_addh_sc_tile_1/downstepper_test 0
C1248 5v0_addh_sc_tile_1/inv_nti 5v0_add_q_sc_1/ctrl_over 0.03482f
C1249 5v0_addh_sc_tile_1/ctrl_sign VDD_3V3_0 0.23492f
C1250 5v0_nter2oter_code_sc_0/pti in_1 0
C1251 5v0_addh_sc_tile_2/ctrl_sign 5v0_addh_sc_tile_2/upstepper_test 0.15846f
C1252 5v0_add_q_sc_0/downstepper_test res_c 0.00302f
C1253 VDD_1V65_2 VSS_3 0.07318f
C1254 5v0_addh_sc_tile_2/pti VSS_3 1.12046f
C1255 VDD_1V65_4 VSS_3 0.09068f
C1256 5v0_addh_sc_tile_2/inv_nti VSS_3 1.37407f
C1257 5v0_addh_sc_tile_2/m1_843_n857# VSS_3 0.16265f ; **FLOATING
C1258 5v0_addh_sc_tile_2/ctrl_sign VSS_3 1.24533f
C1259 5v0_addh_sc_tile_2/a_n1205_n937# VSS_3 0 ; **FLOATING
C1260 5v0_addh_sc_tile_2/a_n1373_n454# VSS_3 0.00335f ; **FLOATING
C1261 5v0_addh_sc_tile_2/a_n1778_n454# VSS_3 0.00573f ; **FLOATING
C1262 5v0_addh_sc_tile_2/inv_pti VSS_3 0.90106f
C1263 5v0_addh_sc_tile_2/not_internal_0/a_36_68# VSS_3 0.00764f ; **FLOATING
C1264 5v0_addh_sc_tile_2/5v0_half_adder_selector_sc_0/5v0_tgate_sel_2_sc_1/input_A VSS_3 0
C1265 5v0_addh_sc_tile_2/a_382_n1095# VSS_3 0.83941f ; **FLOATING
C1266 in_3 VSS_3 1.64592f
C1267 res_0 VSS_3 0.02768f
C1268 5v0_addh_sc_tile_2/ctrl_over VSS_3 0.79847f
C1269 5v0_addh_sc_tile_2/m1_103_293# VSS_3 0.74864f ; **FLOATING
C1270 5v0_addh_sc_tile_2/5v0_half_adder_selector_sc_0/res_stage0 VSS_3 0.50069f
C1271 5v0_addh_sc_tile_2/downstepper_test VSS_3 0.58128f
C1272 5v0_addh_sc_tile_2/upstepper_test VSS_3 0.53687f
C1273 5v0_addh_sc_tile_2/nti VSS_3 1.25122f
C1274 5v0_addh_sc_tile_1/pti VSS_3 1.11901f
C1275 VDD_1V65_3 VSS_3 0.09068f
C1276 5v0_addh_sc_tile_1/inv_nti VSS_3 1.35525f
C1277 5v0_addh_sc_tile_1/m1_843_n857# VSS_3 0.15965f ; **FLOATING
C1278 5v0_addh_sc_tile_1/ctrl_sign VSS_3 1.01291f
C1279 5v0_addh_sc_tile_1/a_n1205_n937# VSS_3 0 ; **FLOATING
C1280 5v0_addh_sc_tile_1/a_n1373_n454# VSS_3 0.00335f ; **FLOATING
C1281 5v0_addh_sc_tile_1/a_n1778_n454# VSS_3 0.00573f ; **FLOATING
C1282 5v0_addh_sc_tile_1/inv_pti VSS_3 0.90273f
C1283 5v0_addh_sc_tile_1/not_internal_0/a_36_68# VSS_3 0.00764f ; **FLOATING
C1284 5v0_addh_sc_tile_1/5v0_half_adder_selector_sc_0/5v0_tgate_sel_2_sc_1/input_A VSS_3 0
C1285 5v0_addh_sc_tile_1/a_382_n1095# VSS_3 0.81445f ; **FLOATING
C1286 5v0_addh_sc_tile_1/ternary_input VSS_3 1.54515f
C1287 5v0_nter2oter_code_sc_0/in VSS_3 1.10918f
C1288 5v0_addh_sc_tile_1/ctrl_over VSS_3 1.07299f
C1289 5v0_addh_sc_tile_1/m1_103_293# VSS_3 0.74864f ; **FLOATING
C1290 5v0_addh_sc_tile_1/5v0_half_adder_selector_sc_0/res_stage0 VSS_3 0.50069f
C1291 5v0_addh_sc_tile_1/downstepper_test VSS_3 0.58128f
C1292 VDD_3V3_1 VSS_3 39.20797f
C1293 5v0_addh_sc_tile_1/upstepper_test VSS_3 0.53687f
C1294 5v0_addh_sc_tile_1/nti VSS_3 1.26507f
C1295 5v0_addh_sc_tile_0/pti VSS_3 1.124f
C1296 VDD_1V65_0 VSS_3 0.09068f
C1297 5v0_addh_sc_tile_0/inv_nti VSS_3 1.35924f
C1298 5v0_addh_sc_tile_0/m1_843_n857# VSS_3 0.15969f ; **FLOATING
C1299 in_0_sign VSS_3 0.8701f
C1300 5v0_addh_sc_tile_0/a_n1205_n937# VSS_3 0 ; **FLOATING
C1301 5v0_addh_sc_tile_0/a_n1373_n454# VSS_3 0.00335f ; **FLOATING
C1302 5v0_addh_sc_tile_0/a_n1778_n454# VSS_3 0.00573f ; **FLOATING
C1303 5v0_addh_sc_tile_0/inv_pti VSS_3 0.90056f
C1304 5v0_addh_sc_tile_0/carry_sign_probe VSS_3 0.24862f
C1305 5v0_addh_sc_tile_0/not_internal_0/a_36_68# VSS_3 0.00764f ; **FLOATING
C1306 5v0_addh_sc_tile_0/5v0_half_adder_selector_sc_0/5v0_tgate_sel_2_sc_1/input_A VSS_3 0
C1307 5v0_addh_sc_tile_0/a_382_n1095# VSS_3 0.81488f ; **FLOATING
C1308 in_1 VSS_3 1.69892f
C1309 in_0_over VSS_3 0.49348f
C1310 5v0_addh_sc_tile_0/m1_103_293# VSS_3 0.74828f ; **FLOATING
C1311 5v0_addh_sc_tile_0/5v0_half_adder_selector_sc_0/res_stage0 VSS_3 0.50069f
C1312 5v0_addh_sc_tile_0/downstepper_test VSS_3 0.58277f
C1313 5v0_addh_sc_tile_0/upstepper_test VSS_3 0.53687f
C1314 5v0_addh_sc_tile_0/nti VSS_3 1.25147f
C1315 in_2 VSS_3 0.95062f
C1316 5v0_nter2oter_code_sc_1/pti VSS_3 0.59555f
C1317 5v0_nter2oter_code_sc_1/nti VSS_3 0.65951f
C1318 5v0_nter2oter_code_sc_1/gf180mcu_fd_sc_mcu7t5v0__nor2_1_0/a_224_472# VSS_3 0 ; **FLOATING
C1319 5v0_nter2oter_code_sc_1/not_internal_0/a_36_68# VSS_3 0.00808f ; **FLOATING
C1320 5v0_nter2oter_code_sc_1/not_internal_0/a_56_472# VSS_3 0.00314f ; **FLOATING
C1321 5v0_nter2oter_code_sc_0/pti VSS_3 0.58081f
C1322 5v0_nter2oter_code_sc_0/nti VSS_3 0.67092f
C1323 5v0_nter2oter_code_sc_0/gf180mcu_fd_sc_mcu7t5v0__nor2_1_0/a_224_472# VSS_3 0 ; **FLOATING
C1324 5v0_add_q_sc_1/pti VSS_3 0.54814f
C1325 5v0_add_q_sc_1/VDD_1V65 VSS_3 0.25926f
C1326 5v0_add_q_sc_1/inv_nti VSS_3 0.53566f
C1327 5v0_add_q_sc_1/inv_pti VSS_3 0.62353f
C1328 5v0_add_q_sc_1/a_n1205_n937# VSS_3 0.0038f ; **FLOATING
C1329 5v0_add_q_sc_1/a_n1373_n454# VSS_3 0.00345f ; **FLOATING
C1330 5v0_add_q_sc_1/a_n1778_n454# VSS_3 0.00577f ; **FLOATING
C1331 5v0_add_q_sc_1/not_internal_0/a_36_68# VSS_3 0.00764f ; **FLOATING
C1332 5v0_add_q_sc_1/not_internal_0/a_56_472# VSS_3 0 ; **FLOATING
C1333 5v0_add_q_sc_1/5v0_half_adder_selector_sc_0/5v0_tgate_sel_2_sc_1/input_A VSS_3 0
C1334 5v0_add_q_sc_1/5v0_half_adder_selector_sc_0/m1_n244_n517# VSS_3 0.29628f ; **FLOATING
C1335 5v0_add_q_sc_1/ternary_input VSS_3 1.9466f
C1336 5v0_add_q_sc_1/ctrl_over VSS_3 0.98262f
C1337 5v0_add_q_sc_1/5v0_half_adder_selector_sc_0/m1_n239_179# VSS_3 0.37403f ; **FLOATING
C1338 5v0_add_q_sc_1/5v0_half_adder_selector_sc_0/res_stage0 VSS_3 0.78312f
C1339 5v0_add_q_sc_1/downstepper_test VSS_3 1.03042f
C1340 5v0_add_q_sc_1/ctrl_sign VSS_3 1.15556f
C1341 5v0_add_q_sc_1/nti VSS_3 1.38161f
C1342 5v0_add_q_sc_0/pti VSS_3 0.54828f
C1343 VDD_1V65_5 VSS_3 0.09068f
C1344 5v0_add_q_sc_0/inv_nti VSS_3 0.53457f
C1345 5v0_add_q_sc_0/inv_pti VSS_3 0.5765f
C1346 5v0_add_q_sc_0/a_n1205_n937# VSS_3 0 ; **FLOATING
C1347 5v0_add_q_sc_0/a_n1373_n454# VSS_3 0.00335f ; **FLOATING
C1348 5v0_add_q_sc_0/a_n1778_n454# VSS_3 0.00573f ; **FLOATING
C1349 5v0_add_q_sc_0/not_internal_0/a_36_68# VSS_3 0.00764f ; **FLOATING
C1350 5v0_add_q_sc_0/5v0_half_adder_selector_sc_0/5v0_tgate_sel_2_sc_1/input_A VSS_3 0
C1351 5v0_add_q_sc_0/5v0_half_adder_selector_sc_0/m1_n244_n517# VSS_3 0.29628f ; **FLOATING
C1352 5v0_add_q_sc_0/ternary_input VSS_3 2.49121f
C1353 res_c VSS_3 0.0293f
C1354 5v0_add_q_sc_0/ctrl_over VSS_3 0.76005f
C1355 5v0_add_q_sc_0/5v0_half_adder_selector_sc_0/m1_n239_179# VSS_3 0.29907f ; **FLOATING
C1356 5v0_add_q_sc_0/5v0_half_adder_selector_sc_0/res_stage0 VSS_3 0.50905f
C1357 5v0_add_q_sc_0/downstepper_test VSS_3 0.64086f
C1358 5v0_add_q_sc_0/ctrl_sign VSS_3 0.4943f
C1359 VDD_3V3_0 VSS_3 47.36225f
C1360 5v0_add_q_sc_0/upstepper_test VSS_3 0.54953f
C1361 5v0_add_q_sc_0/nti VSS_3 1.26578f
C1362 5v0_addh_sc_tile_0/carry_0_probe VSS_3 0.59349f
C1363 m1_n2844_n810# VSS_3 0.41232f ; **FLOATING
