* NGSPICE file created from 5v0_add3_sc.ext - technology: gf180mcuD

.option scale=5n

X0 int_c01 m1_n2844_n810# 5v0_addh_sc_tile_0/carry_sign_probe VSS_3 nfet_06v0 ad=14.432n pd=0.504m as=14.432n ps=0.504m w=164 l=120
X1 VDD_1V65_2 5v0_addh_sc_tile_0/carry_0_probe int_c01 VSS_3 nfet_06v0 ad=14.432n pd=0.504m as=14.432n ps=0.504m w=164 l=120
X2 5v0_add_q_sc_0/pti int_carry VSS_3 VSS_3 nfet_06v0 ad=6.336n pd=0.32m as=6.478n ps=0.255m w=72 l=578
X3 VDD_3V3_0 int_carry 5v0_add_q_sc_0/pti VDD_3V3_0 pfet_06v0 ad=12.81n pd=0.349m as=12.688n ps=0.348m w=244 l=100
X4 VDD_3V3_0 int_carry 5v0_add_q_sc_0/nti VDD_3V3_0 pfet_06v0 ad=13.616n pd=0.392m as=9.696n ps=0.394m w=96 l=150
X5 VSS_3 int_carry 5v0_add_q_sc_0/nti VSS_3 nfet_06v0 ad=6.478n pd=0.255m as=12.7n ps=0.454m w=127 l=120
X6 5v0_add_q_sc_0/pti int_carry VDD_3V3_0 VDD_3V3_0 pfet_06v0 ad=12.688n pd=0.348m as=13.616n ps=0.392m w=244 l=100
X7 5v0_add_q_sc_0/pti int_carry VDD_3V3_0 VDD_3V3_0 pfet_06v0 ad=27.328n pd=0.712m as=12.81n ps=0.349m w=244 l=100
X8 5v0_add_q_sc_0/5v0_half_adder_selector_sc_0/res_stage0 5v0_add_q_sc_0/5v0_half_adder_selector_sc_0/m1_n239_179# 5v0_add_q_sc_0/downstepper_test VSS_3 nfet_06v0 ad=14.432n pd=0.504m as=14.432n ps=0.504m w=164 l=120
X9 5v0_add_q_sc_0/5v0_half_adder_selector_sc_0/res_stage0 5v0_add_q_sc_0/5v0_half_adder_selector_sc_0/m1_n239_179# 5v0_add_q_sc_0/upstepper_test VDD_3V3_0 pfet_06v0 ad=21.472n pd=0.664m as=21.472n ps=0.664m w=244 l=100
X10 5v0_add_q_sc_0/5v0_half_adder_selector_sc_0/m1_n239_179# 5v0_add_q_sc_0/ctrl_sign VSS_3 VSS_3 nfet_06v0 ad=14.432n pd=0.504m as=14.432n ps=0.504m w=164 l=120
X11 5v0_add_q_sc_0/5v0_half_adder_selector_sc_0/m1_n239_179# 5v0_add_q_sc_0/ctrl_sign VDD_3V3_0 VDD_3V3_0 pfet_06v0 ad=21.472n pd=0.664m as=21.472n ps=0.664m w=244 l=100
X12 5v0_add_q_sc_0/5v0_half_adder_selector_sc_0/res_stage0 5v0_add_q_sc_0/ctrl_sign 5v0_add_q_sc_0/upstepper_test VSS_3 nfet_06v0 ad=31.489n pd=1.041m as=43.711n ps=1.504m w=164 l=120
X13 5v0_add_q_sc_0/5v0_half_adder_selector_sc_0/res_stage0 5v0_add_q_sc_0/ctrl_sign 5v0_add_q_sc_0/downstepper_test VDD_3V3_0 pfet_06v0 ad=46.849n pd=1.361m as=42.856n ps=1.326m w=244 l=100
X14 res_c 5v0_add_q_sc_0/5v0_half_adder_selector_sc_0/m1_n244_n517# 5v0_add_q_sc_0/5v0_half_adder_selector_sc_0/res_stage0 VSS_3 nfet_06v0 ad=17.057n pd=0.537m as=0 ps=0 w=164 l=120
X15 res_c 5v0_add_q_sc_0/5v0_half_adder_selector_sc_0/m1_n244_n517# int_carry VDD_3V3_0 pfet_06v0 ad=25.377n pd=0.697m as=46.849n ps=1.361m w=244 l=100
X16 5v0_add_q_sc_0/5v0_half_adder_selector_sc_0/m1_n244_n517# 5v0_add_q_sc_0/ctrl_over VSS_3 VSS_3 nfet_06v0 ad=14.432n pd=0.504m as=0.59241u ps=0.02092 w=164 l=120
X17 5v0_add_q_sc_0/5v0_half_adder_selector_sc_0/m1_n244_n517# 5v0_add_q_sc_0/ctrl_over VDD_3V3_0 VDD_3V3_0 pfet_06v0 ad=21.472n pd=0.664m as=0.50045u ps=0.0145 w=244 l=100
X18 res_c 5v0_add_q_sc_0/ctrl_over int_carry VSS_3 nfet_06v0 ad=0 pd=0 as=31.489n ps=1.041m w=164 l=120
X19 res_c 5v0_add_q_sc_0/ctrl_over 5v0_add_q_sc_0/5v0_half_adder_selector_sc_0/res_stage0 VDD_3V3_0 pfet_06v0 ad=0 pd=0 as=0 ps=0 w=244 l=100
X20 5v0_add_q_sc_0/inv_pti 5v0_add_q_sc_0/pti VSS_3 VSS_3 nfet_06v0 ad=14.432n pd=0.504m as=14.432n ps=0.504m w=164 l=120
X21 5v0_add_q_sc_0/inv_pti 5v0_add_q_sc_0/pti VDD_3V3_0 VDD_3V3_0 pfet_06v0 ad=21.472n pd=0.664m as=21.472n ps=0.664m w=244 l=100
X22 5v0_add_q_sc_0/a_n1373_n454# 5v0_add_q_sc_0/inv_nti 5v0_add_q_sc_0/downstepper_test VSS_3 nfet_06v0 ad=3.528n pd=0.195m as=8.599n ps=0.264m w=147 l=120
X23 5v0_add_q_sc_0/upstepper_test 5v0_add_q_sc_0/nti 5v0_add_q_sc_0/a_n1205_n937# VDD_3V3_0 pfet_06v0 ad=21.384n pd=0.662m as=5.832n ps=0.291m w=243 l=100
X24 5v0_add_q_sc_0/inv_nti 5v0_add_q_sc_0/nti VDD_3V3_0 VDD_3V3_0 pfet_06v0 ad=21.472n pd=0.664m as=21.472n ps=0.664m w=244 l=100
X25 5v0_add_q_sc_0/upstepper_test 5v0_add_q_sc_0/nti VDD_1V65_5 VSS_3 nfet_06v0 ad=14.847n pd=0.496m as=10.51n ps=0.29m w=147 l=120
X26 5v0_add_q_sc_0/a_n1205_n937# 5v0_add_q_sc_0/inv_pti VDD_3V3_0 VDD_3V3_0 pfet_06v0 ad=5.832n pd=0.291m as=21.384n ps=0.662m w=243 l=100
X27 5v0_add_q_sc_0/downstepper_test 5v0_add_q_sc_0/pti 5v0_add_q_sc_0/a_n1778_n454# VSS_3 nfet_06v0 ad=8.599n pd=0.264m as=3.528n ps=0.195m w=147 l=120
X28 5v0_add_q_sc_0/inv_nti 5v0_add_q_sc_0/nti VSS_3 VSS_3 nfet_06v0 ad=14.432n pd=0.504m as=14.432n ps=0.504m w=164 l=120
X29 5v0_add_q_sc_0/a_n1778_n454# 5v0_add_q_sc_0/inv_nti VSS_3 VSS_3 nfet_06v0 ad=3.528n pd=0.195m as=14.847n ps=0.496m w=147 l=120
X30 5v0_add_q_sc_0/upstepper_test 5v0_add_q_sc_0/inv_pti VSS_3 VSS_3 nfet_06v0 ad=14.432n pd=0.504m as=14.432n ps=0.504m w=164 l=120
X31 VDD_1V65_5 5v0_add_q_sc_0/inv_pti 5v0_add_q_sc_0/a_n1373_n454# VSS_3 nfet_06v0 ad=10.51n pd=0.29m as=3.528n ps=0.195m w=147 l=120
X32 5v0_add_q_sc_0/downstepper_test 5v0_add_q_sc_0/inv_nti VDD_3V3_0 VDD_3V3_0 pfet_06v0 ad=21.384n pd=0.662m as=21.384n ps=0.662m w=243 l=100
X33 5v0_add_q_sc_1/pti int_c01 VSS_3 VSS_3 nfet_06v0 ad=6.336n pd=0.32m as=0 ps=0 w=72 l=578
X34 VDD_3V3_1 int_c01 5v0_add_q_sc_1/pti VDD_3V3_1 pfet_06v0 ad=0.54021u pd=0.01553 as=52.704n ps=1.408m w=244 l=100
X35 VDD_3V3_1 int_c01 5v0_add_q_sc_1/nti VDD_3V3_1 pfet_06v0 ad=0 pd=0 as=9.696n ps=0.394m w=96 l=150
X36 VSS_3 int_c01 5v0_add_q_sc_1/nti VSS_3 nfet_06v0 ad=0 pd=0 as=12.7n ps=0.454m w=127 l=120
X37 5v0_add_q_sc_1/pti int_c01 VDD_3V3_1 VDD_3V3_1 pfet_06v0 ad=0 pd=0 as=0 ps=0 w=244 l=100
X38 5v0_add_q_sc_1/pti int_c01 VDD_3V3_1 VDD_3V3_1 pfet_06v0 ad=0 pd=0 as=0 ps=0 w=244 l=100
X39 5v0_add_q_sc_1/5v0_half_adder_selector_sc_0/res_stage0 5v0_add_q_sc_1/5v0_half_adder_selector_sc_0/m1_n239_179# 5v0_add_q_sc_1/downstepper_test VSS_3 nfet_06v0 ad=31.489n pd=1.041m as=31.631n ps=1.032m w=164 l=120
X40 5v0_add_q_sc_1/5v0_half_adder_selector_sc_0/res_stage0 5v0_add_q_sc_1/5v0_half_adder_selector_sc_0/m1_n239_179# 5v0_add_q_sc_1/upstepper_test VDD_3V3_1 pfet_06v0 ad=46.849n pd=1.361m as=42.856n ps=1.326m w=244 l=100
X41 5v0_add_q_sc_1/5v0_half_adder_selector_sc_0/m1_n239_179# c_2_s VSS_3 VSS_3 nfet_06v0 ad=14.432n pd=0.504m as=0 ps=0 w=164 l=120
X42 5v0_add_q_sc_1/5v0_half_adder_selector_sc_0/m1_n239_179# c_2_s VDD_3V3_1 VDD_3V3_1 pfet_06v0 ad=21.472n pd=0.664m as=0 ps=0 w=244 l=100
X43 5v0_add_q_sc_1/5v0_half_adder_selector_sc_0/res_stage0 c_2_s 5v0_add_q_sc_1/upstepper_test VSS_3 nfet_06v0 ad=0 pd=0 as=43.711n ps=1.504m w=164 l=120
X44 5v0_add_q_sc_1/5v0_half_adder_selector_sc_0/res_stage0 c_2_s 5v0_add_q_sc_1/downstepper_test VDD_3V3_1 pfet_06v0 ad=0 pd=0 as=42.856n ps=1.326m w=244 l=100
X45 int_carry 5v0_add_q_sc_1/5v0_half_adder_selector_sc_0/m1_n244_n517# 5v0_add_q_sc_1/5v0_half_adder_selector_sc_0/res_stage0 VSS_3 nfet_06v0 ad=0 pd=0 as=0 ps=0 w=164 l=120
X46 int_carry 5v0_add_q_sc_1/5v0_half_adder_selector_sc_0/m1_n244_n517# int_c01 VDD_3V3_1 pfet_06v0 ad=0 pd=0 as=42.946n ps=1.33m w=244 l=100
X47 5v0_add_q_sc_1/5v0_half_adder_selector_sc_0/m1_n244_n517# c_2_o VSS_3 VSS_3 nfet_06v0 ad=14.432n pd=0.504m as=0 ps=0 w=164 l=120
X48 5v0_add_q_sc_1/5v0_half_adder_selector_sc_0/m1_n244_n517# c_2_o VDD_3V3_1 VDD_3V3_1 pfet_06v0 ad=21.472n pd=0.664m as=0 ps=0 w=244 l=100
X49 int_carry c_2_o int_c01 VSS_3 nfet_06v0 ad=0 pd=0 as=31.489n ps=1.041m w=164 l=120
X50 int_carry c_2_o 5v0_add_q_sc_1/5v0_half_adder_selector_sc_0/res_stage0 VDD_3V3_1 pfet_06v0 ad=0 pd=0 as=0 ps=0 w=244 l=100
X51 5v0_add_q_sc_1/inv_pti 5v0_add_q_sc_1/pti VSS_3 VSS_3 nfet_06v0 ad=14.432n pd=0.504m as=0 ps=0 w=164 l=120
X52 5v0_add_q_sc_1/inv_pti 5v0_add_q_sc_1/pti VDD_3V3_1 VDD_3V3_1 pfet_06v0 ad=21.472n pd=0.664m as=0 ps=0 w=244 l=100
X53 5v0_add_q_sc_1/a_n1373_n454# 5v0_add_q_sc_1/inv_nti 5v0_add_q_sc_1/downstepper_test VSS_3 nfet_06v0 ad=7.056n pd=0.39m as=0 ps=0 w=147 l=120
X54 5v0_add_q_sc_1/upstepper_test 5v0_add_q_sc_1/nti 5v0_add_q_sc_1/a_n1205_n937# VDD_3V3_1 pfet_06v0 ad=0 pd=0 as=11.664n ps=0.582m w=243 l=100
X55 5v0_add_q_sc_1/inv_nti 5v0_add_q_sc_1/nti VDD_3V3_1 VDD_3V3_1 pfet_06v0 ad=21.472n pd=0.664m as=0 ps=0 w=244 l=100
X56 5v0_add_q_sc_1/upstepper_test 5v0_add_q_sc_1/nti VDD_1V65_1 VSS_3 nfet_06v0 ad=0 pd=0 as=21.021n ps=0.58m w=147 l=120
X57 5v0_add_q_sc_1/a_n1205_n937# 5v0_add_q_sc_1/inv_pti VDD_3V3_1 VDD_3V3_1 pfet_06v0 ad=0 pd=0 as=0 ps=0 w=243 l=100
X58 5v0_add_q_sc_1/downstepper_test 5v0_add_q_sc_1/pti 5v0_add_q_sc_1/a_n1778_n454# VSS_3 nfet_06v0 ad=0 pd=0 as=7.056n ps=0.39m w=147 l=120
X59 5v0_add_q_sc_1/inv_nti 5v0_add_q_sc_1/nti VSS_3 VSS_3 nfet_06v0 ad=14.432n pd=0.504m as=0 ps=0 w=164 l=120
X60 5v0_add_q_sc_1/a_n1778_n454# 5v0_add_q_sc_1/inv_nti VSS_3 VSS_3 nfet_06v0 ad=0 pd=0 as=0 ps=0 w=147 l=120
X61 5v0_add_q_sc_1/upstepper_test 5v0_add_q_sc_1/inv_pti VSS_3 VSS_3 nfet_06v0 ad=0 pd=0 as=0 ps=0 w=164 l=120
X62 VDD_1V65_1 5v0_add_q_sc_1/inv_pti 5v0_add_q_sc_1/a_n1373_n454# VSS_3 nfet_06v0 ad=0 pd=0 as=0 ps=0 w=147 l=120
X63 5v0_add_q_sc_1/downstepper_test 5v0_add_q_sc_1/inv_nti VDD_3V3_1 VDD_3V3_1 pfet_06v0 ad=0 pd=0 as=0 ps=0 w=243 l=100
X64 5v0_addh_sc_tile_2/ctrl_over 5v0_addh_sc_tile_2/ctrl_sign 5v0_nter2oter_code_sc_0/gf180mcu_fd_sc_mcu7t5v0__nor2_1_0/a_224_472# VDD_3V3_0 pfet_06v0 ad=21.472n pd=0.664m as=16.348n ps=0.378m w=244 l=100
X65 VSS_3 5v0_addh_sc_tile_2/ctrl_sign 5v0_addh_sc_tile_2/ctrl_over VSS_3 nfet_06v0 ad=9.944n pd=0.402m as=5.876n ps=0.217m w=113 l=120
X66 5v0_nter2oter_code_sc_0/gf180mcu_fd_sc_mcu7t5v0__nor2_1_0/a_224_472# 5v0_nter2oter_code_sc_0/nti VDD_3V3_0 VDD_3V3_0 pfet_06v0 ad=16.348n pd=0.378m as=20.932n ps=0.664m w=244 l=100
X67 5v0_addh_sc_tile_2/ctrl_over 5v0_nter2oter_code_sc_0/nti VSS_3 VSS_3 nfet_06v0 ad=5.876n pd=0.217m as=9.944n ps=0.402m w=113 l=120
X68 5v0_addh_sc_tile_2/ctrl_sign 5v0_nter2oter_code_sc_0/pti VSS_3 VSS_3 nfet_06v0 ad=14.432n pd=0.504m as=0 ps=0 w=164 l=120
X69 5v0_addh_sc_tile_2/ctrl_sign 5v0_nter2oter_code_sc_0/pti VDD_3V3_0 VDD_3V3_0 pfet_06v0 ad=21.472n pd=0.664m as=0 ps=0 w=244 l=100
X70 5v0_nter2oter_code_sc_0/pti int_012 VSS_3 VSS_3 nfet_06v0 ad=6.336n pd=0.32m as=6.478n ps=0.255m w=72 l=578
X71 VDD_3V3_1 int_012 5v0_nter2oter_code_sc_0/pti VDD_3V3_1 pfet_06v0 ad=12.81n pd=0.349m as=12.688n ps=0.348m w=244 l=100
X72 VDD_3V3_1 int_012 5v0_nter2oter_code_sc_0/nti VDD_3V3_1 pfet_06v0 ad=13.616n pd=0.392m as=9.696n ps=0.394m w=96 l=150
X73 VSS_3 int_012 5v0_nter2oter_code_sc_0/nti VSS_3 nfet_06v0 ad=6.478n pd=0.255m as=12.7n ps=0.454m w=127 l=120
X74 5v0_nter2oter_code_sc_0/pti int_012 VDD_3V3_1 VDD_3V3_1 pfet_06v0 ad=12.688n pd=0.348m as=13.616n ps=0.392m w=244 l=100
X75 5v0_nter2oter_code_sc_0/pti int_012 VDD_3V3_1 VDD_3V3_1 pfet_06v0 ad=27.328n pd=0.712m as=12.81n ps=0.349m w=244 l=100
X76 5v0_addh_sc_tile_1/ctrl_over 5v0_addh_sc_tile_1/ctrl_sign 5v0_nter2oter_code_sc_1/gf180mcu_fd_sc_mcu7t5v0__nor2_1_0/a_224_472# VDD_3V3_0 pfet_06v0 ad=21.472n pd=0.664m as=32.696n ps=0.756m w=244 l=100
X77 VSS_3 5v0_addh_sc_tile_1/ctrl_sign 5v0_addh_sc_tile_1/ctrl_over VSS_3 nfet_06v0 ad=0 pd=0 as=11.752n ps=0.434m w=113 l=120
X78 5v0_nter2oter_code_sc_1/gf180mcu_fd_sc_mcu7t5v0__nor2_1_0/a_224_472# 5v0_nter2oter_code_sc_1/nti VDD_3V3_0 VDD_3V3_0 pfet_06v0 ad=0 pd=0 as=0 ps=0 w=244 l=100
X79 5v0_addh_sc_tile_1/ctrl_over 5v0_nter2oter_code_sc_1/nti VSS_3 VSS_3 nfet_06v0 ad=0 pd=0 as=0 ps=0 w=113 l=120
X80 5v0_addh_sc_tile_1/ctrl_sign 5v0_nter2oter_code_sc_1/pti VSS_3 VSS_3 nfet_06v0 ad=14.432n pd=0.504m as=0 ps=0 w=164 l=120
X81 5v0_addh_sc_tile_1/ctrl_sign 5v0_nter2oter_code_sc_1/pti VDD_3V3_0 VDD_3V3_0 pfet_06v0 ad=21.472n pd=0.664m as=0 ps=0 w=244 l=100
X82 5v0_nter2oter_code_sc_1/pti in_2 VSS_3 VSS_3 nfet_06v0 ad=6.336n pd=0.32m as=0 ps=0 w=72 l=578
X83 VDD_3V3_1 in_2 5v0_nter2oter_code_sc_1/pti VDD_3V3_1 pfet_06v0 ad=0 pd=0 as=52.704n ps=1.408m w=244 l=100
X84 VDD_3V3_1 in_2 5v0_nter2oter_code_sc_1/nti VDD_3V3_1 pfet_06v0 ad=0 pd=0 as=9.696n ps=0.394m w=96 l=150
X85 VSS_3 in_2 5v0_nter2oter_code_sc_1/nti VSS_3 nfet_06v0 ad=0 pd=0 as=12.7n ps=0.454m w=127 l=120
X86 5v0_nter2oter_code_sc_1/pti in_2 VDD_3V3_1 VDD_3V3_1 pfet_06v0 ad=0 pd=0 as=0 ps=0 w=244 l=100
X87 5v0_nter2oter_code_sc_1/pti in_2 VDD_3V3_1 VDD_3V3_1 pfet_06v0 ad=0 pd=0 as=0 ps=0 w=244 l=100
X88 m1_n2844_n810# 5v0_addh_sc_tile_0/carry_0_probe VSS_3 VSS_3 nfet_06v0 ad=14.432n pd=0.504m as=0 ps=0 w=164 l=120
X89 m1_n2844_n810# 5v0_addh_sc_tile_0/carry_0_probe VDD_3V3_1 VDD_3V3_1 pfet_06v0 ad=21.472n pd=0.664m as=0 ps=0 w=244 l=100
X90 5v0_addh_sc_tile_0/pti in_1 VSS_3 VSS_3 nfet_06v0 ad=20.768n pd=0.824m as=0 ps=0 w=72 l=578
X91 VDD_3V3_1 in_1 5v0_addh_sc_tile_0/pti VDD_3V3_1 pfet_06v0 ad=0 pd=0 as=74.176n ps=2.072m w=244 l=100
X92 VDD_3V3_1 in_1 5v0_addh_sc_tile_0/nti VDD_3V3_1 pfet_06v0 ad=0 pd=0 as=9.696n ps=0.394m w=96 l=150
X93 VSS_3 in_1 5v0_addh_sc_tile_0/nti VSS_3 nfet_06v0 ad=0 pd=0 as=12.7n ps=0.454m w=127 l=120
X94 5v0_addh_sc_tile_0/pti in_1 VDD_3V3_1 VDD_3V3_1 pfet_06v0 ad=0 pd=0 as=0 ps=0 w=244 l=100
X95 5v0_addh_sc_tile_0/pti in_1 VDD_3V3_1 VDD_3V3_1 pfet_06v0 ad=0 pd=0 as=0 ps=0 w=244 l=100
X96 5v0_addh_sc_tile_0/5v0_half_adder_selector_sc_0/res_stage0 5v0_addh_sc_tile_0/m1_103_293# 5v0_addh_sc_tile_0/downstepper_test VSS_3 nfet_06v0 ad=31.489n pd=1.041m as=31.631n ps=1.032m w=164 l=120
X97 5v0_addh_sc_tile_0/5v0_half_adder_selector_sc_0/res_stage0 5v0_addh_sc_tile_0/m1_103_293# 5v0_addh_sc_tile_0/upstepper_test VDD_3V3_1 pfet_06v0 ad=46.849n pd=1.361m as=42.856n ps=1.326m w=244 l=100
X98 5v0_addh_sc_tile_0/m1_103_293# in_0_sign VSS_3 VSS_3 nfet_06v0 ad=14.432n pd=0.504m as=0 ps=0 w=164 l=120
X99 5v0_addh_sc_tile_0/m1_103_293# in_0_sign VDD_3V3_1 VDD_3V3_1 pfet_06v0 ad=21.472n pd=0.664m as=0 ps=0 w=244 l=100
X100 5v0_addh_sc_tile_0/5v0_half_adder_selector_sc_0/res_stage0 in_0_sign 5v0_addh_sc_tile_0/upstepper_test VSS_3 nfet_06v0 ad=0 pd=0 as=43.711n ps=1.504m w=164 l=120
X101 5v0_addh_sc_tile_0/5v0_half_adder_selector_sc_0/res_stage0 in_0_sign 5v0_addh_sc_tile_0/downstepper_test VDD_3V3_1 pfet_06v0 ad=0 pd=0 as=42.856n ps=1.326m w=244 l=100
X102 res_01 5v0_addh_sc_tile_0/a_382_n1095# 5v0_addh_sc_tile_0/5v0_half_adder_selector_sc_0/res_stage0 VSS_3 nfet_06v0 ad=31.489n pd=1.041m as=0 ps=0 w=164 l=120
X103 res_01 5v0_addh_sc_tile_0/a_382_n1095# in_1 VDD_3V3_1 pfet_06v0 ad=46.849n pd=1.361m as=21.472n ps=0.664m w=244 l=100
X104 5v0_addh_sc_tile_0/a_382_n1095# in_0_over VSS_3 VSS_3 nfet_06v0 ad=14.432n pd=0.504m as=0 ps=0 w=164 l=120
X105 5v0_addh_sc_tile_0/a_382_n1095# in_0_over VDD_3V3_1 VDD_3V3_1 pfet_06v0 ad=21.472n pd=0.664m as=0 ps=0 w=244 l=100
X106 res_01 in_0_over in_1 VSS_3 nfet_06v0 ad=0 pd=0 as=14.432n ps=0.504m w=164 l=120
X107 res_01 in_0_over 5v0_addh_sc_tile_0/5v0_half_adder_selector_sc_0/res_stage0 VDD_3V3_1 pfet_06v0 ad=0 pd=0 as=0 ps=0 w=244 l=100
X108 5v0_addh_sc_tile_0/inv_pti 5v0_addh_sc_tile_0/pti VSS_3 VSS_3 nfet_06v0 ad=28.864n pd=1.008m as=0 ps=0 w=164 l=120
X109 5v0_addh_sc_tile_0/inv_pti 5v0_addh_sc_tile_0/pti VDD_3V3_1 VDD_3V3_1 pfet_06v0 ad=42.944n pd=1.328m as=0 ps=0 w=244 l=100
X110 5v0_addh_sc_tile_0/carry_0_probe 5v0_addh_sc_tile_0/a_382_n1095# 5v0_addh_sc_tile_0/m1_843_n857# VSS_3 nfet_06v0 ad=14.432n pd=0.504m as=14.432n ps=0.504m w=164 l=120
X111 5v0_addh_sc_tile_0/carry_0_probe in_0_over 5v0_addh_sc_tile_0/m1_843_n857# VDD_3V3_1 pfet_06v0 ad=21.472n pd=0.664m as=21.472n ps=0.664m w=244 l=100
X112 5v0_addh_sc_tile_0/inv_nti in_0_sign 5v0_addh_sc_tile_0/carry_sign_probe VDD_3V3_1 pfet_06v0 ad=21.472n pd=0.664m as=12.688n ps=0.348m w=244 l=100
X113 5v0_addh_sc_tile_0/carry_sign_probe 5v0_addh_sc_tile_0/m1_103_293# 5v0_addh_sc_tile_0/inv_nti VSS_3 nfet_06v0 ad=8.528n pd=0.268m as=14.432n ps=0.504m w=164 l=120
X114 5v0_addh_sc_tile_0/carry_sign_probe 5v0_addh_sc_tile_0/m1_103_293# 5v0_addh_sc_tile_0/inv_pti VDD_3V3_1 pfet_06v0 ad=12.688n pd=0.348m as=21.472n ps=0.664m w=244 l=100
X115 5v0_addh_sc_tile_0/inv_pti in_0_sign 5v0_addh_sc_tile_0/carry_sign_probe VSS_3 nfet_06v0 ad=14.432n pd=0.504m as=8.528n ps=0.268m w=164 l=120
X116 5v0_addh_sc_tile_0/inv_nti in_0_sign 5v0_addh_sc_tile_0/m1_843_n857# VDD_3V3_1 pfet_06v0 ad=64.416n pd=1.992m as=46.848n ps=1.36m w=244 l=100
X117 5v0_addh_sc_tile_0/m1_843_n857# 5v0_addh_sc_tile_0/m1_103_293# 5v0_addh_sc_tile_0/inv_nti VSS_3 nfet_06v0 ad=31.488n pd=1.04m as=43.296n ps=1.512m w=164 l=120
X118 5v0_addh_sc_tile_0/m1_843_n857# 5v0_addh_sc_tile_0/m1_103_293# 5v0_addh_sc_tile_0/pti VDD_3V3_1 pfet_06v0 ad=0 pd=0 as=0 ps=0 w=244 l=100
X119 5v0_addh_sc_tile_0/pti in_0_sign 5v0_addh_sc_tile_0/m1_843_n857# VSS_3 nfet_06v0 ad=0 pd=0 as=0 ps=0 w=164 l=120
X120 5v0_addh_sc_tile_0/a_n1373_n454# 5v0_addh_sc_tile_0/inv_nti 5v0_addh_sc_tile_0/downstepper_test VSS_3 nfet_06v0 ad=3.528n pd=0.195m as=8.599n ps=0.264m w=147 l=120
X121 5v0_addh_sc_tile_0/upstepper_test 5v0_addh_sc_tile_0/nti 5v0_addh_sc_tile_0/a_n1205_n937# VDD_3V3_1 pfet_06v0 ad=21.384n pd=0.662m as=5.832n ps=0.291m w=243 l=100
X122 5v0_addh_sc_tile_0/inv_nti 5v0_addh_sc_tile_0/nti VDD_3V3_1 VDD_3V3_1 pfet_06v0 ad=21.472n pd=0.664m as=21.472n ps=0.664m w=244 l=100
X123 5v0_addh_sc_tile_0/upstepper_test 5v0_addh_sc_tile_0/nti VDD_1V65_0 VSS_3 nfet_06v0 ad=14.847n pd=0.496m as=10.51n ps=0.29m w=147 l=120
X124 5v0_addh_sc_tile_0/carry_0_probe 5v0_addh_sc_tile_0/a_382_n1095# VDD_3V3_1 VDD_3V3_1 pfet_06v0 ad=21.472n pd=0.664m as=21.472n ps=0.664m w=244 l=100
X125 5v0_addh_sc_tile_0/a_n1205_n937# 5v0_addh_sc_tile_0/inv_pti VDD_3V3_1 VDD_3V3_1 pfet_06v0 ad=5.832n pd=0.291m as=21.384n ps=0.662m w=243 l=100
X126 5v0_addh_sc_tile_0/downstepper_test 5v0_addh_sc_tile_0/pti 5v0_addh_sc_tile_0/a_n1778_n454# VSS_3 nfet_06v0 ad=8.599n pd=0.264m as=3.528n ps=0.195m w=147 l=120
X127 5v0_addh_sc_tile_0/inv_nti 5v0_addh_sc_tile_0/nti VSS_3 VSS_3 nfet_06v0 ad=14.432n pd=0.504m as=14.432n ps=0.504m w=164 l=120
X128 5v0_addh_sc_tile_0/a_n1778_n454# 5v0_addh_sc_tile_0/inv_nti VSS_3 VSS_3 nfet_06v0 ad=3.528n pd=0.195m as=14.847n ps=0.496m w=147 l=120
X129 5v0_addh_sc_tile_0/upstepper_test 5v0_addh_sc_tile_0/inv_pti VSS_3 VSS_3 nfet_06v0 ad=14.432n pd=0.504m as=14.432n ps=0.504m w=164 l=120
X130 VDD_1V65_0 5v0_addh_sc_tile_0/inv_pti 5v0_addh_sc_tile_0/a_n1373_n454# VSS_3 nfet_06v0 ad=10.51n pd=0.29m as=3.528n ps=0.195m w=147 l=120
X131 5v0_addh_sc_tile_0/downstepper_test 5v0_addh_sc_tile_0/inv_nti VDD_3V3_1 VDD_3V3_1 pfet_06v0 ad=21.384n pd=0.662m as=21.384n ps=0.662m w=243 l=100
X132 5v0_addh_sc_tile_1/pti res_01 VSS_3 VSS_3 nfet_06v0 ad=20.768n pd=0.824m as=0 ps=0 w=72 l=578
X133 VDD_3V3_1 res_01 5v0_addh_sc_tile_1/pti VDD_3V3_1 pfet_06v0 ad=0 pd=0 as=74.176n ps=2.072m w=244 l=100
X134 VDD_3V3_1 res_01 5v0_addh_sc_tile_1/nti VDD_3V3_1 pfet_06v0 ad=0 pd=0 as=9.696n ps=0.394m w=96 l=150
X135 VSS_3 res_01 5v0_addh_sc_tile_1/nti VSS_3 nfet_06v0 ad=0 pd=0 as=12.7n ps=0.454m w=127 l=120
X136 5v0_addh_sc_tile_1/pti res_01 VDD_3V3_1 VDD_3V3_1 pfet_06v0 ad=0 pd=0 as=0 ps=0 w=244 l=100
X137 5v0_addh_sc_tile_1/pti res_01 VDD_3V3_1 VDD_3V3_1 pfet_06v0 ad=0 pd=0 as=0 ps=0 w=244 l=100
X138 5v0_addh_sc_tile_1/5v0_half_adder_selector_sc_0/res_stage0 5v0_addh_sc_tile_1/m1_103_293# 5v0_addh_sc_tile_1/downstepper_test VSS_3 nfet_06v0 ad=31.489n pd=1.041m as=31.631n ps=1.032m w=164 l=120
X139 5v0_addh_sc_tile_1/5v0_half_adder_selector_sc_0/res_stage0 5v0_addh_sc_tile_1/m1_103_293# 5v0_addh_sc_tile_1/upstepper_test VDD_3V3_1 pfet_06v0 ad=46.849n pd=1.361m as=42.856n ps=1.326m w=244 l=100
X140 5v0_addh_sc_tile_1/m1_103_293# 5v0_addh_sc_tile_1/ctrl_sign VSS_3 VSS_3 nfet_06v0 ad=14.432n pd=0.504m as=0 ps=0 w=164 l=120
X141 5v0_addh_sc_tile_1/m1_103_293# 5v0_addh_sc_tile_1/ctrl_sign VDD_3V3_1 VDD_3V3_1 pfet_06v0 ad=21.472n pd=0.664m as=0 ps=0 w=244 l=100
X142 5v0_addh_sc_tile_1/5v0_half_adder_selector_sc_0/res_stage0 5v0_addh_sc_tile_1/ctrl_sign 5v0_addh_sc_tile_1/upstepper_test VSS_3 nfet_06v0 ad=0 pd=0 as=43.711n ps=1.504m w=164 l=120
X143 5v0_addh_sc_tile_1/5v0_half_adder_selector_sc_0/res_stage0 5v0_addh_sc_tile_1/ctrl_sign 5v0_addh_sc_tile_1/downstepper_test VDD_3V3_1 pfet_06v0 ad=0 pd=0 as=42.856n ps=1.326m w=244 l=100
X144 int_012 5v0_addh_sc_tile_1/a_382_n1095# 5v0_addh_sc_tile_1/5v0_half_adder_selector_sc_0/res_stage0 VSS_3 nfet_06v0 ad=17.057n pd=0.537m as=0 ps=0 w=164 l=120
X145 int_012 5v0_addh_sc_tile_1/a_382_n1095# res_01 VDD_3V3_0 pfet_06v0 ad=25.377n pd=0.697m as=0 ps=0 w=244 l=100
X146 5v0_addh_sc_tile_1/a_382_n1095# 5v0_addh_sc_tile_1/ctrl_over VSS_3 VSS_3 nfet_06v0 ad=14.432n pd=0.504m as=0 ps=0 w=164 l=120
X147 5v0_addh_sc_tile_1/a_382_n1095# 5v0_addh_sc_tile_1/ctrl_over VDD_3V3_0 VDD_3V3_0 pfet_06v0 ad=21.472n pd=0.664m as=0 ps=0 w=244 l=100
X148 int_012 5v0_addh_sc_tile_1/ctrl_over res_01 VSS_3 nfet_06v0 ad=0 pd=0 as=0 ps=0 w=164 l=120
X149 int_012 5v0_addh_sc_tile_1/ctrl_over 5v0_addh_sc_tile_1/5v0_half_adder_selector_sc_0/res_stage0 VDD_3V3_0 pfet_06v0 ad=0 pd=0 as=0 ps=0 w=244 l=100
X150 5v0_addh_sc_tile_1/inv_pti 5v0_addh_sc_tile_1/pti VSS_3 VSS_3 nfet_06v0 ad=28.864n pd=1.008m as=0 ps=0 w=164 l=120
X151 5v0_addh_sc_tile_1/inv_pti 5v0_addh_sc_tile_1/pti VDD_3V3_1 VDD_3V3_1 pfet_06v0 ad=42.944n pd=1.328m as=0 ps=0 w=244 l=100
X152 c_2_o 5v0_addh_sc_tile_1/a_382_n1095# 5v0_addh_sc_tile_1/m1_843_n857# VSS_3 nfet_06v0 ad=14.432n pd=0.504m as=31.488n ps=1.04m w=164 l=120
X153 c_2_o 5v0_addh_sc_tile_1/ctrl_over 5v0_addh_sc_tile_1/m1_843_n857# VDD_3V3_0 pfet_06v0 ad=42.944n pd=1.328m as=46.848n ps=1.36m w=244 l=100
X154 5v0_addh_sc_tile_1/inv_nti 5v0_addh_sc_tile_1/ctrl_sign c_2_s VDD_3V3_1 pfet_06v0 ad=64.416n pd=1.992m as=25.376n ps=0.696m w=244 l=100
X155 c_2_s 5v0_addh_sc_tile_1/m1_103_293# 5v0_addh_sc_tile_1/inv_nti VSS_3 nfet_06v0 ad=17.056n pd=0.536m as=43.296n ps=1.512m w=164 l=120
X156 c_2_s 5v0_addh_sc_tile_1/m1_103_293# 5v0_addh_sc_tile_1/inv_pti VDD_3V3_1 pfet_06v0 ad=0 pd=0 as=0 ps=0 w=244 l=100
X157 5v0_addh_sc_tile_1/inv_pti 5v0_addh_sc_tile_1/ctrl_sign c_2_s VSS_3 nfet_06v0 ad=0 pd=0 as=0 ps=0 w=164 l=120
X158 5v0_addh_sc_tile_1/inv_nti 5v0_addh_sc_tile_1/ctrl_sign 5v0_addh_sc_tile_1/m1_843_n857# VDD_3V3_0 pfet_06v0 ad=0 pd=0 as=0 ps=0 w=244 l=100
X159 5v0_addh_sc_tile_1/m1_843_n857# 5v0_addh_sc_tile_1/m1_103_293# 5v0_addh_sc_tile_1/inv_nti VSS_3 nfet_06v0 ad=0 pd=0 as=0 ps=0 w=164 l=120
X160 5v0_addh_sc_tile_1/m1_843_n857# 5v0_addh_sc_tile_1/m1_103_293# 5v0_addh_sc_tile_1/pti VDD_3V3_0 pfet_06v0 ad=0 pd=0 as=0 ps=0 w=244 l=100
X161 5v0_addh_sc_tile_1/pti 5v0_addh_sc_tile_1/ctrl_sign 5v0_addh_sc_tile_1/m1_843_n857# VSS_3 nfet_06v0 ad=0 pd=0 as=0 ps=0 w=164 l=120
X162 5v0_addh_sc_tile_1/a_n1373_n454# 5v0_addh_sc_tile_1/inv_nti 5v0_addh_sc_tile_1/downstepper_test VSS_3 nfet_06v0 ad=7.056n pd=0.39m as=0 ps=0 w=147 l=120
X163 5v0_addh_sc_tile_1/upstepper_test 5v0_addh_sc_tile_1/nti 5v0_addh_sc_tile_1/a_n1205_n937# VDD_3V3_0 pfet_06v0 ad=0 pd=0 as=11.664n ps=0.582m w=243 l=100
X164 5v0_addh_sc_tile_1/inv_nti 5v0_addh_sc_tile_1/nti VDD_3V3_0 VDD_3V3_0 pfet_06v0 ad=0 pd=0 as=0 ps=0 w=244 l=100
X165 5v0_addh_sc_tile_1/upstepper_test 5v0_addh_sc_tile_1/nti VDD_1V65_3 VSS_3 nfet_06v0 ad=0 pd=0 as=21.021n ps=0.58m w=147 l=120
X166 c_2_o 5v0_addh_sc_tile_1/a_382_n1095# VDD_3V3_0 VDD_3V3_0 pfet_06v0 ad=0 pd=0 as=0 ps=0 w=244 l=100
X167 5v0_addh_sc_tile_1/a_n1205_n937# 5v0_addh_sc_tile_1/inv_pti VDD_3V3_0 VDD_3V3_0 pfet_06v0 ad=0 pd=0 as=0 ps=0 w=243 l=100
X168 5v0_addh_sc_tile_1/downstepper_test 5v0_addh_sc_tile_1/pti 5v0_addh_sc_tile_1/a_n1778_n454# VSS_3 nfet_06v0 ad=0 pd=0 as=7.056n ps=0.39m w=147 l=120
X169 5v0_addh_sc_tile_1/inv_nti 5v0_addh_sc_tile_1/nti VSS_3 VSS_3 nfet_06v0 ad=0 pd=0 as=0 ps=0 w=164 l=120
X170 5v0_addh_sc_tile_1/a_n1778_n454# 5v0_addh_sc_tile_1/inv_nti VSS_3 VSS_3 nfet_06v0 ad=0 pd=0 as=0 ps=0 w=147 l=120
X171 5v0_addh_sc_tile_1/upstepper_test 5v0_addh_sc_tile_1/inv_pti VSS_3 VSS_3 nfet_06v0 ad=0 pd=0 as=0 ps=0 w=164 l=120
X172 VDD_1V65_3 5v0_addh_sc_tile_1/inv_pti 5v0_addh_sc_tile_1/a_n1373_n454# VSS_3 nfet_06v0 ad=0 pd=0 as=0 ps=0 w=147 l=120
X173 5v0_addh_sc_tile_1/downstepper_test 5v0_addh_sc_tile_1/inv_nti VDD_3V3_0 VDD_3V3_0 pfet_06v0 ad=0 pd=0 as=0 ps=0 w=243 l=100
X174 5v0_addh_sc_tile_2/pti in_3 VSS_3 VSS_3 nfet_06v0 ad=20.768n pd=0.824m as=0 ps=0 w=72 l=578
X175 VDD_3V3_0 in_3 5v0_addh_sc_tile_2/pti VDD_3V3_0 pfet_06v0 ad=0 pd=0 as=74.176n ps=2.072m w=244 l=100
X176 VDD_3V3_0 in_3 5v0_addh_sc_tile_2/nti VDD_3V3_0 pfet_06v0 ad=0 pd=0 as=9.696n ps=0.394m w=96 l=150
X177 VSS_3 in_3 5v0_addh_sc_tile_2/nti VSS_3 nfet_06v0 ad=0 pd=0 as=12.7n ps=0.454m w=127 l=120
X178 5v0_addh_sc_tile_2/pti in_3 VDD_3V3_0 VDD_3V3_0 pfet_06v0 ad=0 pd=0 as=0 ps=0 w=244 l=100
X179 5v0_addh_sc_tile_2/pti in_3 VDD_3V3_0 VDD_3V3_0 pfet_06v0 ad=0 pd=0 as=0 ps=0 w=244 l=100
X180 5v0_addh_sc_tile_2/5v0_half_adder_selector_sc_0/res_stage0 5v0_addh_sc_tile_2/m1_103_293# 5v0_addh_sc_tile_2/downstepper_test VSS_3 nfet_06v0 ad=31.489n pd=1.041m as=31.631n ps=1.032m w=164 l=120
X181 5v0_addh_sc_tile_2/5v0_half_adder_selector_sc_0/res_stage0 5v0_addh_sc_tile_2/m1_103_293# 5v0_addh_sc_tile_2/upstepper_test VDD_3V3_0 pfet_06v0 ad=46.849n pd=1.361m as=42.856n ps=1.326m w=244 l=100
X182 5v0_addh_sc_tile_2/m1_103_293# 5v0_addh_sc_tile_2/ctrl_sign VSS_3 VSS_3 nfet_06v0 ad=14.432n pd=0.504m as=0 ps=0 w=164 l=120
X183 5v0_addh_sc_tile_2/m1_103_293# 5v0_addh_sc_tile_2/ctrl_sign VDD_3V3_0 VDD_3V3_0 pfet_06v0 ad=21.472n pd=0.664m as=0 ps=0 w=244 l=100
X184 5v0_addh_sc_tile_2/5v0_half_adder_selector_sc_0/res_stage0 5v0_addh_sc_tile_2/ctrl_sign 5v0_addh_sc_tile_2/upstepper_test VSS_3 nfet_06v0 ad=0 pd=0 as=43.711n ps=1.504m w=164 l=120
X185 5v0_addh_sc_tile_2/5v0_half_adder_selector_sc_0/res_stage0 5v0_addh_sc_tile_2/ctrl_sign 5v0_addh_sc_tile_2/downstepper_test VDD_3V3_0 pfet_06v0 ad=0 pd=0 as=42.856n ps=1.326m w=244 l=100
X186 res_0 5v0_addh_sc_tile_2/a_382_n1095# 5v0_addh_sc_tile_2/5v0_half_adder_selector_sc_0/res_stage0 VSS_3 nfet_06v0 ad=17.057n pd=0.537m as=0 ps=0 w=164 l=120
X187 res_0 5v0_addh_sc_tile_2/a_382_n1095# in_3 VDD_3V3_0 pfet_06v0 ad=25.377n pd=0.697m as=21.472n ps=0.664m w=244 l=100
X188 5v0_addh_sc_tile_2/a_382_n1095# 5v0_addh_sc_tile_2/ctrl_over VSS_3 VSS_3 nfet_06v0 ad=14.432n pd=0.504m as=0 ps=0 w=164 l=120
X189 5v0_addh_sc_tile_2/a_382_n1095# 5v0_addh_sc_tile_2/ctrl_over VDD_3V3_0 VDD_3V3_0 pfet_06v0 ad=21.472n pd=0.664m as=0 ps=0 w=244 l=100
X190 res_0 5v0_addh_sc_tile_2/ctrl_over in_3 VSS_3 nfet_06v0 ad=0 pd=0 as=14.432n ps=0.504m w=164 l=120
X191 res_0 5v0_addh_sc_tile_2/ctrl_over 5v0_addh_sc_tile_2/5v0_half_adder_selector_sc_0/res_stage0 VDD_3V3_0 pfet_06v0 ad=0 pd=0 as=0 ps=0 w=244 l=100
X192 5v0_addh_sc_tile_2/inv_pti 5v0_addh_sc_tile_2/pti VSS_3 VSS_3 nfet_06v0 ad=28.864n pd=1.008m as=0 ps=0 w=164 l=120
X193 5v0_addh_sc_tile_2/inv_pti 5v0_addh_sc_tile_2/pti VDD_3V3_0 VDD_3V3_0 pfet_06v0 ad=42.944n pd=1.328m as=0 ps=0 w=244 l=100
X194 5v0_add_q_sc_0/ctrl_over 5v0_addh_sc_tile_2/a_382_n1095# 5v0_addh_sc_tile_2/m1_843_n857# VSS_3 nfet_06v0 ad=14.432n pd=0.504m as=31.488n ps=1.04m w=164 l=120
X195 5v0_add_q_sc_0/ctrl_over 5v0_addh_sc_tile_2/ctrl_over 5v0_addh_sc_tile_2/m1_843_n857# VDD_3V3_0 pfet_06v0 ad=42.944n pd=1.328m as=46.848n ps=1.36m w=244 l=100
X196 5v0_addh_sc_tile_2/inv_nti 5v0_addh_sc_tile_2/ctrl_sign 5v0_add_q_sc_0/ctrl_sign VDD_3V3_0 pfet_06v0 ad=64.416n pd=1.992m as=25.376n ps=0.696m w=244 l=100
X197 5v0_add_q_sc_0/ctrl_sign 5v0_addh_sc_tile_2/m1_103_293# 5v0_addh_sc_tile_2/inv_nti VSS_3 nfet_06v0 ad=17.056n pd=0.536m as=43.296n ps=1.512m w=164 l=120
X198 5v0_add_q_sc_0/ctrl_sign 5v0_addh_sc_tile_2/m1_103_293# 5v0_addh_sc_tile_2/inv_pti VDD_3V3_0 pfet_06v0 ad=0 pd=0 as=0 ps=0 w=244 l=100
X199 5v0_addh_sc_tile_2/inv_pti 5v0_addh_sc_tile_2/ctrl_sign 5v0_add_q_sc_0/ctrl_sign VSS_3 nfet_06v0 ad=0 pd=0 as=0 ps=0 w=164 l=120
X200 5v0_addh_sc_tile_2/inv_nti 5v0_addh_sc_tile_2/ctrl_sign 5v0_addh_sc_tile_2/m1_843_n857# VDD_3V3_0 pfet_06v0 ad=0 pd=0 as=0 ps=0 w=244 l=100
X201 5v0_addh_sc_tile_2/m1_843_n857# 5v0_addh_sc_tile_2/m1_103_293# 5v0_addh_sc_tile_2/inv_nti VSS_3 nfet_06v0 ad=0 pd=0 as=0 ps=0 w=164 l=120
X202 5v0_addh_sc_tile_2/m1_843_n857# 5v0_addh_sc_tile_2/m1_103_293# 5v0_addh_sc_tile_2/pti VDD_3V3_0 pfet_06v0 ad=0 pd=0 as=0 ps=0 w=244 l=100
X203 5v0_addh_sc_tile_2/pti 5v0_addh_sc_tile_2/ctrl_sign 5v0_addh_sc_tile_2/m1_843_n857# VSS_3 nfet_06v0 ad=0 pd=0 as=0 ps=0 w=164 l=120
X204 5v0_addh_sc_tile_2/a_n1373_n454# 5v0_addh_sc_tile_2/inv_nti 5v0_addh_sc_tile_2/downstepper_test VSS_3 nfet_06v0 ad=7.056n pd=0.39m as=0 ps=0 w=147 l=120
X205 5v0_addh_sc_tile_2/upstepper_test 5v0_addh_sc_tile_2/nti 5v0_addh_sc_tile_2/a_n1205_n937# VDD_3V3_0 pfet_06v0 ad=0 pd=0 as=11.664n ps=0.582m w=243 l=100
X206 5v0_addh_sc_tile_2/inv_nti 5v0_addh_sc_tile_2/nti VDD_3V3_0 VDD_3V3_0 pfet_06v0 ad=0 pd=0 as=0 ps=0 w=244 l=100
X207 5v0_addh_sc_tile_2/upstepper_test 5v0_addh_sc_tile_2/nti VDD_1V65_4 VSS_3 nfet_06v0 ad=0 pd=0 as=21.021n ps=0.58m w=147 l=120
X208 5v0_add_q_sc_0/ctrl_over 5v0_addh_sc_tile_2/a_382_n1095# VDD_3V3_0 VDD_3V3_0 pfet_06v0 ad=0 pd=0 as=0 ps=0 w=244 l=100
X209 5v0_addh_sc_tile_2/a_n1205_n937# 5v0_addh_sc_tile_2/inv_pti VDD_3V3_0 VDD_3V3_0 pfet_06v0 ad=0 pd=0 as=0 ps=0 w=243 l=100
X210 5v0_addh_sc_tile_2/downstepper_test 5v0_addh_sc_tile_2/pti 5v0_addh_sc_tile_2/a_n1778_n454# VSS_3 nfet_06v0 ad=0 pd=0 as=7.056n ps=0.39m w=147 l=120
X211 5v0_addh_sc_tile_2/inv_nti 5v0_addh_sc_tile_2/nti VSS_3 VSS_3 nfet_06v0 ad=0 pd=0 as=0 ps=0 w=164 l=120
X212 5v0_addh_sc_tile_2/a_n1778_n454# 5v0_addh_sc_tile_2/inv_nti VSS_3 VSS_3 nfet_06v0 ad=0 pd=0 as=0 ps=0 w=147 l=120
X213 5v0_addh_sc_tile_2/upstepper_test 5v0_addh_sc_tile_2/inv_pti VSS_3 VSS_3 nfet_06v0 ad=0 pd=0 as=0 ps=0 w=164 l=120
X214 VDD_1V65_4 5v0_addh_sc_tile_2/inv_pti 5v0_addh_sc_tile_2/a_n1373_n454# VSS_3 nfet_06v0 ad=0 pd=0 as=0 ps=0 w=147 l=120
X215 5v0_addh_sc_tile_2/downstepper_test 5v0_addh_sc_tile_2/inv_nti VDD_3V3_0 VDD_3V3_0 pfet_06v0 ad=0 pd=0 as=0 ps=0 w=243 l=100
C0 VDD_3V3_1 VDD_1V65_1 0.0427f
C1 5v0_add_q_sc_1/upstepper_test 5v0_add_q_sc_1/pti 0
C2 5v0_addh_sc_tile_1/m1_843_n857# 5v0_add_q_sc_0/upstepper_test 0.0015f
C3 in_2 5v0_addh_sc_tile_0/inv_nti 0.0153f
C4 5v0_addh_sc_tile_2/inv_pti 5v0_addh_sc_tile_2/nti 0.24025f
C5 5v0_add_q_sc_0/ctrl_over in_3 0.00136f
C6 5v0_add_q_sc_0/inv_nti 5v0_add_q_sc_0/upstepper_test 0.0011f
C7 5v0_add_q_sc_1/nti in_0_sign 0
C8 5v0_add_q_sc_0/ctrl_over 5v0_addh_sc_tile_2/ctrl_over 0.15107f
C9 5v0_add_q_sc_1/a_n1373_n454# VDD_1V65_1 0.00232f
C10 5v0_addh_sc_tile_1/nti 5v0_addh_sc_tile_2/a_382_n1095# 0
C11 in_3 5v0_addh_sc_tile_2/inv_nti 0.28245f
C12 5v0_add_q_sc_1/nti 5v0_addh_sc_tile_1/pti 0
C13 5v0_addh_sc_tile_2/ctrl_over 5v0_addh_sc_tile_2/inv_nti 0.26006f
C14 5v0_addh_sc_tile_1/a_n1373_n454# 5v0_addh_sc_tile_1/inv_pti 0.00135f
C15 5v0_addh_sc_tile_2/ctrl_sign 5v0_addh_sc_tile_2/m1_103_293# 0.61512f
C16 5v0_nter2oter_code_sc_1/nti 5v0_addh_sc_tile_1/ctrl_sign 0.13214f
C17 5v0_addh_sc_tile_2/ctrl_over 5v0_add_q_sc_0/ctrl_sign 0.2177f
C18 5v0_addh_sc_tile_1/nti int_012 0.0044f
C19 5v0_addh_sc_tile_1/ctrl_sign 5v0_nter2oter_code_sc_1/gf180mcu_fd_sc_mcu7t5v0__nor2_1_0/a_224_472# 0
C20 VDD_1V65_5 5v0_add_q_sc_0/downstepper_test 0.13024f
C21 5v0_add_q_sc_1/nti m1_n2844_n810# 0.00573f
C22 res_01 5v0_addh_sc_tile_1/5v0_half_adder_selector_sc_0/res_stage0 0.26626f
C23 5v0_nter2oter_code_sc_1/nti 5v0_addh_sc_tile_2/upstepper_test 0
C24 5v0_add_q_sc_0/inv_pti 5v0_add_q_sc_0/5v0_half_adder_selector_sc_0/m1_n239_179# 0
C25 5v0_add_q_sc_1/a_n1205_n937# 5v0_add_q_sc_1/upstepper_test 0.00334f
C26 5v0_add_q_sc_1/a_n1205_n937# 5v0_add_q_sc_1/5v0_half_adder_selector_sc_0/res_stage0 0
C27 5v0_add_q_sc_1/downstepper_test 5v0_add_q_sc_1/pti 0.08084f
C28 in_2 5v0_addh_sc_tile_0/pti 0
C29 5v0_add_q_sc_0/ctrl_over 5v0_addh_sc_tile_2/5v0_half_adder_selector_sc_0/res_stage0 0
C30 5v0_nter2oter_code_sc_1/nti VDD_3V3_0 0.31259f
C31 5v0_addh_sc_tile_0/inv_nti in_0_over 0.21462f
C32 5v0_addh_sc_tile_2/a_382_n1095# 5v0_addh_sc_tile_1/ctrl_over 0
C33 5v0_add_q_sc_0/5v0_half_adder_selector_sc_0/m1_n239_179# 5v0_addh_sc_tile_2/pti 0
C34 c_2_s 5v0_addh_sc_tile_0/carry_0_probe 0.01575f
C35 VDD_3V3_0 5v0_nter2oter_code_sc_1/gf180mcu_fd_sc_mcu7t5v0__nor2_1_0/a_224_472# 0.01644f
C36 5v0_add_q_sc_0/a_n1778_n454# 5v0_add_q_sc_0/upstepper_test 0
C37 res_0 VDD_1V65_4 0
C38 5v0_addh_sc_tile_1/downstepper_test 5v0_addh_sc_tile_2/inv_nti 0.00392f
C39 5v0_addh_sc_tile_0/inv_nti VDD_3V3_1 0.85215f
C40 int_c01 c_2_s 0.20636f
C41 5v0_addh_sc_tile_1/nti in_1 0.00579f
C42 5v0_add_q_sc_1/nti 5v0_addh_sc_tile_0/carry_sign_probe 0
C43 5v0_addh_sc_tile_2/5v0_half_adder_selector_sc_0/res_stage0 5v0_addh_sc_tile_2/inv_nti 0.02878f
C44 5v0_addh_sc_tile_0/m1_843_n857# 5v0_addh_sc_tile_0/inv_nti 0.36668f
C45 5v0_add_q_sc_0/5v0_half_adder_selector_sc_0/5v0_tgate_sel_2_sc_1/input_A VDD_3V3_0 0.02871f
C46 5v0_addh_sc_tile_2/ctrl_sign 5v0_addh_sc_tile_1/nti 0.01236f
C47 5v0_addh_sc_tile_1/ctrl_over int_012 0.27048f
C48 5v0_addh_sc_tile_1/downstepper_test 5v0_add_q_sc_0/ctrl_sign 0.00426f
C49 5v0_addh_sc_tile_1/ctrl_sign 5v0_addh_sc_tile_1/inv_pti 0.41772f
C50 in_3 5v0_nter2oter_code_sc_0/nti 0.00248f
C51 5v0_addh_sc_tile_2/ctrl_over 5v0_nter2oter_code_sc_0/nti 0.22761f
C52 VDD_1V65_5 5v0_add_q_sc_0/a_n1205_n937# 0.00354f
C53 int_carry 5v0_add_q_sc_0/5v0_half_adder_selector_sc_0/m1_n244_n517# 0.07888f
C54 5v0_addh_sc_tile_1/upstepper_test 5v0_addh_sc_tile_1/inv_pti 0.06901f
C55 5v0_addh_sc_tile_0/nti VDD_1V65_0 0.21326f
C56 5v0_add_q_sc_1/a_n1205_n937# 5v0_add_q_sc_1/downstepper_test 0.00453f
C57 in_2 res_01 0.02606f
C58 VDD_3V3_0 5v0_addh_sc_tile_1/inv_pti 0.1766f
C59 5v0_addh_sc_tile_0/pti in_0_over 0.10966f
C60 in_1 5v0_addh_sc_tile_1/ctrl_over 0
C61 5v0_addh_sc_tile_1/m1_843_n857# 5v0_add_q_sc_0/inv_pti 0
C62 5v0_add_q_sc_0/5v0_half_adder_selector_sc_0/res_stage0 5v0_addh_sc_tile_1/ctrl_over 0
C63 5v0_addh_sc_tile_2/ctrl_sign 5v0_addh_sc_tile_1/ctrl_over 0.019f
C64 5v0_addh_sc_tile_0/pti VDD_3V3_1 0.68621f
C65 5v0_nter2oter_code_sc_0/gf180mcu_fd_sc_mcu7t5v0__nor2_1_0/a_224_472# 5v0_nter2oter_code_sc_0/nti 0.00842f
C66 5v0_add_q_sc_0/inv_pti 5v0_add_q_sc_0/inv_nti 0.08256f
C67 5v0_addh_sc_tile_2/a_n1205_n937# 5v0_addh_sc_tile_2/upstepper_test 0.00334f
C68 5v0_addh_sc_tile_0/pti 5v0_addh_sc_tile_0/m1_843_n857# 0.11666f
C69 5v0_addh_sc_tile_0/inv_nti 5v0_addh_sc_tile_0/inv_pti 0.25737f
C70 c_2_o 5v0_add_q_sc_1/nti 0.00725f
C71 5v0_addh_sc_tile_1/m1_103_293# 5v0_addh_sc_tile_1/5v0_half_adder_selector_sc_0/res_stage0 0.18549f
C72 5v0_add_q_sc_0/ctrl_over 5v0_add_q_sc_0/upstepper_test 0.00167f
C73 5v0_addh_sc_tile_2/a_382_n1095# int_012 0
C74 5v0_addh_sc_tile_2/a_n1205_n937# VDD_3V3_0 0.00891f
C75 5v0_nter2oter_code_sc_0/pti 5v0_nter2oter_code_sc_0/nti 0.00234f
C76 5v0_add_q_sc_1/pti 5v0_add_q_sc_1/inv_nti 0.10916f
C77 int_carry 5v0_add_q_sc_0/a_n1373_n454# 0.00136f
C78 res_c 5v0_add_q_sc_0/5v0_half_adder_selector_sc_0/m1_n244_n517# 0.16119f
C79 5v0_add_q_sc_0/upstepper_test 5v0_add_q_sc_0/ctrl_sign 0.08746f
C80 5v0_addh_sc_tile_2/inv_pti in_2 0
C81 5v0_addh_sc_tile_1/inv_nti 5v0_addh_sc_tile_1/5v0_half_adder_selector_sc_0/res_stage0 0.02399f
C82 res_01 in_0_over 0.21152f
C83 5v0_addh_sc_tile_0/inv_nti 5v0_addh_sc_tile_1/ctrl_sign 0.02895f
C84 5v0_add_q_sc_0/downstepper_test 5v0_addh_sc_tile_1/ctrl_over 0
C85 5v0_add_q_sc_1/5v0_half_adder_selector_sc_0/5v0_tgate_sel_2_sc_1/input_A 5v0_add_q_sc_1/upstepper_test 0
C86 5v0_addh_sc_tile_0/nti 5v0_nter2oter_code_sc_0/nti 0.00244f
C87 c_2_s in_0_sign 0
C88 5v0_addh_sc_tile_0/pti 5v0_addh_sc_tile_0/inv_pti 0.44081f
C89 res_01 VDD_3V3_1 1.22329f
C90 5v0_add_q_sc_1/5v0_half_adder_selector_sc_0/5v0_tgate_sel_2_sc_1/input_A 5v0_add_q_sc_1/5v0_half_adder_selector_sc_0/res_stage0 0.00253f
C91 res_01 5v0_addh_sc_tile_0/m1_843_n857# 0
C92 in_3 VDD_1V65_4 0.01451f
C93 5v0_addh_sc_tile_2/a_n1373_n454# 5v0_addh_sc_tile_2/upstepper_test 0
C94 5v0_addh_sc_tile_1/nti 5v0_addh_sc_tile_1/a_382_n1095# 0
C95 5v0_add_q_sc_1/upstepper_test 5v0_add_q_sc_1/5v0_half_adder_selector_sc_0/res_stage0 0.27475f
C96 5v0_addh_sc_tile_2/a_382_n1095# 5v0_add_q_sc_0/5v0_half_adder_selector_sc_0/res_stage0 0.0013f
C97 5v0_addh_sc_tile_2/ctrl_over VDD_1V65_4 0.00145f
C98 5v0_addh_sc_tile_2/ctrl_sign 5v0_addh_sc_tile_2/a_382_n1095# 0.07412f
C99 5v0_addh_sc_tile_1/pti c_2_s 0.01108f
C100 in_1 int_012 0.00145f
C101 5v0_addh_sc_tile_2/a_n1373_n454# VDD_3V3_0 0.00122f
C102 5v0_add_q_sc_1/a_n1205_n937# 5v0_add_q_sc_1/inv_nti 0
C103 5v0_nter2oter_code_sc_1/pti 5v0_addh_sc_tile_2/inv_nti 0
C104 5v0_addh_sc_tile_2/ctrl_sign int_012 0.30294f
C105 c_2_s m1_n2844_n810# 0.00441f
C106 res_01 5v0_addh_sc_tile_1/a_n1373_n454# 0.00163f
C107 5v0_addh_sc_tile_0/pti 5v0_addh_sc_tile_1/ctrl_sign 0.00125f
C108 5v0_addh_sc_tile_2/downstepper_test res_0 0.00302f
C109 5v0_addh_sc_tile_1/a_382_n1095# 5v0_addh_sc_tile_1/ctrl_over 0.70472f
C110 5v0_add_q_sc_1/5v0_half_adder_selector_sc_0/5v0_tgate_sel_2_sc_1/input_A 5v0_add_q_sc_1/downstepper_test 0
C111 5v0_addh_sc_tile_2/a_n1778_n454# 5v0_addh_sc_tile_2/upstepper_test 0
C112 5v0_add_q_sc_1/upstepper_test 5v0_add_q_sc_1/downstepper_test 0.38867f
C113 5v0_addh_sc_tile_2/a_382_n1095# 5v0_add_q_sc_0/downstepper_test 0.00139f
C114 c_2_s 5v0_addh_sc_tile_0/carry_sign_probe 0.00205f
C115 5v0_addh_sc_tile_1/nti 5v0_addh_sc_tile_1/a_n1778_n454# 0.00142f
C116 5v0_addh_sc_tile_1/5v0_half_adder_selector_sc_0/5v0_tgate_sel_2_sc_1/input_A 5v0_addh_sc_tile_1/5v0_half_adder_selector_sc_0/res_stage0 0.00253f
C117 5v0_add_q_sc_1/downstepper_test 5v0_add_q_sc_1/5v0_half_adder_selector_sc_0/res_stage0 0.25483f
C118 5v0_add_q_sc_0/ctrl_over 5v0_add_q_sc_0/inv_pti 0
C119 5v0_add_q_sc_1/5v0_half_adder_selector_sc_0/m1_n244_n517# int_carry 0.16119f
C120 5v0_add_q_sc_0/ctrl_over 5v0_addh_sc_tile_2/pti 0.13176f
C121 VDD_3V3_1 5v0_addh_sc_tile_1/m1_103_293# 0.62378f
C122 5v0_addh_sc_tile_2/nti res_0 0
C123 res_01 5v0_addh_sc_tile_1/ctrl_sign 0.17378f
C124 5v0_add_q_sc_0/inv_pti 5v0_add_q_sc_0/ctrl_sign 0.00263f
C125 5v0_addh_sc_tile_2/pti 5v0_addh_sc_tile_2/inv_nti 0.42143f
C126 VDD_3V3_1 int_carry 0.20806f
C127 5v0_addh_sc_tile_1/inv_nti 5v0_addh_sc_tile_1/a_n1205_n937# 0
C128 5v0_addh_sc_tile_1/upstepper_test res_01 0.01604f
C129 res_01 5v0_addh_sc_tile_2/upstepper_test 0
C130 5v0_addh_sc_tile_1/inv_nti in_0_over 0
C131 5v0_add_q_sc_0/downstepper_test 5v0_add_q_sc_0/5v0_half_adder_selector_sc_0/res_stage0 0.25483f
C132 5v0_nter2oter_code_sc_1/nti 5v0_addh_sc_tile_1/nti 0.20212f
C133 5v0_add_q_sc_0/ctrl_sign 5v0_addh_sc_tile_2/pti 0.011f
C134 c_2_s 5v0_addh_sc_tile_1/downstepper_test 0
C135 c_2_o c_2_s 0.02923f
C136 5v0_addh_sc_tile_1/inv_pti 5v0_add_q_sc_1/pti 0
C137 5v0_addh_sc_tile_2/m1_103_293# 5v0_addh_sc_tile_1/inv_pti 0
C138 5v0_addh_sc_tile_1/inv_nti VDD_3V3_1 0.11496f
C139 5v0_add_q_sc_0/ctrl_over 5v0_add_q_sc_0/5v0_half_adder_selector_sc_0/m1_n239_179# 0.00258f
C140 5v0_addh_sc_tile_1/5v0_half_adder_selector_sc_0/res_stage0 5v0_addh_sc_tile_0/carry_0_probe 0.00121f
C141 5v0_addh_sc_tile_1/a_382_n1095# int_012 0.16245f
C142 VDD_3V3_0 res_01 0.0901f
C143 5v0_add_q_sc_1/pti VDD_1V65_1 0.00115f
C144 5v0_add_q_sc_0/inv_nti 5v0_add_q_sc_0/a_n1778_n454# 0.00214f
C145 5v0_add_q_sc_0/5v0_half_adder_selector_sc_0/m1_n239_179# 5v0_addh_sc_tile_2/inv_nti 0
C146 5v0_add_q_sc_0/5v0_half_adder_selector_sc_0/m1_n239_179# 5v0_add_q_sc_0/ctrl_sign 0.307f
C147 5v0_add_q_sc_1/upstepper_test 5v0_add_q_sc_1/inv_nti 0.0011f
C148 5v0_addh_sc_tile_2/inv_pti 5v0_addh_sc_tile_1/ctrl_sign 0.00447f
C149 in_3 5v0_addh_sc_tile_2/downstepper_test 0.18203f
C150 5v0_add_q_sc_0/nti 5v0_add_q_sc_0/5v0_half_adder_selector_sc_0/m1_n244_n517# 0
C151 5v0_nter2oter_code_sc_1/nti 5v0_addh_sc_tile_1/ctrl_over 0.2759f
C152 5v0_addh_sc_tile_2/inv_pti 5v0_addh_sc_tile_2/upstepper_test 0.07254f
C153 5v0_addh_sc_tile_2/ctrl_over 5v0_addh_sc_tile_2/downstepper_test 0.02378f
C154 5v0_addh_sc_tile_1/inv_nti 5v0_addh_sc_tile_1/a_n1373_n454# 0
C155 5v0_addh_sc_tile_1/a_382_n1095# 5v0_add_q_sc_0/5v0_half_adder_selector_sc_0/res_stage0 0.00175f
C156 5v0_addh_sc_tile_0/a_n1373_n454# in_1 0.00163f
C157 5v0_addh_sc_tile_1/ctrl_over 5v0_nter2oter_code_sc_1/gf180mcu_fd_sc_mcu7t5v0__nor2_1_0/a_224_472# 0.02885f
C158 5v0_addh_sc_tile_1/nti 5v0_addh_sc_tile_1/inv_pti 0.23171f
C159 5v0_add_q_sc_0/a_n1205_n937# 5v0_add_q_sc_0/5v0_half_adder_selector_sc_0/res_stage0 0
C160 c_2_s 5v0_addh_sc_tile_0/m1_103_293# 0
C161 5v0_addh_sc_tile_2/inv_pti VDD_3V3_0 1.08715f
C162 5v0_add_q_sc_1/a_n1205_n937# VDD_1V65_1 0.00354f
C163 int_c01 5v0_add_q_sc_1/inv_pti 0.08427f
C164 5v0_addh_sc_tile_1/ctrl_sign 5v0_addh_sc_tile_1/m1_103_293# 0.60951f
C165 5v0_add_q_sc_1/downstepper_test 5v0_addh_sc_tile_1/a_382_n1095# 0.00433f
C166 5v0_addh_sc_tile_1/upstepper_test 5v0_addh_sc_tile_1/m1_103_293# 0.07773f
C167 5v0_addh_sc_tile_1/ctrl_sign int_carry 0
C168 in_2 5v0_addh_sc_tile_0/downstepper_test 0.0129f
C169 5v0_add_q_sc_1/downstepper_test 5v0_add_q_sc_1/inv_nti 0.17947f
C170 in_0_over 5v0_addh_sc_tile_0/5v0_half_adder_selector_sc_0/res_stage0 0.09179f
C171 5v0_addh_sc_tile_2/5v0_half_adder_selector_sc_0/res_stage0 5v0_addh_sc_tile_2/downstepper_test 0.24494f
C172 in_3 5v0_addh_sc_tile_2/nti 0.52138f
C173 5v0_addh_sc_tile_1/inv_pti 5v0_addh_sc_tile_1/ctrl_over 0.0052f
C174 5v0_add_q_sc_0/nti 5v0_add_q_sc_0/a_n1373_n454# 0
C175 VDD_3V3_0 5v0_addh_sc_tile_1/m1_103_293# 0.14668f
C176 5v0_addh_sc_tile_2/ctrl_over 5v0_addh_sc_tile_2/nti 0.007f
C177 5v0_addh_sc_tile_1/inv_nti 5v0_addh_sc_tile_1/ctrl_sign 0.25029f
C178 5v0_addh_sc_tile_0/a_n1778_n454# in_1 0.00182f
C179 VDD_3V3_1 5v0_addh_sc_tile_0/5v0_half_adder_selector_sc_0/res_stage0 0.16177f
C180 5v0_addh_sc_tile_1/a_382_n1095# 5v0_add_q_sc_0/downstepper_test 0.00203f
C181 5v0_add_q_sc_0/a_n1205_n937# 5v0_add_q_sc_0/downstepper_test 0.00453f
C182 5v0_addh_sc_tile_1/upstepper_test 5v0_addh_sc_tile_1/inv_nti 0.00736f
C183 VDD_3V3_0 int_carry 1.5908f
C184 int_c01 5v0_add_q_sc_1/5v0_half_adder_selector_sc_0/m1_n244_n517# 0.07888f
C185 5v0_nter2oter_code_sc_1/nti int_012 0.00204f
C186 int_012 5v0_nter2oter_code_sc_1/gf180mcu_fd_sc_mcu7t5v0__nor2_1_0/a_224_472# 0
C187 5v0_add_q_sc_1/nti 5v0_addh_sc_tile_0/a_382_n1095# 0
C188 in_2 5v0_addh_sc_tile_0/upstepper_test 0
C189 5v0_addh_sc_tile_1/inv_nti VDD_3V3_0 0.66943f
C190 5v0_nter2oter_code_sc_0/gf180mcu_fd_sc_mcu7t5v0__nor2_1_0/a_224_472# 5v0_addh_sc_tile_2/nti 0
C191 5v0_addh_sc_tile_1/pti 5v0_addh_sc_tile_1/5v0_half_adder_selector_sc_0/res_stage0 0.01078f
C192 5v0_addh_sc_tile_2/ctrl_over 5v0_add_q_sc_0/5v0_half_adder_selector_sc_0/m1_n244_n517# 0.00443f
C193 in_0_over 5v0_addh_sc_tile_0/carry_0_probe 0.12282f
C194 5v0_add_q_sc_1/nti 5v0_add_q_sc_1/a_n1778_n454# 0
C195 5v0_addh_sc_tile_1/nti 5v0_addh_sc_tile_0/inv_nti 0
C196 VDD_3V3_1 5v0_addh_sc_tile_0/carry_0_probe 0.82134f
C197 in_0_over 5v0_addh_sc_tile_0/downstepper_test 0.02344f
C198 5v0_addh_sc_tile_2/pti VDD_1V65_4 0.00234f
C199 5v0_addh_sc_tile_0/m1_843_n857# 5v0_addh_sc_tile_0/carry_0_probe 0.18376f
C200 5v0_addh_sc_tile_2/5v0_half_adder_selector_sc_0/res_stage0 5v0_addh_sc_tile_2/nti 0.00372f
C201 5v0_add_q_sc_0/pti int_carry 0.6113f
C202 int_c01 VDD_3V3_1 1.23209f
C203 5v0_addh_sc_tile_2/nti 5v0_nter2oter_code_sc_0/pti 0
C204 VDD_1V65_3 5v0_addh_sc_tile_1/a_n1205_n937# 0.00354f
C205 5v0_addh_sc_tile_0/inv_pti 5v0_addh_sc_tile_0/5v0_half_adder_selector_sc_0/res_stage0 0.01365f
C206 VDD_3V3_1 5v0_addh_sc_tile_0/downstepper_test 0.51279f
C207 5v0_addh_sc_tile_2/a_382_n1095# 5v0_addh_sc_tile_1/inv_pti 0
C208 5v0_nter2oter_code_sc_1/nti in_1 0
C209 5v0_addh_sc_tile_2/ctrl_sign 5v0_nter2oter_code_sc_1/nti 0.01527f
C210 5v0_addh_sc_tile_2/ctrl_sign 5v0_nter2oter_code_sc_1/gf180mcu_fd_sc_mcu7t5v0__nor2_1_0/a_224_472# 0.00629f
C211 VDD_3V3_0 res_c 0.09697f
C212 5v0_addh_sc_tile_1/inv_pti int_012 0.00119f
C213 int_c01 5v0_add_q_sc_1/a_n1373_n454# 0.00136f
C214 5v0_addh_sc_tile_1/ctrl_sign 5v0_addh_sc_tile_1/5v0_half_adder_selector_sc_0/5v0_tgate_sel_2_sc_1/input_A 0
C215 5v0_add_q_sc_0/5v0_half_adder_selector_sc_0/5v0_tgate_sel_2_sc_1/input_A 5v0_add_q_sc_0/5v0_half_adder_selector_sc_0/res_stage0 0.00253f
C216 5v0_addh_sc_tile_0/inv_nti 5v0_addh_sc_tile_1/ctrl_over 0
C217 in_0_over 5v0_addh_sc_tile_0/upstepper_test 0.00168f
C218 5v0_addh_sc_tile_1/nti 5v0_addh_sc_tile_0/pti 0
C219 5v0_addh_sc_tile_1/upstepper_test 5v0_addh_sc_tile_1/5v0_half_adder_selector_sc_0/5v0_tgate_sel_2_sc_1/input_A 0
C220 5v0_add_q_sc_1/upstepper_test VDD_1V65_1 0.16859f
C221 5v0_addh_sc_tile_2/ctrl_over 5v0_addh_sc_tile_1/5v0_half_adder_selector_sc_0/res_stage0 0.00478f
C222 res_01 5v0_addh_sc_tile_2/m1_103_293# 0
C223 5v0_addh_sc_tile_0/inv_pti 5v0_addh_sc_tile_0/carry_0_probe 0.01451f
C224 VDD_3V3_1 5v0_addh_sc_tile_0/upstepper_test 0.45677f
C225 5v0_addh_sc_tile_1/ctrl_sign 5v0_addh_sc_tile_0/5v0_half_adder_selector_sc_0/res_stage0 0.00758f
C226 int_c01 5v0_addh_sc_tile_0/inv_pti 0.00639f
C227 VDD_1V65_3 5v0_addh_sc_tile_1/a_n1373_n454# 0.00232f
C228 VDD_3V3_0 5v0_addh_sc_tile_1/5v0_half_adder_selector_sc_0/5v0_tgate_sel_2_sc_1/input_A 0.02871f
C229 5v0_addh_sc_tile_0/inv_pti 5v0_addh_sc_tile_0/downstepper_test 0.14186f
C230 5v0_addh_sc_tile_2/ctrl_sign 5v0_addh_sc_tile_1/inv_pti 0
C231 5v0_add_q_sc_0/ctrl_over 5v0_addh_sc_tile_2/inv_nti 0.01761f
C232 5v0_nter2oter_code_sc_1/pti 5v0_addh_sc_tile_2/downstepper_test 0
C233 5v0_add_q_sc_0/5v0_half_adder_selector_sc_0/5v0_tgate_sel_2_sc_1/input_A 5v0_add_q_sc_0/downstepper_test 0
C234 5v0_add_q_sc_0/ctrl_over 5v0_add_q_sc_0/ctrl_sign 0.02618f
C235 5v0_addh_sc_tile_1/downstepper_test 5v0_addh_sc_tile_1/5v0_half_adder_selector_sc_0/res_stage0 0.25483f
C236 c_2_o 5v0_addh_sc_tile_1/5v0_half_adder_selector_sc_0/res_stage0 0
C237 5v0_add_q_sc_1/downstepper_test 5v0_addh_sc_tile_1/inv_pti 0.00756f
C238 5v0_addh_sc_tile_1/ctrl_sign 5v0_addh_sc_tile_0/carry_0_probe 0.02297f
C239 5v0_addh_sc_tile_1/nti res_01 0.54752f
C240 in_0_sign in_0_over 0.05861f
C241 5v0_add_q_sc_0/ctrl_sign 5v0_addh_sc_tile_2/inv_nti 0.12058f
C242 int_c01 5v0_addh_sc_tile_1/ctrl_sign 0
C243 5v0_addh_sc_tile_2/inv_pti 5v0_addh_sc_tile_2/m1_103_293# 0.17639f
C244 5v0_add_q_sc_1/downstepper_test VDD_1V65_1 0.13024f
C245 5v0_addh_sc_tile_0/inv_pti 5v0_addh_sc_tile_0/upstepper_test 0.07282f
C246 5v0_addh_sc_tile_1/upstepper_test 5v0_addh_sc_tile_0/carry_0_probe 0.02787f
C247 5v0_addh_sc_tile_1/ctrl_sign 5v0_addh_sc_tile_0/downstepper_test 0.02017f
C248 VDD_3V3_1 in_0_sign 0.65887f
C249 5v0_addh_sc_tile_0/m1_843_n857# in_0_sign 0.24363f
C250 VDD_1V65_5 int_carry 0.03394f
C251 in_2 5v0_addh_sc_tile_2/ctrl_over 0
C252 5v0_addh_sc_tile_1/pti in_0_over 0.00417f
C253 5v0_addh_sc_tile_0/inv_nti int_012 0.00631f
C254 5v0_addh_sc_tile_1/pti VDD_3V3_1 0.57114f
C255 5v0_addh_sc_tile_1/pti 5v0_addh_sc_tile_0/m1_843_n857# 0
C256 VDD_3V3_0 5v0_addh_sc_tile_0/carry_0_probe 0
C257 5v0_addh_sc_tile_1/upstepper_test VDD_1V65_3 0.16859f
C258 5v0_nter2oter_code_sc_1/pti 5v0_addh_sc_tile_2/nti 0
C259 in_0_over m1_n2844_n810# 0.00329f
C260 VDD_3V3_0 5v0_addh_sc_tile_0/downstepper_test 0
C261 VDD_3V3_1 m1_n2844_n810# 0.14825f
C262 5v0_addh_sc_tile_0/m1_843_n857# m1_n2844_n810# 0.00191f
C263 res_01 5v0_addh_sc_tile_1/ctrl_over 0.25947f
C264 5v0_addh_sc_tile_0/a_382_n1095# c_2_s 0
C265 VDD_1V65_3 VDD_3V3_0 0.04264f
C266 5v0_add_q_sc_1/inv_pti c_2_o 0.0024f
C267 5v0_addh_sc_tile_1/ctrl_sign 5v0_addh_sc_tile_0/upstepper_test 0
C268 5v0_addh_sc_tile_2/inv_pti 5v0_addh_sc_tile_1/nti 0
C269 in_1 5v0_addh_sc_tile_0/inv_nti 0.28245f
C270 5v0_add_q_sc_1/a_n1778_n454# c_2_s 0
C271 5v0_addh_sc_tile_2/ctrl_sign 5v0_addh_sc_tile_0/inv_nti 0
C272 5v0_addh_sc_tile_2/downstepper_test 5v0_addh_sc_tile_2/pti 0.20149f
C273 VDD_3V3_0 5v0_addh_sc_tile_2/m1_843_n857# 0.17677f
C274 in_0_over 5v0_addh_sc_tile_0/carry_sign_probe 0.00413f
C275 5v0_addh_sc_tile_0/inv_pti in_0_sign 0.23041f
C276 in_2 5v0_nter2oter_code_sc_0/pti 0.00216f
C277 5v0_addh_sc_tile_1/pti 5v0_addh_sc_tile_1/a_n1373_n454# 0
C278 5v0_add_q_sc_0/upstepper_test 5v0_add_q_sc_0/a_n1373_n454# 0
C279 5v0_addh_sc_tile_1/inv_nti 5v0_addh_sc_tile_2/m1_103_293# 0.00513f
C280 5v0_addh_sc_tile_1/inv_nti 5v0_add_q_sc_1/pti 0
C281 5v0_addh_sc_tile_1/m1_843_n857# c_2_s 0.0069f
C282 5v0_addh_sc_tile_1/a_382_n1095# 5v0_addh_sc_tile_1/inv_pti 0.00129f
C283 VDD_3V3_1 5v0_addh_sc_tile_0/carry_sign_probe 0.17781f
C284 5v0_addh_sc_tile_0/m1_843_n857# 5v0_addh_sc_tile_0/carry_sign_probe 0.00703f
C285 5v0_addh_sc_tile_1/a_382_n1095# VDD_1V65_1 0
C286 5v0_addh_sc_tile_2/ctrl_over VDD_3V3_1 0.00186f
C287 5v0_addh_sc_tile_1/ctrl_sign 5v0_add_q_sc_0/nti 0
C288 5v0_addh_sc_tile_1/inv_pti 5v0_add_q_sc_1/inv_nti 0.00455f
C289 VDD_3V3_0 res_0 0.09575f
C290 5v0_add_q_sc_1/inv_nti VDD_1V65_1 0.01114f
C291 5v0_addh_sc_tile_2/inv_pti 5v0_addh_sc_tile_1/ctrl_over 0.00359f
C292 5v0_addh_sc_tile_0/inv_pti m1_n2844_n810# 0.00753f
C293 in_2 5v0_addh_sc_tile_0/nti 0.0018f
C294 c_2_s 5v0_add_q_sc_1/5v0_half_adder_selector_sc_0/m1_n239_179# 0.30422f
C295 5v0_add_q_sc_1/5v0_half_adder_selector_sc_0/m1_n244_n517# c_2_o 0.34508f
C296 5v0_addh_sc_tile_2/a_382_n1095# res_01 0
C297 in_1 5v0_addh_sc_tile_0/pti 0.66373f
C298 in_0_sign 5v0_addh_sc_tile_1/ctrl_sign 0
C299 5v0_addh_sc_tile_0/a_n1205_n937# 5v0_addh_sc_tile_0/inv_nti 0
C300 5v0_addh_sc_tile_2/nti 5v0_addh_sc_tile_2/pti 0.24563f
C301 VDD_3V3_0 5v0_add_q_sc_0/nti 0.63773f
C302 5v0_addh_sc_tile_1/a_n1205_n937# 5v0_addh_sc_tile_1/downstepper_test 0.00453f
C303 in_0_over 5v0_addh_sc_tile_1/downstepper_test 0
C304 5v0_addh_sc_tile_1/inv_nti 5v0_addh_sc_tile_1/nti 0.22702f
C305 5v0_addh_sc_tile_1/pti 5v0_addh_sc_tile_1/ctrl_sign 0.48393f
C306 res_01 int_012 0.17192f
C307 VDD_3V3_1 5v0_addh_sc_tile_1/downstepper_test 0.09186f
C308 5v0_addh_sc_tile_0/inv_pti 5v0_addh_sc_tile_0/carry_sign_probe 0.17523f
C309 c_2_o VDD_3V3_1 0.6465f
C310 5v0_addh_sc_tile_0/m1_843_n857# 5v0_addh_sc_tile_1/downstepper_test 0
C311 5v0_addh_sc_tile_1/upstepper_test 5v0_addh_sc_tile_1/pti 0.02161f
C312 5v0_addh_sc_tile_1/m1_103_293# 5v0_addh_sc_tile_1/ctrl_over 0.02786f
C313 VDD_3V3_1 5v0_nter2oter_code_sc_0/pti 0.29053f
C314 VDD_3V3_0 in_0_sign 0
C315 5v0_addh_sc_tile_1/ctrl_sign m1_n2844_n810# 0.00105f
C316 5v0_addh_sc_tile_0/5v0_half_adder_selector_sc_0/5v0_tgate_sel_2_sc_1/input_A in_0_over 0.04656f
C317 5v0_nter2oter_code_sc_1/nti 5v0_nter2oter_code_sc_1/gf180mcu_fd_sc_mcu7t5v0__nor2_1_0/a_224_472# 0.00898f
C318 5v0_addh_sc_tile_2/pti 5v0_add_q_sc_0/5v0_half_adder_selector_sc_0/m1_n244_n517# 0.00139f
C319 5v0_add_q_sc_0/pti 5v0_add_q_sc_0/nti 0.1782f
C320 5v0_addh_sc_tile_1/ctrl_over int_carry 0.01695f
C321 5v0_addh_sc_tile_2/inv_nti VDD_1V65_4 0.08611f
C322 5v0_addh_sc_tile_1/pti VDD_3V3_0 0.08682f
C323 5v0_addh_sc_tile_1/upstepper_test m1_n2844_n810# 0.00447f
C324 5v0_addh_sc_tile_0/5v0_half_adder_selector_sc_0/5v0_tgate_sel_2_sc_1/input_A VDD_3V3_1 0.02871f
C325 5v0_addh_sc_tile_0/nti in_0_over 0.00162f
C326 5v0_addh_sc_tile_2/inv_pti 5v0_addh_sc_tile_2/a_382_n1095# 0.00129f
C327 in_1 res_01 0.18462f
C328 5v0_addh_sc_tile_0/a_n1373_n454# 5v0_addh_sc_tile_0/inv_nti 0
C329 5v0_addh_sc_tile_2/ctrl_sign res_01 0
C330 5v0_addh_sc_tile_1/inv_nti 5v0_addh_sc_tile_1/ctrl_over 0.47006f
C331 5v0_addh_sc_tile_0/nti VDD_3V3_1 0.74269f
C332 5v0_addh_sc_tile_1/a_n1373_n454# 5v0_addh_sc_tile_1/downstepper_test 0.00442f
C333 5v0_addh_sc_tile_2/inv_pti int_012 0.00498f
C334 in_3 5v0_addh_sc_tile_1/ctrl_sign 0
C335 5v0_addh_sc_tile_0/inv_nti 5v0_add_q_sc_1/inv_nti 0
C336 5v0_add_q_sc_0/5v0_half_adder_selector_sc_0/m1_n239_179# 5v0_add_q_sc_0/5v0_half_adder_selector_sc_0/m1_n244_n517# 0.00585f
C337 5v0_addh_sc_tile_2/ctrl_over 5v0_addh_sc_tile_1/ctrl_sign 0
C338 5v0_addh_sc_tile_0/m1_103_293# in_0_over 0.02633f
C339 5v0_addh_sc_tile_1/upstepper_test 5v0_addh_sc_tile_0/carry_sign_probe 0
C340 5v0_add_q_sc_0/inv_pti 5v0_add_q_sc_0/a_n1373_n454# 0.00135f
C341 in_3 5v0_addh_sc_tile_2/upstepper_test 0.01604f
C342 in_2 5v0_nter2oter_code_sc_1/pti 0.46231f
C343 5v0_addh_sc_tile_1/upstepper_test 5v0_addh_sc_tile_2/ctrl_over 0
C344 5v0_addh_sc_tile_2/ctrl_over 5v0_addh_sc_tile_2/upstepper_test 0.16997f
C345 VDD_3V3_1 5v0_addh_sc_tile_0/m1_103_293# 0.73472f
C346 5v0_addh_sc_tile_0/m1_843_n857# 5v0_addh_sc_tile_0/m1_103_293# 0.20659f
C347 5v0_add_q_sc_0/upstepper_test VDD_3V3_1 0
C348 5v0_addh_sc_tile_1/ctrl_over res_c 0
C349 in_3 VDD_3V3_0 1.10285f
C350 VDD_3V3_0 5v0_addh_sc_tile_2/ctrl_over 2.0131f
C351 5v0_addh_sc_tile_2/a_382_n1095# int_carry 0.0013f
C352 5v0_add_q_sc_1/pti 5v0_addh_sc_tile_0/carry_0_probe 0
C353 5v0_addh_sc_tile_0/a_n1373_n454# 5v0_addh_sc_tile_0/pti 0
C354 5v0_addh_sc_tile_2/inv_pti 5v0_addh_sc_tile_2/ctrl_sign 0.28426f
C355 5v0_addh_sc_tile_0/a_n1778_n454# 5v0_addh_sc_tile_0/inv_nti 0.00226f
C356 int_c01 5v0_add_q_sc_1/pti 0.54174f
C357 5v0_addh_sc_tile_0/nti 5v0_addh_sc_tile_0/inv_pti 0.24025f
C358 5v0_addh_sc_tile_1/ctrl_sign 5v0_addh_sc_tile_1/downstepper_test 0.20144f
C359 5v0_addh_sc_tile_0/pti 5v0_add_q_sc_1/inv_nti 0.00104f
C360 c_2_o 5v0_addh_sc_tile_1/ctrl_sign 0.01552f
C361 5v0_nter2oter_code_sc_0/pti 5v0_addh_sc_tile_1/ctrl_sign 0.00632f
C362 5v0_add_q_sc_1/upstepper_test int_carry 0
C363 5v0_addh_sc_tile_1/upstepper_test 5v0_addh_sc_tile_1/downstepper_test 0.38867f
C364 5v0_nter2oter_code_sc_0/gf180mcu_fd_sc_mcu7t5v0__nor2_1_0/a_224_472# VDD_3V3_0 0.01413f
C365 5v0_addh_sc_tile_2/5v0_half_adder_selector_sc_0/res_stage0 5v0_addh_sc_tile_2/upstepper_test 0.27475f
C366 5v0_addh_sc_tile_1/5v0_half_adder_selector_sc_0/5v0_tgate_sel_2_sc_1/input_A 5v0_addh_sc_tile_1/ctrl_over 0.04656f
C367 5v0_add_q_sc_1/5v0_half_adder_selector_sc_0/res_stage0 int_carry 0.17113f
C368 5v0_addh_sc_tile_1/inv_nti int_012 0.01488f
C369 5v0_addh_sc_tile_0/inv_pti 5v0_addh_sc_tile_0/m1_103_293# 0.17653f
C370 5v0_addh_sc_tile_2/m1_103_293# 5v0_addh_sc_tile_2/m1_843_n857# 0.20659f
C371 VDD_3V3_0 5v0_addh_sc_tile_1/downstepper_test 0.41827f
C372 5v0_addh_sc_tile_2/5v0_half_adder_selector_sc_0/res_stage0 VDD_3V3_0 0.16541f
C373 c_2_o VDD_3V3_0 0.33124f
C374 5v0_nter2oter_code_sc_1/pti VDD_3V3_1 0.29062f
C375 VDD_1V65_5 5v0_add_q_sc_0/nti 0.21326f
C376 VDD_3V3_0 5v0_nter2oter_code_sc_0/pti 0.17187f
C377 5v0_addh_sc_tile_1/nti 5v0_addh_sc_tile_0/carry_0_probe 0.013f
C378 5v0_addh_sc_tile_1/ctrl_over 5v0_addh_sc_tile_0/5v0_half_adder_selector_sc_0/res_stage0 0
C379 5v0_addh_sc_tile_0/nti 5v0_addh_sc_tile_1/ctrl_sign 0
C380 5v0_addh_sc_tile_1/a_382_n1095# res_01 0.09307f
C381 5v0_addh_sc_tile_0/a_n1778_n454# 5v0_addh_sc_tile_0/pti 0.00135f
C382 5v0_add_q_sc_0/5v0_half_adder_selector_sc_0/res_stage0 int_carry 0.27792f
C383 5v0_addh_sc_tile_2/ctrl_sign int_carry 0
C384 in_2 5v0_addh_sc_tile_2/pti 0
C385 int_c01 5v0_add_q_sc_1/a_n1205_n937# 0
C386 5v0_add_q_sc_1/nti c_2_s 0.2845f
C387 5v0_nter2oter_code_sc_1/nti 5v0_addh_sc_tile_0/inv_nti 0.00216f
C388 VDD_1V65_3 5v0_addh_sc_tile_1/nti 0.21326f
C389 5v0_addh_sc_tile_2/ctrl_sign 5v0_addh_sc_tile_1/inv_nti 0.00386f
C390 5v0_addh_sc_tile_0/a_382_n1095# 5v0_addh_sc_tile_1/5v0_half_adder_selector_sc_0/res_stage0 0
C391 5v0_addh_sc_tile_2/ctrl_over 5v0_addh_sc_tile_2/5v0_half_adder_selector_sc_0/5v0_tgate_sel_2_sc_1/input_A 0.04656f
C392 c_2_o 5v0_add_q_sc_0/pti 0.00513f
C393 5v0_addh_sc_tile_0/m1_103_293# 5v0_addh_sc_tile_1/ctrl_sign 0.00101f
C394 5v0_addh_sc_tile_0/nti VDD_3V3_0 0
C395 5v0_add_q_sc_1/downstepper_test int_carry 0.00477f
C396 5v0_add_q_sc_0/upstepper_test 5v0_addh_sc_tile_1/ctrl_sign 0
C397 5v0_addh_sc_tile_1/ctrl_over 5v0_addh_sc_tile_0/carry_0_probe 0
C398 5v0_add_q_sc_0/downstepper_test 5v0_addh_sc_tile_1/m1_103_293# 0
C399 5v0_addh_sc_tile_0/pti VDD_1V65_2 0
C400 5v0_addh_sc_tile_2/downstepper_test 5v0_addh_sc_tile_2/inv_nti 0.29987f
C401 5v0_add_q_sc_0/inv_nti 5v0_add_q_sc_0/a_n1373_n454# 0
C402 5v0_addh_sc_tile_1/inv_nti 5v0_add_q_sc_1/downstepper_test 0.00441f
C403 5v0_nter2oter_code_sc_1/pti 5v0_addh_sc_tile_0/inv_pti 0
C404 5v0_addh_sc_tile_1/ctrl_over 5v0_addh_sc_tile_0/downstepper_test 0
C405 5v0_addh_sc_tile_2/downstepper_test 5v0_add_q_sc_0/ctrl_sign 0
C406 VDD_1V65_3 5v0_addh_sc_tile_1/ctrl_over 0.02438f
C407 5v0_add_q_sc_0/downstepper_test int_carry 0.17146f
C408 5v0_add_q_sc_0/5v0_half_adder_selector_sc_0/res_stage0 res_c 0.08533f
C409 5v0_addh_sc_tile_1/nti res_0 0
C410 5v0_addh_sc_tile_0/inv_nti 5v0_addh_sc_tile_1/inv_pti 0
C411 res_01 5v0_addh_sc_tile_1/a_n1778_n454# 0.00182f
C412 VDD_3V3_0 5v0_add_q_sc_0/upstepper_test 0.55779f
C413 5v0_addh_sc_tile_1/inv_nti 5v0_add_q_sc_0/downstepper_test 0
C414 5v0_addh_sc_tile_1/pti 5v0_addh_sc_tile_2/m1_103_293# 0
C415 5v0_addh_sc_tile_1/pti 5v0_add_q_sc_1/pti 0
C416 5v0_addh_sc_tile_2/5v0_half_adder_selector_sc_0/res_stage0 5v0_addh_sc_tile_2/5v0_half_adder_selector_sc_0/5v0_tgate_sel_2_sc_1/input_A 0.00253f
C417 5v0_add_q_sc_0/ctrl_over 5v0_addh_sc_tile_2/nti 0
C418 VDD_1V65_5 5v0_addh_sc_tile_2/ctrl_over 0
C419 5v0_nter2oter_code_sc_1/pti 5v0_addh_sc_tile_1/ctrl_sign 0.28956f
C420 5v0_addh_sc_tile_1/ctrl_over 5v0_addh_sc_tile_0/upstepper_test 0
C421 5v0_addh_sc_tile_1/a_382_n1095# 5v0_addh_sc_tile_1/m1_103_293# 0.07764f
C422 5v0_add_q_sc_1/inv_pti 5v0_addh_sc_tile_1/m1_843_n857# 0
C423 5v0_addh_sc_tile_2/nti 5v0_addh_sc_tile_2/inv_nti 0.22786f
C424 5v0_add_q_sc_0/pti 5v0_add_q_sc_0/upstepper_test 0
C425 5v0_addh_sc_tile_1/m1_103_293# 5v0_add_q_sc_1/inv_nti 0.00334f
C426 5v0_addh_sc_tile_1/nti in_0_sign 0
C427 5v0_addh_sc_tile_1/a_382_n1095# int_carry 0.00603f
C428 5v0_add_q_sc_0/downstepper_test res_c 0.00302f
C429 5v0_addh_sc_tile_0/pti 5v0_addh_sc_tile_1/inv_pti 0.00107f
C430 in_1 5v0_addh_sc_tile_0/5v0_half_adder_selector_sc_0/res_stage0 0.2646f
C431 5v0_nter2oter_code_sc_1/nti res_01 0.01204f
C432 5v0_add_q_sc_0/a_n1205_n937# int_carry 0
C433 5v0_add_q_sc_0/ctrl_over 5v0_add_q_sc_0/5v0_half_adder_selector_sc_0/m1_n244_n517# 0.34138f
C434 5v0_addh_sc_tile_0/carry_sign_probe 5v0_add_q_sc_1/pti 0
C435 5v0_addh_sc_tile_1/pti 5v0_addh_sc_tile_1/nti 0.24193f
C436 VDD_3V3_0 5v0_nter2oter_code_sc_1/pti 0.19634f
C437 5v0_addh_sc_tile_1/inv_nti 5v0_addh_sc_tile_1/a_382_n1095# 0.28394f
C438 5v0_add_q_sc_1/inv_pti 5v0_add_q_sc_1/5v0_half_adder_selector_sc_0/m1_n239_179# 0
C439 in_3 5v0_addh_sc_tile_2/m1_103_293# 0
C440 5v0_addh_sc_tile_1/ctrl_over 5v0_add_q_sc_0/nti 0
C441 5v0_addh_sc_tile_2/inv_nti 5v0_add_q_sc_0/5v0_half_adder_selector_sc_0/m1_n244_n517# 0
C442 5v0_addh_sc_tile_2/ctrl_over 5v0_addh_sc_tile_2/m1_103_293# 0.05856f
C443 5v0_addh_sc_tile_1/inv_nti 5v0_add_q_sc_1/inv_nti 0
C444 int_c01 5v0_add_q_sc_1/upstepper_test 0.02545f
C445 5v0_addh_sc_tile_2/a_382_n1095# 5v0_addh_sc_tile_2/m1_843_n857# 0.05013f
C446 int_c01 5v0_add_q_sc_1/5v0_half_adder_selector_sc_0/res_stage0 0.27251f
C447 5v0_add_q_sc_0/ctrl_sign 5v0_add_q_sc_0/5v0_half_adder_selector_sc_0/m1_n244_n517# 0
C448 5v0_addh_sc_tile_0/a_382_n1095# in_0_over 0.63576f
C449 5v0_add_q_sc_0/inv_pti 5v0_addh_sc_tile_1/ctrl_sign 0
C450 5v0_addh_sc_tile_0/a_382_n1095# VDD_3V3_1 0.63349f
C451 in_1 5v0_addh_sc_tile_0/carry_0_probe 0.00136f
C452 5v0_addh_sc_tile_0/a_382_n1095# 5v0_addh_sc_tile_0/m1_843_n857# 0.05013f
C453 5v0_addh_sc_tile_2/nti 5v0_nter2oter_code_sc_0/nti 0.00237f
C454 5v0_addh_sc_tile_1/pti 5v0_addh_sc_tile_1/ctrl_over 0.11567f
C455 5v0_addh_sc_tile_2/a_382_n1095# res_0 0.16245f
C456 res_01 5v0_addh_sc_tile_1/inv_pti 0.05503f
C457 5v0_addh_sc_tile_0/a_n1205_n937# 5v0_addh_sc_tile_0/5v0_half_adder_selector_sc_0/res_stage0 0
C458 in_1 5v0_addh_sc_tile_0/downstepper_test 0.18203f
C459 5v0_addh_sc_tile_2/inv_pti 5v0_nter2oter_code_sc_1/nti 0
C460 5v0_addh_sc_tile_1/ctrl_sign 5v0_addh_sc_tile_2/pti 0.00148f
C461 5v0_addh_sc_tile_2/m1_103_293# 5v0_addh_sc_tile_1/downstepper_test 0.00921f
C462 5v0_addh_sc_tile_2/inv_pti 5v0_nter2oter_code_sc_1/gf180mcu_fd_sc_mcu7t5v0__nor2_1_0/a_224_472# 0
C463 c_2_o 5v0_add_q_sc_1/pti 0
C464 5v0_add_q_sc_1/5v0_half_adder_selector_sc_0/m1_n244_n517# 5v0_add_q_sc_1/5v0_half_adder_selector_sc_0/m1_n239_179# 0.00585f
C465 5v0_addh_sc_tile_2/ctrl_sign VDD_1V65_3 0
C466 5v0_addh_sc_tile_1/nti 5v0_addh_sc_tile_2/ctrl_over 0.00207f
C467 5v0_addh_sc_tile_2/5v0_half_adder_selector_sc_0/res_stage0 5v0_addh_sc_tile_2/m1_103_293# 0.18487f
C468 5v0_addh_sc_tile_1/m1_843_n857# VDD_3V3_1 0.00388f
C469 5v0_addh_sc_tile_1/inv_nti 5v0_addh_sc_tile_1/a_n1778_n454# 0.00226f
C470 5v0_add_q_sc_0/inv_pti VDD_3V3_0 0.40694f
C471 5v0_addh_sc_tile_1/m1_103_293# VDD_1V65_2 0
C472 5v0_addh_sc_tile_2/upstepper_test 5v0_addh_sc_tile_2/pti 0.02426f
C473 5v0_addh_sc_tile_2/a_382_n1095# 5v0_add_q_sc_0/nti 0
C474 int_c01 5v0_add_q_sc_1/downstepper_test 0.16195f
C475 5v0_addh_sc_tile_2/ctrl_sign 5v0_addh_sc_tile_2/m1_843_n857# 0.24363f
C476 5v0_addh_sc_tile_1/5v0_half_adder_selector_sc_0/res_stage0 5v0_add_q_sc_0/ctrl_sign 0
C477 VDD_3V3_0 5v0_addh_sc_tile_2/pti 0.713f
C478 5v0_addh_sc_tile_1/a_382_n1095# 5v0_addh_sc_tile_1/5v0_half_adder_selector_sc_0/5v0_tgate_sel_2_sc_1/input_A 0.02928f
C479 5v0_add_q_sc_0/5v0_half_adder_selector_sc_0/m1_n239_179# 5v0_addh_sc_tile_1/ctrl_sign 0
C480 5v0_addh_sc_tile_2/downstepper_test VDD_1V65_4 0.13024f
C481 5v0_addh_sc_tile_0/pti 5v0_addh_sc_tile_0/inv_nti 0.4209f
C482 VDD_3V3_1 5v0_add_q_sc_1/5v0_half_adder_selector_sc_0/m1_n239_179# 0.29031f
C483 VDD_1V65_5 5v0_add_q_sc_0/upstepper_test 0.16859f
C484 5v0_addh_sc_tile_0/a_382_n1095# 5v0_addh_sc_tile_0/inv_pti 0.00129f
C485 in_1 5v0_addh_sc_tile_0/upstepper_test 0.01604f
C486 5v0_add_q_sc_0/pti 5v0_add_q_sc_0/inv_pti 0.19726f
C487 5v0_addh_sc_tile_2/inv_pti 5v0_addh_sc_tile_1/inv_pti 0
C488 5v0_addh_sc_tile_2/ctrl_over 5v0_addh_sc_tile_1/ctrl_over 0.02247f
C489 5v0_addh_sc_tile_0/a_n1205_n937# 5v0_addh_sc_tile_0/downstepper_test 0.00453f
C490 5v0_addh_sc_tile_1/nti 5v0_addh_sc_tile_1/downstepper_test 0.06935f
C491 5v0_addh_sc_tile_2/5v0_half_adder_selector_sc_0/res_stage0 5v0_addh_sc_tile_1/nti 0
C492 c_2_o 5v0_addh_sc_tile_1/nti 0
C493 5v0_add_q_sc_1/a_n1205_n937# c_2_o 0
C494 VDD_3V3_0 5v0_add_q_sc_0/5v0_half_adder_selector_sc_0/m1_n239_179# 0.30519f
C495 5v0_nter2oter_code_sc_1/nti 5v0_addh_sc_tile_1/inv_nti 0.00264f
C496 5v0_addh_sc_tile_1/pti int_012 0
C497 5v0_add_q_sc_0/5v0_half_adder_selector_sc_0/res_stage0 5v0_add_q_sc_0/nti 0.00372f
C498 in_2 VDD_1V65_0 0
C499 5v0_nter2oter_code_sc_0/gf180mcu_fd_sc_mcu7t5v0__nor2_1_0/a_224_472# 5v0_addh_sc_tile_1/ctrl_over 0
C500 5v0_addh_sc_tile_0/a_382_n1095# 5v0_addh_sc_tile_1/ctrl_sign 0.01186f
C501 res_01 5v0_addh_sc_tile_0/inv_nti 0.0179f
C502 5v0_addh_sc_tile_2/nti VDD_1V65_4 0.21326f
C503 5v0_addh_sc_tile_1/inv_pti 5v0_addh_sc_tile_1/m1_103_293# 0.17653f
C504 5v0_addh_sc_tile_1/a_382_n1095# 5v0_addh_sc_tile_0/carry_0_probe 0
C505 5v0_addh_sc_tile_0/a_n1205_n937# 5v0_addh_sc_tile_0/upstepper_test 0.00334f
C506 5v0_addh_sc_tile_1/upstepper_test 5v0_addh_sc_tile_0/a_382_n1095# 0.00208f
C507 in_1 in_0_sign 0
C508 c_2_o 5v0_addh_sc_tile_1/ctrl_over 0.12383f
C509 5v0_addh_sc_tile_1/downstepper_test 5v0_addh_sc_tile_1/ctrl_over 0.16058f
C510 5v0_addh_sc_tile_1/inv_pti int_carry 0.00157f
C511 5v0_nter2oter_code_sc_0/pti 5v0_addh_sc_tile_1/ctrl_over 0.00235f
C512 5v0_addh_sc_tile_0/carry_0_probe 5v0_add_q_sc_1/inv_nti 0.00204f
C513 5v0_addh_sc_tile_0/a_n1373_n454# 5v0_addh_sc_tile_0/downstepper_test 0.00442f
C514 5v0_addh_sc_tile_1/m1_843_n857# 5v0_addh_sc_tile_1/ctrl_sign 0.24363f
C515 VDD_3V3_0 5v0_addh_sc_tile_0/a_382_n1095# 0
C516 in_3 5v0_addh_sc_tile_2/a_382_n1095# 0.09307f
C517 int_c01 5v0_add_q_sc_1/inv_nti 0.02537f
C518 5v0_addh_sc_tile_2/ctrl_sign 5v0_addh_sc_tile_1/pti 0
C519 5v0_addh_sc_tile_2/a_382_n1095# 5v0_addh_sc_tile_2/ctrl_over 0.69037f
C520 5v0_addh_sc_tile_1/inv_nti 5v0_addh_sc_tile_1/inv_pti 0.26136f
C521 5v0_addh_sc_tile_1/nti 5v0_addh_sc_tile_0/m1_103_293# 0
C522 in_3 int_012 0.01005f
C523 5v0_add_q_sc_1/inv_pti 5v0_add_q_sc_1/nti 0.21255f
C524 5v0_addh_sc_tile_2/ctrl_over int_012 1.76395f
C525 5v0_add_q_sc_0/downstepper_test 5v0_add_q_sc_0/nti 0.07205f
C526 5v0_addh_sc_tile_2/inv_pti 5v0_addh_sc_tile_2/a_n1373_n454# 0.00135f
C527 5v0_addh_sc_tile_1/m1_843_n857# VDD_3V3_0 0.20528f
C528 res_01 5v0_addh_sc_tile_0/pti 0
C529 5v0_addh_sc_tile_0/nti 5v0_addh_sc_tile_1/ctrl_over 0
C530 VDD_1V65_0 in_0_over 0.00145f
C531 5v0_add_q_sc_0/inv_nti VDD_3V3_0 0.56502f
C532 5v0_addh_sc_tile_1/pti 5v0_add_q_sc_1/downstepper_test 0.00147f
C533 5v0_addh_sc_tile_0/a_n1373_n454# 5v0_addh_sc_tile_0/upstepper_test 0
C534 VDD_1V65_0 VDD_3V3_1 0.04264f
C535 in_2 5v0_nter2oter_code_sc_0/nti 0
C536 VDD_1V65_5 5v0_add_q_sc_0/inv_pti 0.14775f
C537 5v0_addh_sc_tile_0/a_n1778_n454# 5v0_addh_sc_tile_0/downstepper_test 0.0031f
C538 5v0_addh_sc_tile_2/a_382_n1095# 5v0_addh_sc_tile_1/downstepper_test 0.0018f
C539 5v0_addh_sc_tile_2/5v0_half_adder_selector_sc_0/res_stage0 5v0_addh_sc_tile_2/a_382_n1095# 0.08951f
C540 5v0_addh_sc_tile_2/ctrl_sign in_3 0.0062f
C541 5v0_addh_sc_tile_1/m1_843_n857# 5v0_add_q_sc_0/pti 0.00111f
C542 5v0_addh_sc_tile_2/ctrl_over 5v0_add_q_sc_0/5v0_half_adder_selector_sc_0/res_stage0 0.00474f
C543 VDD_1V65_3 5v0_addh_sc_tile_1/a_n1778_n454# 0
C544 5v0_add_q_sc_0/pti 5v0_add_q_sc_0/inv_nti 0.11055f
C545 5v0_addh_sc_tile_2/ctrl_sign 5v0_addh_sc_tile_2/ctrl_over 0.63344f
C546 5v0_add_q_sc_0/upstepper_test 5v0_addh_sc_tile_1/ctrl_over 0.00229f
C547 c_2_o int_012 0
C548 5v0_addh_sc_tile_1/downstepper_test int_012 0.03365f
C549 5v0_add_q_sc_1/5v0_half_adder_selector_sc_0/m1_n244_n517# 5v0_add_q_sc_1/nti 0
C550 5v0_addh_sc_tile_1/a_382_n1095# 5v0_add_q_sc_0/nti 0
C551 5v0_nter2oter_code_sc_0/pti int_012 0.58802f
C552 5v0_addh_sc_tile_1/nti 5v0_nter2oter_code_sc_1/pti 0
C553 5v0_add_q_sc_1/5v0_half_adder_selector_sc_0/5v0_tgate_sel_2_sc_1/input_A c_2_o 0.04656f
C554 c_2_o 5v0_add_q_sc_1/upstepper_test 0.00943f
C555 5v0_add_q_sc_0/a_n1205_n937# 5v0_add_q_sc_0/nti 0
C556 VDD_1V65_2 5v0_addh_sc_tile_0/carry_0_probe 0.03841f
C557 c_2_o 5v0_add_q_sc_1/5v0_half_adder_selector_sc_0/res_stage0 0.11645f
C558 int_c01 VDD_1V65_2 0.02356f
C559 5v0_add_q_sc_1/nti in_0_over 0.00117f
C560 5v0_addh_sc_tile_0/a_n1778_n454# 5v0_addh_sc_tile_0/upstepper_test 0
C561 VDD_1V65_0 5v0_addh_sc_tile_0/inv_pti 0.14775f
C562 5v0_addh_sc_tile_2/ctrl_sign 5v0_nter2oter_code_sc_0/gf180mcu_fd_sc_mcu7t5v0__nor2_1_0/a_224_472# 0
C563 5v0_add_q_sc_1/nti VDD_3V3_1 0.5318f
C564 5v0_addh_sc_tile_0/nti int_012 0.0033f
C565 5v0_nter2oter_code_sc_1/nti 5v0_addh_sc_tile_0/downstepper_test 0
C566 5v0_addh_sc_tile_2/m1_103_293# 5v0_addh_sc_tile_2/pti 0.10002f
C567 5v0_addh_sc_tile_1/pti 5v0_addh_sc_tile_1/a_382_n1095# 0.12627f
C568 VDD_3V3_1 5v0_nter2oter_code_sc_0/nti 0.09208f
C569 5v0_addh_sc_tile_2/ctrl_sign 5v0_addh_sc_tile_1/downstepper_test 0.00468f
C570 in_1 5v0_nter2oter_code_sc_0/pti 0
C571 5v0_addh_sc_tile_2/ctrl_sign 5v0_addh_sc_tile_2/5v0_half_adder_selector_sc_0/res_stage0 0.25152f
C572 5v0_addh_sc_tile_2/ctrl_over 5v0_add_q_sc_0/downstepper_test 0.01272f
C573 5v0_addh_sc_tile_2/ctrl_sign 5v0_nter2oter_code_sc_0/pti 0.23385f
C574 5v0_addh_sc_tile_1/pti 5v0_add_q_sc_1/inv_nti 0.00257f
C575 5v0_nter2oter_code_sc_1/pti 5v0_addh_sc_tile_1/ctrl_over 0.00583f
C576 5v0_add_q_sc_0/pti 5v0_add_q_sc_0/a_n1778_n454# 0.00135f
C577 5v0_add_q_sc_1/a_n1373_n454# 5v0_add_q_sc_1/nti 0
C578 5v0_addh_sc_tile_2/a_382_n1095# 5v0_add_q_sc_0/upstepper_test 0
C579 c_2_s 5v0_addh_sc_tile_1/5v0_half_adder_selector_sc_0/res_stage0 0
C580 5v0_addh_sc_tile_2/nti 5v0_addh_sc_tile_2/downstepper_test 0.06935f
C581 5v0_addh_sc_tile_2/inv_pti res_01 0
C582 c_2_o 5v0_add_q_sc_1/downstepper_test 0.12191f
C583 VDD_1V65_0 5v0_addh_sc_tile_1/ctrl_sign 0
C584 5v0_addh_sc_tile_1/ctrl_sign 5v0_addh_sc_tile_2/inv_nti 0
C585 5v0_add_q_sc_1/inv_nti m1_n2844_n810# 0.00427f
C586 5v0_addh_sc_tile_0/nti in_1 0.52138f
C587 5v0_addh_sc_tile_1/inv_nti 5v0_addh_sc_tile_0/pti 0
C588 5v0_addh_sc_tile_1/inv_pti 5v0_addh_sc_tile_0/carry_0_probe 0.01474f
C589 5v0_addh_sc_tile_1/ctrl_sign 5v0_add_q_sc_0/ctrl_sign 0
C590 5v0_nter2oter_code_sc_1/nti 5v0_addh_sc_tile_0/upstepper_test 0
C591 5v0_addh_sc_tile_2/upstepper_test 5v0_addh_sc_tile_2/inv_nti 0.00736f
C592 5v0_addh_sc_tile_1/nti 5v0_addh_sc_tile_2/pti 0
C593 int_c01 5v0_addh_sc_tile_1/inv_pti 0.00686f
C594 5v0_add_q_sc_1/nti 5v0_addh_sc_tile_0/inv_pti 0
C595 5v0_add_q_sc_0/ctrl_over VDD_3V3_0 0.91135f
C596 c_2_o 5v0_add_q_sc_0/downstepper_test 0.0085f
C597 int_c01 VDD_1V65_1 0.03394f
C598 5v0_addh_sc_tile_1/pti 5v0_addh_sc_tile_1/a_n1778_n454# 0.00135f
C599 VDD_3V3_0 5v0_addh_sc_tile_2/inv_nti 0.88474f
C600 VDD_1V65_3 5v0_addh_sc_tile_1/inv_pti 0.14775f
C601 res_01 5v0_addh_sc_tile_1/m1_103_293# 0
C602 in_1 5v0_addh_sc_tile_0/m1_103_293# 0
C603 VDD_1V65_5 5v0_add_q_sc_0/inv_nti 0.01114f
C604 5v0_add_q_sc_0/inv_pti 5v0_addh_sc_tile_1/ctrl_over 0.00152f
C605 5v0_add_q_sc_1/inv_pti c_2_s 0.05919f
C606 VDD_3V3_0 5v0_add_q_sc_0/ctrl_sign 0.80665f
C607 5v0_addh_sc_tile_1/inv_pti 5v0_addh_sc_tile_2/m1_843_n857# 0
C608 5v0_add_q_sc_0/upstepper_test 5v0_add_q_sc_0/5v0_half_adder_selector_sc_0/res_stage0 0.27475f
C609 5v0_addh_sc_tile_0/a_382_n1095# 5v0_add_q_sc_1/pti 0
C610 5v0_add_q_sc_0/ctrl_over 5v0_add_q_sc_0/pti 0
C611 5v0_addh_sc_tile_0/inv_nti 5v0_addh_sc_tile_0/5v0_half_adder_selector_sc_0/res_stage0 0.02878f
C612 5v0_nter2oter_code_sc_1/pti int_012 0.00485f
C613 5v0_add_q_sc_1/a_n1778_n454# 5v0_add_q_sc_1/pti 0.00135f
C614 5v0_addh_sc_tile_1/ctrl_over 5v0_addh_sc_tile_2/pti 0
C615 5v0_add_q_sc_1/nti 5v0_addh_sc_tile_1/ctrl_sign 0.00138f
C616 5v0_addh_sc_tile_0/nti 5v0_addh_sc_tile_0/a_n1205_n937# 0
C617 5v0_addh_sc_tile_1/inv_nti res_01 0.28104f
C618 5v0_addh_sc_tile_1/ctrl_sign 5v0_nter2oter_code_sc_0/nti 0
C619 5v0_addh_sc_tile_1/a_382_n1095# 5v0_addh_sc_tile_1/downstepper_test 0.00679f
C620 c_2_o 5v0_addh_sc_tile_1/a_382_n1095# 0.08702f
C621 5v0_add_q_sc_0/pti 5v0_add_q_sc_0/ctrl_sign 0
C622 VDD_1V65_2 m1_n2844_n810# 0.00448f
C623 5v0_nter2oter_code_sc_1/nti 5v0_addh_sc_tile_1/pti 0
C624 c_2_o 5v0_add_q_sc_1/inv_nti 0.00311f
C625 VDD_1V65_5 5v0_add_q_sc_0/a_n1778_n454# 0
C626 5v0_add_q_sc_0/5v0_half_adder_selector_sc_0/m1_n239_179# 5v0_addh_sc_tile_1/ctrl_over 0.00107f
C627 5v0_add_q_sc_0/ctrl_over 5v0_addh_sc_tile_2/5v0_half_adder_selector_sc_0/5v0_tgate_sel_2_sc_1/input_A 0
C628 5v0_addh_sc_tile_1/nti 5v0_addh_sc_tile_0/a_382_n1095# 0.01157f
C629 5v0_addh_sc_tile_0/inv_nti 5v0_addh_sc_tile_0/carry_0_probe 0.03001f
C630 VDD_3V3_0 5v0_nter2oter_code_sc_0/nti 0.31492f
C631 5v0_add_q_sc_1/5v0_half_adder_selector_sc_0/m1_n244_n517# c_2_s 0
C632 5v0_add_q_sc_0/upstepper_test 5v0_add_q_sc_0/downstepper_test 0.38867f
C633 5v0_addh_sc_tile_2/ctrl_sign 5v0_nter2oter_code_sc_1/pti 0.0299f
C634 int_c01 5v0_addh_sc_tile_0/inv_nti 0.001f
C635 5v0_addh_sc_tile_0/pti 5v0_addh_sc_tile_0/5v0_half_adder_selector_sc_0/res_stage0 0.01078f
C636 5v0_addh_sc_tile_0/inv_nti 5v0_addh_sc_tile_0/downstepper_test 0.29989f
C637 5v0_addh_sc_tile_0/nti 5v0_addh_sc_tile_0/a_n1373_n454# 0
C638 5v0_addh_sc_tile_2/inv_pti 5v0_addh_sc_tile_1/inv_nti 0
C639 c_2_s in_0_over 0.00327f
C640 in_0_sign 5v0_addh_sc_tile_1/inv_pti 0.00171f
C641 5v0_addh_sc_tile_2/a_382_n1095# 5v0_addh_sc_tile_2/pti 0.12254f
C642 VDD_3V3_1 c_2_s 1.0828f
C643 5v0_addh_sc_tile_0/m1_843_n857# c_2_s 0
C644 5v0_addh_sc_tile_1/a_n1778_n454# 5v0_addh_sc_tile_1/downstepper_test 0.0031f
C645 5v0_addh_sc_tile_1/pti 5v0_addh_sc_tile_1/inv_pti 0.37325f
C646 5v0_addh_sc_tile_1/m1_103_293# int_carry 0
C647 5v0_nter2oter_code_sc_1/nti in_3 0
C648 int_012 5v0_addh_sc_tile_2/pti 0.00286f
C649 5v0_nter2oter_code_sc_1/nti 5v0_addh_sc_tile_2/ctrl_over 0
C650 5v0_addh_sc_tile_0/a_382_n1095# 5v0_addh_sc_tile_1/ctrl_over 0
C651 5v0_addh_sc_tile_1/a_382_n1095# 5v0_add_q_sc_0/upstepper_test 0.0104f
C652 5v0_addh_sc_tile_0/pti 5v0_addh_sc_tile_0/carry_0_probe 0.14485f
C653 5v0_addh_sc_tile_1/inv_pti m1_n2844_n810# 0
C654 5v0_addh_sc_tile_1/inv_nti 5v0_addh_sc_tile_1/m1_103_293# 0.35313f
C655 5v0_addh_sc_tile_0/inv_nti 5v0_addh_sc_tile_0/upstepper_test 0.00736f
C656 int_c01 5v0_addh_sc_tile_0/pti 0.00103f
C657 5v0_add_q_sc_0/a_n1205_n937# 5v0_add_q_sc_0/upstepper_test 0.00334f
C658 5v0_add_q_sc_0/ctrl_over VDD_1V65_5 0
C659 5v0_addh_sc_tile_0/pti 5v0_addh_sc_tile_0/downstepper_test 0.20149f
C660 res_01 5v0_addh_sc_tile_0/5v0_half_adder_selector_sc_0/res_stage0 0.0902f
C661 5v0_addh_sc_tile_1/ctrl_sign VDD_1V65_4 0
C662 5v0_add_q_sc_0/inv_pti 5v0_add_q_sc_0/5v0_half_adder_selector_sc_0/res_stage0 0
C663 5v0_add_q_sc_0/inv_nti 5v0_addh_sc_tile_1/ctrl_over 0
C664 5v0_addh_sc_tile_1/m1_843_n857# 5v0_addh_sc_tile_1/ctrl_over 0.10251f
C665 5v0_addh_sc_tile_0/nti 5v0_addh_sc_tile_0/a_n1778_n454# 0.00142f
C666 5v0_addh_sc_tile_1/inv_nti int_carry 0.0263f
C667 5v0_addh_sc_tile_2/upstepper_test VDD_1V65_4 0.16859f
C668 5v0_add_q_sc_0/5v0_half_adder_selector_sc_0/res_stage0 5v0_addh_sc_tile_2/pti 0
C669 5v0_addh_sc_tile_0/inv_pti c_2_s 0
C670 5v0_addh_sc_tile_2/ctrl_sign 5v0_addh_sc_tile_2/pti 0.28211f
C671 5v0_nter2oter_code_sc_1/nti 5v0_addh_sc_tile_1/downstepper_test 0
C672 VDD_3V3_0 VDD_1V65_4 0.0468f
C673 5v0_addh_sc_tile_1/downstepper_test 5v0_nter2oter_code_sc_1/gf180mcu_fd_sc_mcu7t5v0__nor2_1_0/a_224_472# 0
C674 5v0_addh_sc_tile_2/ctrl_over 5v0_addh_sc_tile_1/inv_pti 0
C675 5v0_add_q_sc_0/ctrl_over 5v0_addh_sc_tile_2/m1_103_293# 0.01398f
C676 res_01 5v0_addh_sc_tile_0/carry_0_probe 0.00236f
C677 5v0_addh_sc_tile_0/pti 5v0_addh_sc_tile_0/upstepper_test 0.02426f
C678 5v0_addh_sc_tile_0/inv_nti in_0_sign 0.24892f
C679 res_c int_carry 0.167f
C680 5v0_add_q_sc_0/5v0_half_adder_selector_sc_0/res_stage0 5v0_add_q_sc_0/5v0_half_adder_selector_sc_0/m1_n239_179# 0.18379f
C681 res_01 5v0_addh_sc_tile_0/downstepper_test 0.00308f
C682 5v0_addh_sc_tile_2/m1_103_293# 5v0_addh_sc_tile_2/inv_nti 0.35313f
C683 5v0_add_q_sc_0/inv_pti 5v0_add_q_sc_0/downstepper_test 0.07797f
C684 5v0_addh_sc_tile_1/pti 5v0_addh_sc_tile_0/inv_nti 0
C685 5v0_addh_sc_tile_2/a_n1205_n937# 5v0_addh_sc_tile_2/ctrl_over 0
C686 VDD_1V65_3 res_01 0.01451f
C687 c_2_s 5v0_addh_sc_tile_1/ctrl_sign 0.24986f
C688 5v0_addh_sc_tile_0/nti 5v0_nter2oter_code_sc_1/nti 0
C689 5v0_addh_sc_tile_2/m1_103_293# 5v0_add_q_sc_0/ctrl_sign 0.21173f
C690 5v0_add_q_sc_0/downstepper_test 5v0_addh_sc_tile_2/pti 0
C691 5v0_addh_sc_tile_1/upstepper_test c_2_s 0
C692 5v0_addh_sc_tile_1/inv_pti 5v0_addh_sc_tile_1/downstepper_test 0.1369f
C693 c_2_o 5v0_addh_sc_tile_1/inv_pti 0.01474f
C694 5v0_addh_sc_tile_0/inv_nti m1_n2844_n810# 0.02458f
C695 5v0_add_q_sc_1/upstepper_test 5v0_add_q_sc_1/a_n1778_n454# 0
C696 c_2_o VDD_1V65_1 0.04751f
C697 in_1 5v0_addh_sc_tile_0/a_382_n1095# 0.09307f
C698 5v0_addh_sc_tile_0/pti in_0_sign 0.27027f
C699 5v0_add_q_sc_0/downstepper_test 5v0_add_q_sc_0/5v0_half_adder_selector_sc_0/m1_n239_179# 0.09961f
C700 5v0_addh_sc_tile_1/nti 5v0_addh_sc_tile_2/inv_nti 0
C701 5v0_add_q_sc_0/inv_pti 5v0_addh_sc_tile_1/a_382_n1095# 0
C702 5v0_addh_sc_tile_1/pti 5v0_addh_sc_tile_0/pti 0
C703 5v0_addh_sc_tile_2/a_n1373_n454# in_3 0.00163f
C704 5v0_addh_sc_tile_2/a_n1205_n937# 5v0_addh_sc_tile_2/5v0_half_adder_selector_sc_0/res_stage0 0
C705 5v0_addh_sc_tile_0/inv_nti 5v0_addh_sc_tile_0/carry_sign_probe 0.17527f
C706 5v0_add_q_sc_1/nti 5v0_add_q_sc_1/pti 0.15563f
C707 5v0_addh_sc_tile_1/nti 5v0_add_q_sc_0/ctrl_sign 0
C708 5v0_add_q_sc_1/upstepper_test 5v0_add_q_sc_1/5v0_half_adder_selector_sc_0/m1_n239_179# 0.07502f
C709 5v0_add_q_sc_0/5v0_half_adder_selector_sc_0/5v0_tgate_sel_2_sc_1/input_A 5v0_add_q_sc_0/upstepper_test 0
C710 5v0_add_q_sc_1/5v0_half_adder_selector_sc_0/res_stage0 5v0_add_q_sc_1/5v0_half_adder_selector_sc_0/m1_n239_179# 0.18379f
C711 5v0_addh_sc_tile_0/pti m1_n2844_n810# 0.00645f
C712 5v0_addh_sc_tile_1/m1_103_293# 5v0_addh_sc_tile_0/carry_0_probe 0.002f
C713 5v0_addh_sc_tile_2/inv_pti 5v0_addh_sc_tile_2/m1_843_n857# 0
C714 5v0_add_q_sc_0/ctrl_over 5v0_addh_sc_tile_1/ctrl_over 0
C715 5v0_add_q_sc_1/a_n1778_n454# 5v0_add_q_sc_1/downstepper_test 0.0031f
C716 int_c01 5v0_addh_sc_tile_1/m1_103_293# 0
C717 VDD_1V65_0 5v0_addh_sc_tile_1/ctrl_over 0
C718 5v0_addh_sc_tile_0/m1_103_293# 5v0_addh_sc_tile_1/inv_pti 0.00205f
C719 5v0_addh_sc_tile_1/ctrl_over 5v0_addh_sc_tile_2/inv_nti 0
C720 res_01 in_0_sign 0
C721 5v0_addh_sc_tile_1/a_382_n1095# 5v0_add_q_sc_0/5v0_half_adder_selector_sc_0/m1_n239_179# 0.0035f
C722 int_c01 int_carry 0.17661f
C723 5v0_nter2oter_code_sc_1/nti 5v0_nter2oter_code_sc_1/pti 0.00234f
C724 5v0_addh_sc_tile_1/ctrl_over 5v0_add_q_sc_0/ctrl_sign 0.00366f
C725 5v0_addh_sc_tile_0/pti 5v0_addh_sc_tile_0/carry_sign_probe 0.01168f
C726 5v0_addh_sc_tile_1/inv_nti 5v0_addh_sc_tile_0/carry_0_probe 0
C727 5v0_addh_sc_tile_2/a_n1778_n454# in_3 0.00182f
C728 5v0_addh_sc_tile_1/pti res_01 0.67368f
C729 5v0_add_q_sc_1/a_n1205_n937# 5v0_add_q_sc_1/nti 0
C730 int_c01 5v0_addh_sc_tile_1/inv_nti 0
C731 5v0_addh_sc_tile_0/inv_nti 5v0_nter2oter_code_sc_0/pti 0.00589f
C732 5v0_addh_sc_tile_2/downstepper_test 5v0_addh_sc_tile_2/upstepper_test 0.38555f
C733 5v0_add_q_sc_1/downstepper_test 5v0_add_q_sc_1/5v0_half_adder_selector_sc_0/m1_n239_179# 0.09961f
C734 5v0_add_q_sc_0/inv_nti 5v0_add_q_sc_0/downstepper_test 0.1819f
C735 5v0_addh_sc_tile_2/m1_843_n857# int_carry 0
C736 5v0_addh_sc_tile_1/inv_nti VDD_1V65_3 0.08611f
C737 VDD_3V3_0 5v0_addh_sc_tile_2/downstepper_test 0.5243f
C738 in_0_over 5v0_addh_sc_tile_1/5v0_half_adder_selector_sc_0/res_stage0 0
C739 5v0_addh_sc_tile_1/a_n1205_n937# 5v0_addh_sc_tile_1/5v0_half_adder_selector_sc_0/res_stage0 0
C740 5v0_add_q_sc_0/ctrl_over 5v0_addh_sc_tile_2/a_382_n1095# 0.06871f
C741 VDD_3V3_1 5v0_addh_sc_tile_1/5v0_half_adder_selector_sc_0/res_stage0 0.01812f
C742 5v0_addh_sc_tile_0/nti 5v0_addh_sc_tile_0/inv_nti 0.22786f
C743 5v0_add_q_sc_1/nti 5v0_addh_sc_tile_1/ctrl_over 0
C744 5v0_addh_sc_tile_2/nti 5v0_addh_sc_tile_1/ctrl_sign 0
C745 5v0_addh_sc_tile_2/a_382_n1095# 5v0_addh_sc_tile_2/inv_nti 0.28654f
C746 5v0_addh_sc_tile_1/ctrl_over 5v0_nter2oter_code_sc_0/nti 0
C747 5v0_addh_sc_tile_0/a_382_n1095# 5v0_add_q_sc_1/inv_nti 0
C748 5v0_addh_sc_tile_2/inv_pti 5v0_addh_sc_tile_1/pti 0
C749 5v0_addh_sc_tile_2/a_382_n1095# 5v0_add_q_sc_0/ctrl_sign 0.00651f
C750 5v0_addh_sc_tile_2/nti 5v0_addh_sc_tile_2/upstepper_test 0.11981f
C751 int_012 5v0_addh_sc_tile_2/inv_nti 0
C752 res_01 5v0_addh_sc_tile_2/ctrl_over 0.00181f
C753 5v0_addh_sc_tile_1/m1_843_n857# 5v0_addh_sc_tile_1/a_382_n1095# 0.05013f
C754 5v0_add_q_sc_1/a_n1778_n454# 5v0_add_q_sc_1/inv_nti 0.00214f
C755 5v0_addh_sc_tile_0/inv_nti 5v0_addh_sc_tile_0/m1_103_293# 0.35313f
C756 5v0_add_q_sc_0/inv_nti 5v0_add_q_sc_0/a_n1205_n937# 0
C757 5v0_add_q_sc_0/nti int_carry 0.62238f
C758 5v0_add_q_sc_0/ctrl_sign int_012 0.01026f
C759 5v0_nter2oter_code_sc_1/nti 5v0_addh_sc_tile_2/pti 0
C760 5v0_add_q_sc_0/a_n1778_n454# 5v0_add_q_sc_0/downstepper_test 0.0031f
C761 VDD_3V3_0 5v0_addh_sc_tile_2/nti 0.7527f
C762 5v0_addh_sc_tile_1/inv_nti 5v0_add_q_sc_0/nti 0
C763 5v0_add_q_sc_0/ctrl_over 5v0_add_q_sc_0/5v0_half_adder_selector_sc_0/res_stage0 0.09148f
C764 5v0_addh_sc_tile_2/ctrl_sign 5v0_add_q_sc_0/ctrl_over 0.00758f
C765 5v0_addh_sc_tile_1/pti 5v0_addh_sc_tile_1/m1_103_293# 0.10002f
C766 5v0_addh_sc_tile_0/nti 5v0_addh_sc_tile_0/pti 0.24563f
C767 5v0_add_q_sc_1/inv_pti VDD_3V3_1 0.40305f
C768 in_1 VDD_1V65_0 0.01451f
C769 5v0_add_q_sc_0/5v0_half_adder_selector_sc_0/res_stage0 5v0_addh_sc_tile_2/inv_nti 0
C770 5v0_addh_sc_tile_2/downstepper_test 5v0_addh_sc_tile_2/5v0_half_adder_selector_sc_0/5v0_tgate_sel_2_sc_1/input_A 0
C771 5v0_addh_sc_tile_2/ctrl_sign 5v0_addh_sc_tile_2/inv_nti 0.24905f
C772 res_01 5v0_addh_sc_tile_1/downstepper_test 0.18203f
C773 5v0_addh_sc_tile_0/downstepper_test 5v0_addh_sc_tile_0/5v0_half_adder_selector_sc_0/res_stage0 0.25483f
C774 in_2 VDD_3V3_1 0.90866f
C775 5v0_addh_sc_tile_1/pti int_carry 0
C776 5v0_addh_sc_tile_2/5v0_half_adder_selector_sc_0/res_stage0 res_01 0
C777 5v0_addh_sc_tile_2/inv_pti in_3 0.05631f
C778 c_2_o res_01 0.00136f
C779 5v0_addh_sc_tile_1/m1_103_293# m1_n2844_n810# 0
C780 res_01 5v0_nter2oter_code_sc_0/pti 0
C781 VDD_3V3_0 5v0_add_q_sc_0/5v0_half_adder_selector_sc_0/m1_n244_n517# 0.29978f
C782 5v0_addh_sc_tile_2/inv_pti 5v0_addh_sc_tile_2/ctrl_over 0.0554f
C783 c_2_s 5v0_add_q_sc_1/pti 0.15254f
C784 5v0_add_q_sc_1/a_n1373_n454# 5v0_add_q_sc_1/inv_pti 0.00135f
C785 5v0_add_q_sc_0/5v0_half_adder_selector_sc_0/res_stage0 5v0_add_q_sc_0/ctrl_sign 0.22359f
C786 5v0_addh_sc_tile_2/ctrl_sign 5v0_add_q_sc_0/ctrl_sign 0.27145f
C787 5v0_addh_sc_tile_0/pti 5v0_addh_sc_tile_0/m1_103_293# 0.10002f
C788 5v0_addh_sc_tile_1/inv_pti 5v0_addh_sc_tile_2/pti 0
C789 5v0_addh_sc_tile_1/inv_nti 5v0_addh_sc_tile_1/pti 0.42143f
C790 5v0_add_q_sc_0/nti res_c 0
C791 5v0_nter2oter_code_sc_0/nti int_012 0.23186f
C792 5v0_add_q_sc_1/nti 5v0_add_q_sc_1/upstepper_test 0.11962f
C793 5v0_nter2oter_code_sc_1/pti 5v0_addh_sc_tile_0/inv_nti 0.00491f
C794 5v0_add_q_sc_1/nti 5v0_add_q_sc_1/5v0_half_adder_selector_sc_0/res_stage0 0.00372f
C795 5v0_addh_sc_tile_1/ctrl_sign 5v0_addh_sc_tile_1/5v0_half_adder_selector_sc_0/res_stage0 0.22639f
C796 5v0_add_q_sc_1/5v0_half_adder_selector_sc_0/m1_n244_n517# VDD_3V3_1 0.28925f
C797 5v0_add_q_sc_0/ctrl_over 5v0_add_q_sc_0/downstepper_test 0.02328f
C798 5v0_addh_sc_tile_0/nti res_01 0
C799 int_c01 5v0_addh_sc_tile_0/carry_0_probe 0.23005f
C800 5v0_addh_sc_tile_1/upstepper_test 5v0_addh_sc_tile_1/5v0_half_adder_selector_sc_0/res_stage0 0.27475f
C801 5v0_addh_sc_tile_0/a_n1205_n937# VDD_1V65_0 0.00354f
C802 5v0_addh_sc_tile_0/5v0_half_adder_selector_sc_0/res_stage0 5v0_addh_sc_tile_0/upstepper_test 0.27475f
C803 5v0_add_q_sc_0/downstepper_test 5v0_addh_sc_tile_2/inv_nti 0
C804 5v0_addh_sc_tile_2/inv_pti 5v0_addh_sc_tile_1/downstepper_test 0.01675f
C805 in_2 5v0_addh_sc_tile_0/inv_pti 0.00153f
C806 5v0_addh_sc_tile_2/inv_pti 5v0_addh_sc_tile_2/5v0_half_adder_selector_sc_0/res_stage0 0.01003f
C807 VDD_3V3_0 5v0_add_q_sc_0/a_n1373_n454# 0.00122f
C808 VDD_3V3_0 5v0_addh_sc_tile_1/5v0_half_adder_selector_sc_0/res_stage0 0.11354f
C809 VDD_3V3_1 in_0_over 0.64118f
C810 5v0_addh_sc_tile_2/ctrl_over int_carry 0.00714f
C811 5v0_addh_sc_tile_0/m1_843_n857# in_0_over 0.09998f
C812 5v0_add_q_sc_0/downstepper_test 5v0_add_q_sc_0/ctrl_sign 0.14564f
C813 res_01 5v0_addh_sc_tile_0/m1_103_293# 0
C814 5v0_addh_sc_tile_2/ctrl_sign 5v0_nter2oter_code_sc_0/nti 0.03693f
C815 5v0_addh_sc_tile_0/m1_843_n857# VDD_3V3_1 0.22222f
C816 5v0_addh_sc_tile_1/inv_nti 5v0_addh_sc_tile_2/ctrl_over 0.00155f
C817 5v0_nter2oter_code_sc_1/pti 5v0_addh_sc_tile_0/pti 0
C818 5v0_add_q_sc_1/nti 5v0_add_q_sc_1/downstepper_test 0.06596f
C819 5v0_add_q_sc_0/ctrl_over 5v0_addh_sc_tile_1/a_382_n1095# 0
C820 5v0_addh_sc_tile_0/upstepper_test 5v0_addh_sc_tile_0/carry_0_probe 0
C821 5v0_addh_sc_tile_1/m1_103_293# 5v0_addh_sc_tile_1/downstepper_test 0.10533f
C822 c_2_o 5v0_addh_sc_tile_1/m1_103_293# 0.01922f
C823 5v0_add_q_sc_1/a_n1373_n454# VDD_3V3_1 0.00122f
C824 5v0_add_q_sc_0/pti 5v0_add_q_sc_0/a_n1373_n454# 0
C825 5v0_addh_sc_tile_0/downstepper_test 5v0_addh_sc_tile_0/upstepper_test 0.38867f
C826 5v0_addh_sc_tile_0/a_382_n1095# 5v0_addh_sc_tile_1/inv_pti 0
C827 5v0_addh_sc_tile_0/a_n1373_n454# VDD_1V65_0 0.00232f
C828 in_0_sign 5v0_addh_sc_tile_0/5v0_half_adder_selector_sc_0/res_stage0 0.22359f
C829 in_2 5v0_addh_sc_tile_1/ctrl_sign 0.1696f
C830 5v0_addh_sc_tile_2/downstepper_test 5v0_addh_sc_tile_2/m1_103_293# 0.0934f
C831 c_2_s 5v0_addh_sc_tile_1/ctrl_over 0
C832 5v0_addh_sc_tile_2/a_n1373_n454# 5v0_addh_sc_tile_2/pti 0
C833 c_2_o int_carry 0.30261f
C834 5v0_addh_sc_tile_0/inv_pti in_0_over 0
C835 5v0_addh_sc_tile_2/ctrl_over res_c 0.00127f
C836 5v0_addh_sc_tile_1/a_382_n1095# 5v0_add_q_sc_0/ctrl_sign 0.0169f
C837 5v0_add_q_sc_1/a_n1778_n454# VDD_1V65_1 0
C838 5v0_addh_sc_tile_1/inv_nti 5v0_addh_sc_tile_1/downstepper_test 0.29493f
C839 5v0_addh_sc_tile_0/inv_pti VDD_3V3_1 1.05126f
C840 5v0_addh_sc_tile_1/m1_843_n857# 5v0_addh_sc_tile_1/inv_pti 0
C841 c_2_o 5v0_addh_sc_tile_1/inv_nti 0.03482f
C842 5v0_addh_sc_tile_0/m1_843_n857# 5v0_addh_sc_tile_0/inv_pti 0
C843 in_2 VDD_3V3_0 0.0135f
C844 5v0_addh_sc_tile_2/inv_pti 5v0_add_q_sc_0/upstepper_test 0
C845 5v0_nter2oter_code_sc_1/pti res_01 0
C846 in_0_sign 5v0_addh_sc_tile_0/carry_0_probe 0.01009f
C847 5v0_addh_sc_tile_1/nti 5v0_addh_sc_tile_2/downstepper_test 0
C848 int_c01 in_0_sign 0
C849 5v0_addh_sc_tile_0/a_n1778_n454# VDD_1V65_0 0
C850 in_0_sign 5v0_addh_sc_tile_0/downstepper_test 0.14463f
C851 5v0_addh_sc_tile_1/pti 5v0_addh_sc_tile_0/carry_0_probe 0.0051f
C852 5v0_addh_sc_tile_1/ctrl_sign in_0_over 0.03467f
C853 5v0_addh_sc_tile_2/a_n1778_n454# 5v0_addh_sc_tile_2/pti 0.00135f
C854 5v0_addh_sc_tile_2/ctrl_sign VDD_1V65_4 0
C855 5v0_add_q_sc_1/nti 5v0_addh_sc_tile_1/a_382_n1095# 0
C856 VDD_1V65_3 in_0_sign 0
C857 5v0_addh_sc_tile_0/carry_sign_probe 5v0_addh_sc_tile_0/5v0_half_adder_selector_sc_0/res_stage0 0
C858 5v0_add_q_sc_0/upstepper_test 5v0_addh_sc_tile_1/m1_103_293# 0.00268f
C859 VDD_3V3_1 5v0_addh_sc_tile_1/ctrl_sign 0.87932f
C860 5v0_addh_sc_tile_1/upstepper_test in_0_over 0.01202f
C861 5v0_addh_sc_tile_1/upstepper_test 5v0_addh_sc_tile_1/a_n1205_n937# 0.00334f
C862 5v0_addh_sc_tile_0/m1_843_n857# 5v0_addh_sc_tile_1/ctrl_sign 0
C863 5v0_add_q_sc_1/nti 5v0_add_q_sc_1/inv_nti 0.20056f
C864 VDD_1V65_3 5v0_addh_sc_tile_1/pti 0.00234f
C865 5v0_addh_sc_tile_0/carry_0_probe m1_n2844_n810# 0.40894f
C866 5v0_addh_sc_tile_1/upstepper_test VDD_3V3_1 0.39457f
C867 int_c01 m1_n2844_n810# 0.11648f
C868 5v0_addh_sc_tile_1/upstepper_test 5v0_addh_sc_tile_0/m1_843_n857# 0.00724f
C869 VDD_3V3_0 5v0_addh_sc_tile_1/a_n1205_n937# 0.00891f
C870 5v0_add_q_sc_0/upstepper_test int_carry 0.02583f
C871 5v0_addh_sc_tile_0/downstepper_test m1_n2844_n810# 0
C872 VDD_3V3_0 in_0_over 0
C873 5v0_add_q_sc_1/5v0_half_adder_selector_sc_0/5v0_tgate_sel_2_sc_1/input_A c_2_s 0
C874 5v0_addh_sc_tile_0/a_382_n1095# 5v0_addh_sc_tile_0/inv_nti 0.28672f
C875 5v0_add_q_sc_1/upstepper_test c_2_s 0.13566f
C876 5v0_add_q_sc_1/5v0_half_adder_selector_sc_0/res_stage0 c_2_s 0.22434f
C877 VDD_3V3_0 VDD_3V3_1 0.00215f
C878 5v0_addh_sc_tile_1/inv_nti 5v0_add_q_sc_0/upstepper_test 0.00109f
C879 5v0_addh_sc_tile_1/5v0_half_adder_selector_sc_0/5v0_tgate_sel_2_sc_1/input_A 5v0_addh_sc_tile_1/downstepper_test 0
C880 in_0_sign 5v0_addh_sc_tile_0/upstepper_test 0.08746f
C881 c_2_o 5v0_addh_sc_tile_1/5v0_half_adder_selector_sc_0/5v0_tgate_sel_2_sc_1/input_A 0
C882 VDD_1V65_5 5v0_add_q_sc_0/a_n1373_n454# 0.00232f
C883 5v0_addh_sc_tile_0/carry_sign_probe 5v0_addh_sc_tile_0/carry_0_probe 0.0594f
C884 5v0_nter2oter_code_sc_1/nti VDD_1V65_0 0
C885 int_c01 5v0_addh_sc_tile_0/carry_sign_probe 0.05455f
C886 5v0_addh_sc_tile_0/carry_sign_probe 5v0_addh_sc_tile_0/downstepper_test 0
C887 5v0_add_q_sc_0/ctrl_over 5v0_add_q_sc_0/5v0_half_adder_selector_sc_0/5v0_tgate_sel_2_sc_1/input_A 0.04656f
C888 5v0_addh_sc_tile_1/upstepper_test 5v0_addh_sc_tile_1/a_n1373_n454# 0
C889 VDD_3V3_0 5v0_addh_sc_tile_1/a_n1373_n454# 0.00122f
C890 5v0_addh_sc_tile_0/a_382_n1095# 5v0_addh_sc_tile_0/pti 0.12627f
C891 res_01 5v0_add_q_sc_0/5v0_half_adder_selector_sc_0/m1_n239_179# 0
C892 5v0_addh_sc_tile_0/5v0_half_adder_selector_sc_0/5v0_tgate_sel_2_sc_1/input_A 5v0_addh_sc_tile_0/5v0_half_adder_selector_sc_0/res_stage0 0.00253f
C893 5v0_addh_sc_tile_1/pti 5v0_add_q_sc_0/nti 0
C894 5v0_add_q_sc_0/5v0_half_adder_selector_sc_0/5v0_tgate_sel_2_sc_1/input_A 5v0_add_q_sc_0/ctrl_sign 0
C895 5v0_addh_sc_tile_2/nti 5v0_addh_sc_tile_1/ctrl_over 0
C896 in_3 5v0_addh_sc_tile_2/m1_843_n857# 0
C897 5v0_add_q_sc_1/downstepper_test c_2_s 0.25694f
C898 5v0_add_q_sc_1/nti VDD_1V65_2 0.02331f
C899 5v0_addh_sc_tile_2/ctrl_over 5v0_addh_sc_tile_2/m1_843_n857# 0.10619f
C900 5v0_addh_sc_tile_2/a_382_n1095# 5v0_addh_sc_tile_2/downstepper_test 0.00679f
C901 5v0_addh_sc_tile_0/nti 5v0_addh_sc_tile_0/5v0_half_adder_selector_sc_0/res_stage0 0.00372f
C902 c_2_o 5v0_addh_sc_tile_0/carry_0_probe 0
C903 5v0_addh_sc_tile_1/downstepper_test 5v0_addh_sc_tile_0/carry_0_probe 0.01317f
C904 5v0_addh_sc_tile_0/carry_sign_probe 5v0_addh_sc_tile_0/upstepper_test 0
C905 5v0_addh_sc_tile_2/inv_pti 5v0_addh_sc_tile_2/pti 0.44081f
C906 5v0_addh_sc_tile_1/inv_pti 5v0_addh_sc_tile_2/inv_nti 0
C907 5v0_addh_sc_tile_1/pti in_0_sign 0
C908 int_c01 c_2_o 0.24448f
C909 in_3 res_0 0.16326f
C910 5v0_nter2oter_code_sc_0/pti 5v0_addh_sc_tile_0/downstepper_test 0.0027f
C911 5v0_addh_sc_tile_1/upstepper_test 5v0_addh_sc_tile_1/ctrl_sign 0.10431f
C912 5v0_addh_sc_tile_1/inv_pti 5v0_add_q_sc_0/ctrl_sign 0
C913 5v0_addh_sc_tile_2/ctrl_over res_0 0.20137f
C914 VDD_1V65_3 5v0_addh_sc_tile_1/downstepper_test 0.13024f
C915 in_0_sign m1_n2844_n810# 0.0018f
C916 5v0_addh_sc_tile_0/m1_103_293# 5v0_addh_sc_tile_0/5v0_half_adder_selector_sc_0/res_stage0 0.18549f
C917 5v0_addh_sc_tile_0/5v0_half_adder_selector_sc_0/5v0_tgate_sel_2_sc_1/input_A 5v0_addh_sc_tile_0/carry_0_probe 0
C918 5v0_addh_sc_tile_0/a_382_n1095# res_01 0.17536f
C919 5v0_addh_sc_tile_2/inv_pti 5v0_add_q_sc_0/5v0_half_adder_selector_sc_0/m1_n239_179# 0.00128f
C920 5v0_addh_sc_tile_1/nti 5v0_addh_sc_tile_1/5v0_half_adder_selector_sc_0/res_stage0 0.00372f
C921 VDD_3V3_0 5v0_addh_sc_tile_1/ctrl_sign 0.42962f
C922 5v0_addh_sc_tile_2/a_n1205_n937# 5v0_addh_sc_tile_2/inv_nti 0
C923 5v0_addh_sc_tile_0/5v0_half_adder_selector_sc_0/5v0_tgate_sel_2_sc_1/input_A 5v0_addh_sc_tile_0/downstepper_test 0
C924 5v0_add_q_sc_1/inv_pti 5v0_add_q_sc_1/pti 0.19726f
C925 5v0_addh_sc_tile_0/nti 5v0_addh_sc_tile_0/carry_0_probe 0
C926 5v0_add_q_sc_0/inv_pti int_carry 0.08665f
C927 5v0_addh_sc_tile_2/ctrl_over 5v0_add_q_sc_0/nti 0
C928 VDD_3V3_0 5v0_addh_sc_tile_2/upstepper_test 0.46517f
C929 5v0_addh_sc_tile_1/upstepper_test VDD_3V3_0 0.13286f
C930 5v0_addh_sc_tile_2/a_382_n1095# 5v0_addh_sc_tile_2/nti 0
C931 5v0_addh_sc_tile_0/nti 5v0_addh_sc_tile_0/downstepper_test 0.06935f
C932 5v0_add_q_sc_0/inv_pti 5v0_addh_sc_tile_1/inv_nti 0
C933 5v0_addh_sc_tile_2/pti int_carry 0.00318f
C934 5v0_addh_sc_tile_2/ctrl_sign 5v0_addh_sc_tile_2/downstepper_test 0.20835f
C935 5v0_addh_sc_tile_1/m1_843_n857# res_01 0
C936 in_0_sign 5v0_addh_sc_tile_0/carry_sign_probe 0.24834f
C937 5v0_add_q_sc_1/nti 5v0_addh_sc_tile_1/inv_pti 0.00413f
C938 5v0_addh_sc_tile_1/a_382_n1095# c_2_s 0.00155f
C939 5v0_addh_sc_tile_2/nti int_012 0.00515f
C940 5v0_addh_sc_tile_0/m1_103_293# 5v0_addh_sc_tile_0/carry_0_probe 0.01488f
C941 5v0_addh_sc_tile_2/5v0_half_adder_selector_sc_0/res_stage0 res_0 0.08533f
C942 5v0_add_q_sc_0/5v0_half_adder_selector_sc_0/m1_n239_179# 5v0_addh_sc_tile_1/m1_103_293# 0
C943 5v0_addh_sc_tile_1/inv_nti 5v0_addh_sc_tile_2/pti 0
C944 5v0_add_q_sc_1/nti VDD_1V65_1 0.21326f
C945 int_c01 5v0_addh_sc_tile_0/m1_103_293# 0
C946 c_2_s 5v0_add_q_sc_1/inv_nti 0.10096f
C947 5v0_addh_sc_tile_0/m1_103_293# 5v0_addh_sc_tile_0/downstepper_test 0.10533f
C948 5v0_addh_sc_tile_1/pti 5v0_addh_sc_tile_2/ctrl_over 0
C949 5v0_addh_sc_tile_1/ctrl_over 5v0_addh_sc_tile_1/5v0_half_adder_selector_sc_0/res_stage0 0.11033f
C950 5v0_addh_sc_tile_0/5v0_half_adder_selector_sc_0/5v0_tgate_sel_2_sc_1/input_A 5v0_addh_sc_tile_0/upstepper_test 0
C951 5v0_addh_sc_tile_2/a_382_n1095# 5v0_add_q_sc_0/5v0_half_adder_selector_sc_0/m1_n244_n517# 0
C952 5v0_add_q_sc_0/5v0_half_adder_selector_sc_0/m1_n239_179# int_carry 0.00189f
C953 5v0_addh_sc_tile_0/carry_sign_probe m1_n2844_n810# 0.12483f
C954 c_2_o 5v0_add_q_sc_0/nti 0.01581f
C955 5v0_addh_sc_tile_2/a_n1373_n454# 5v0_addh_sc_tile_2/inv_nti 0
C956 VDD_1V65_0 5v0_addh_sc_tile_0/inv_nti 0.08611f
C957 5v0_addh_sc_tile_0/nti 5v0_addh_sc_tile_0/upstepper_test 0.11981f
C958 5v0_add_q_sc_0/pti VDD_3V3_0 0.57843f
C959 5v0_addh_sc_tile_1/inv_nti 5v0_add_q_sc_0/5v0_half_adder_selector_sc_0/m1_n239_179# 0
C960 in_2 5v0_addh_sc_tile_1/nti 0.00613f
C961 5v0_addh_sc_tile_2/ctrl_sign 5v0_addh_sc_tile_2/nti 0.01914f
C962 5v0_addh_sc_tile_2/pti res_c 0
C963 5v0_addh_sc_tile_0/m1_103_293# 5v0_addh_sc_tile_0/upstepper_test 0.07773f
C964 VDD_3V3_1 5v0_add_q_sc_1/pti 0.56896f
C965 5v0_addh_sc_tile_2/upstepper_test 5v0_addh_sc_tile_2/5v0_half_adder_selector_sc_0/5v0_tgate_sel_2_sc_1/input_A 0
C966 5v0_addh_sc_tile_1/pti 5v0_addh_sc_tile_1/downstepper_test 0.19626f
C967 c_2_o 5v0_addh_sc_tile_1/pti 0.16959f
C968 in_3 5v0_addh_sc_tile_2/ctrl_over 0.1551f
C969 5v0_addh_sc_tile_0/5v0_half_adder_selector_sc_0/5v0_tgate_sel_2_sc_1/input_A in_0_sign 0
C970 VDD_3V3_0 5v0_addh_sc_tile_2/5v0_half_adder_selector_sc_0/5v0_tgate_sel_2_sc_1/input_A 0.02871f
C971 5v0_add_q_sc_0/5v0_half_adder_selector_sc_0/res_stage0 5v0_add_q_sc_0/5v0_half_adder_selector_sc_0/m1_n244_n517# 0.08646f
C972 5v0_addh_sc_tile_2/a_382_n1095# 5v0_addh_sc_tile_1/5v0_half_adder_selector_sc_0/res_stage0 0
C973 5v0_addh_sc_tile_1/downstepper_test m1_n2844_n810# 0
C974 5v0_nter2oter_code_sc_1/pti 5v0_addh_sc_tile_0/downstepper_test 0.00775f
C975 VDD_1V65_0 5v0_addh_sc_tile_0/pti 0.00234f
C976 5v0_addh_sc_tile_2/a_n1778_n454# 5v0_addh_sc_tile_2/inv_nti 0.00226f
C977 5v0_addh_sc_tile_1/m1_843_n857# 5v0_addh_sc_tile_1/m1_103_293# 0.20659f
C978 in_2 5v0_addh_sc_tile_1/ctrl_over 0.01618f
C979 5v0_add_q_sc_1/a_n1373_n454# 5v0_add_q_sc_1/pti 0
C980 5v0_addh_sc_tile_0/nti in_0_sign 0
C981 5v0_addh_sc_tile_1/inv_nti 5v0_addh_sc_tile_0/a_382_n1095# 0
C982 c_2_s VDD_1V65_2 0.00149f
C983 5v0_addh_sc_tile_1/nti 5v0_addh_sc_tile_1/a_n1205_n937# 0
C984 5v0_addh_sc_tile_1/5v0_half_adder_selector_sc_0/res_stage0 int_012 0.1871f
C985 5v0_addh_sc_tile_1/nti in_0_over 0.00205f
C986 5v0_addh_sc_tile_1/m1_843_n857# int_carry 0.00836f
C987 5v0_add_q_sc_0/inv_nti int_carry 0.02537f
C988 5v0_add_q_sc_0/upstepper_test 5v0_add_q_sc_0/nti 0.11981f
C989 5v0_addh_sc_tile_1/nti VDD_3V3_1 0.14047f
C990 5v0_nter2oter_code_sc_0/gf180mcu_fd_sc_mcu7t5v0__nor2_1_0/a_224_472# 5v0_addh_sc_tile_2/ctrl_over 0.0326f
C991 5v0_addh_sc_tile_1/nti 5v0_addh_sc_tile_0/m1_843_n857# 0
C992 5v0_add_q_sc_1/a_n1205_n937# VDD_3V3_1 0.00891f
C993 5v0_addh_sc_tile_1/m1_843_n857# 5v0_addh_sc_tile_1/inv_nti 0.36668f
C994 in_0_sign 5v0_addh_sc_tile_0/m1_103_293# 0.60072f
C995 5v0_addh_sc_tile_2/ctrl_over 5v0_addh_sc_tile_1/downstepper_test 0.01399f
C996 5v0_addh_sc_tile_2/5v0_half_adder_selector_sc_0/res_stage0 in_3 0.26626f
C997 5v0_add_q_sc_0/ctrl_over res_01 0
C998 in_3 5v0_nter2oter_code_sc_0/pti 0.00219f
C999 5v0_addh_sc_tile_2/5v0_half_adder_selector_sc_0/res_stage0 5v0_addh_sc_tile_2/ctrl_over 0.09179f
C1000 5v0_addh_sc_tile_1/pti 5v0_addh_sc_tile_0/m1_103_293# 0.00135f
C1001 5v0_addh_sc_tile_2/ctrl_over 5v0_nter2oter_code_sc_0/pti 0.00125f
C1002 5v0_add_q_sc_0/downstepper_test 5v0_add_q_sc_0/5v0_half_adder_selector_sc_0/m1_n244_n517# 0.00507f
C1003 5v0_addh_sc_tile_2/a_n1205_n937# VDD_1V65_4 0.00354f
C1004 5v0_addh_sc_tile_1/pti 5v0_add_q_sc_0/upstepper_test 0.0029f
C1005 5v0_add_q_sc_1/nti 5v0_addh_sc_tile_0/pti 0.00264f
C1006 5v0_addh_sc_tile_1/a_n1205_n937# 5v0_addh_sc_tile_1/ctrl_over 0.00169f
C1007 VDD_1V65_5 VDD_3V3_0 0.04709f
C1008 in_0_over 5v0_addh_sc_tile_1/ctrl_over 0
C1009 5v0_addh_sc_tile_0/m1_103_293# m1_n2844_n810# 0
C1010 res_01 5v0_add_q_sc_0/ctrl_sign 0.00787f
C1011 5v0_addh_sc_tile_1/nti 5v0_addh_sc_tile_1/a_n1373_n454# 0
C1012 VDD_3V3_1 5v0_addh_sc_tile_1/ctrl_over 0.02424f
C1013 5v0_add_q_sc_1/inv_pti 5v0_add_q_sc_1/upstepper_test 0.0467f
C1014 5v0_addh_sc_tile_1/ctrl_sign 5v0_add_q_sc_1/pti 0
C1015 5v0_add_q_sc_1/inv_pti 5v0_add_q_sc_1/5v0_half_adder_selector_sc_0/res_stage0 0
C1016 5v0_add_q_sc_0/a_n1778_n454# int_carry 0.00116f
C1017 in_2 int_012 0.00863f
C1018 c_2_s 5v0_addh_sc_tile_1/inv_pti 0.12531f
C1019 c_2_o 5v0_addh_sc_tile_1/downstepper_test 0
C1020 5v0_addh_sc_tile_2/upstepper_test 5v0_addh_sc_tile_2/m1_103_293# 0.07773f
C1021 c_2_s VDD_1V65_1 0
C1022 VDD_1V65_5 5v0_add_q_sc_0/pti 0.00115f
C1023 5v0_addh_sc_tile_0/m1_103_293# 5v0_addh_sc_tile_0/carry_sign_probe 0.21008f
C1024 5v0_addh_sc_tile_1/a_382_n1095# 5v0_add_q_sc_0/5v0_half_adder_selector_sc_0/m1_n244_n517# 0
C1025 5v0_addh_sc_tile_2/m1_843_n857# 5v0_addh_sc_tile_2/pti 0.11666f
C1026 VDD_3V3_0 5v0_addh_sc_tile_2/m1_103_293# 0.75958f
C1027 5v0_add_q_sc_0/downstepper_test 5v0_add_q_sc_0/a_n1373_n454# 0.00442f
C1028 5v0_addh_sc_tile_2/a_n1373_n454# VDD_1V65_4 0.00232f
C1029 5v0_addh_sc_tile_2/inv_pti 5v0_addh_sc_tile_2/inv_nti 0.2615f
C1030 5v0_addh_sc_tile_0/a_382_n1095# 5v0_addh_sc_tile_0/5v0_half_adder_selector_sc_0/res_stage0 0.08951f
C1031 5v0_add_q_sc_0/upstepper_test 5v0_addh_sc_tile_2/ctrl_over 0.00252f
C1032 in_2 in_1 0
C1033 5v0_addh_sc_tile_2/inv_pti 5v0_add_q_sc_0/ctrl_sign 0.10221f
C1034 5v0_addh_sc_tile_2/ctrl_sign in_2 0.0048f
C1035 5v0_addh_sc_tile_1/nti 5v0_addh_sc_tile_1/ctrl_sign 0.14557f
C1036 5v0_add_q_sc_1/5v0_half_adder_selector_sc_0/m1_n244_n517# 5v0_add_q_sc_1/5v0_half_adder_selector_sc_0/5v0_tgate_sel_2_sc_1/input_A 0.02928f
C1037 5v0_addh_sc_tile_0/nti 5v0_nter2oter_code_sc_0/pti 0
C1038 res_0 5v0_addh_sc_tile_2/pti 0
C1039 5v0_add_q_sc_1/inv_pti 5v0_add_q_sc_1/downstepper_test 0.07669f
C1040 5v0_add_q_sc_1/5v0_half_adder_selector_sc_0/m1_n244_n517# 5v0_add_q_sc_1/5v0_half_adder_selector_sc_0/res_stage0 0.08646f
C1041 5v0_addh_sc_tile_1/nti 5v0_addh_sc_tile_2/upstepper_test 0.00102f
C1042 5v0_addh_sc_tile_1/upstepper_test 5v0_addh_sc_tile_1/nti 0.11981f
C1043 5v0_add_q_sc_0/inv_pti 5v0_add_q_sc_0/nti 0.21873f
C1044 VDD_3V3_1 int_012 0.92139f
C1045 5v0_add_q_sc_0/ctrl_over int_carry 0.15164f
C1046 5v0_addh_sc_tile_0/a_382_n1095# 5v0_addh_sc_tile_0/carry_0_probe 0.08241f
C1047 5v0_addh_sc_tile_1/nti VDD_3V3_0 0.44319f
C1048 5v0_add_q_sc_1/5v0_half_adder_selector_sc_0/5v0_tgate_sel_2_sc_1/input_A VDD_3V3_1 0.02871f
C1049 5v0_add_q_sc_1/upstepper_test VDD_3V3_1 0.46215f
C1050 5v0_addh_sc_tile_1/a_382_n1095# 5v0_addh_sc_tile_1/5v0_half_adder_selector_sc_0/res_stage0 0.08951f
C1051 5v0_addh_sc_tile_0/a_382_n1095# 5v0_addh_sc_tile_0/downstepper_test 0.00679f
C1052 5v0_addh_sc_tile_2/inv_nti int_carry 0
C1053 5v0_addh_sc_tile_2/a_n1778_n454# VDD_1V65_4 0
C1054 5v0_add_q_sc_1/5v0_half_adder_selector_sc_0/res_stage0 VDD_3V3_1 0.14945f
C1055 c_2_o 5v0_add_q_sc_0/upstepper_test 0.01814f
C1056 5v0_addh_sc_tile_1/ctrl_sign 5v0_addh_sc_tile_1/ctrl_over 0.49329f
C1057 int_c01 5v0_add_q_sc_1/a_n1778_n454# 0.00116f
C1058 5v0_nter2oter_code_sc_1/pti 5v0_addh_sc_tile_2/ctrl_over 0
C1059 5v0_addh_sc_tile_0/inv_nti c_2_s 0.00142f
C1060 5v0_add_q_sc_0/inv_pti 5v0_addh_sc_tile_1/pti 0
C1061 5v0_add_q_sc_0/ctrl_sign int_carry 0.00264f
C1062 5v0_addh_sc_tile_1/inv_nti 5v0_addh_sc_tile_2/inv_nti 0
C1063 in_1 in_0_over 0.13684f
C1064 5v0_addh_sc_tile_2/upstepper_test 5v0_addh_sc_tile_1/ctrl_over 0
C1065 5v0_addh_sc_tile_1/upstepper_test 5v0_addh_sc_tile_1/ctrl_over 0.0043f
C1066 5v0_add_q_sc_1/a_n1373_n454# 5v0_add_q_sc_1/upstepper_test 0
C1067 in_1 VDD_3V3_1 1.00116f
C1068 5v0_add_q_sc_1/5v0_half_adder_selector_sc_0/m1_n244_n517# 5v0_add_q_sc_1/downstepper_test 0.00507f
C1069 5v0_addh_sc_tile_1/inv_nti 5v0_add_q_sc_0/ctrl_sign 0
C1070 in_1 5v0_addh_sc_tile_0/m1_843_n857# 0
C1071 5v0_addh_sc_tile_2/ctrl_sign VDD_3V3_1 0.00526f
C1072 5v0_addh_sc_tile_1/pti 5v0_addh_sc_tile_2/pti 0
C1073 VDD_3V3_0 5v0_addh_sc_tile_1/ctrl_over 1.20698f
C1074 5v0_add_q_sc_0/ctrl_over res_c 0.20136f
C1075 5v0_add_q_sc_1/nti 5v0_addh_sc_tile_1/m1_103_293# 0.00685f
C1076 5v0_add_q_sc_1/downstepper_test in_0_over 0
C1077 int_c01 5v0_add_q_sc_1/5v0_half_adder_selector_sc_0/m1_n239_179# 0.00189f
C1078 5v0_add_q_sc_1/inv_pti 5v0_addh_sc_tile_1/a_382_n1095# 0
C1079 5v0_addh_sc_tile_2/a_n1205_n937# 5v0_addh_sc_tile_2/downstepper_test 0.00453f
C1080 5v0_add_q_sc_1/downstepper_test VDD_3V3_1 0.52531f
C1081 5v0_add_q_sc_1/nti int_carry 0
C1082 5v0_addh_sc_tile_1/pti 5v0_add_q_sc_0/5v0_half_adder_selector_sc_0/m1_n239_179# 0
C1083 5v0_nter2oter_code_sc_1/pti 5v0_nter2oter_code_sc_0/pti 0.20957f
C1084 5v0_add_q_sc_1/inv_pti 5v0_add_q_sc_1/inv_nti 0.08256f
C1085 5v0_addh_sc_tile_0/pti c_2_s 0.00768f
C1086 5v0_add_q_sc_0/ctrl_sign res_c 0
C1087 5v0_add_q_sc_0/pti 5v0_addh_sc_tile_1/ctrl_over 0.00209f
C1088 5v0_addh_sc_tile_0/a_n1205_n937# in_0_over 0
C1089 5v0_add_q_sc_0/inv_pti 5v0_addh_sc_tile_2/ctrl_over 0
C1090 5v0_add_q_sc_1/nti 5v0_addh_sc_tile_1/inv_nti 0
C1091 5v0_add_q_sc_0/5v0_half_adder_selector_sc_0/5v0_tgate_sel_2_sc_1/input_A 5v0_add_q_sc_0/5v0_half_adder_selector_sc_0/m1_n244_n517# 0.02928f
C1092 in_1 5v0_addh_sc_tile_0/inv_pti 0.05631f
C1093 5v0_add_q_sc_1/a_n1373_n454# 5v0_add_q_sc_1/downstepper_test 0.00442f
C1094 5v0_addh_sc_tile_0/a_n1205_n937# VDD_3V3_1 0.00891f
C1095 in_3 5v0_addh_sc_tile_2/pti 0.66373f
C1096 5v0_addh_sc_tile_1/ctrl_sign int_012 0.01034f
C1097 5v0_addh_sc_tile_2/ctrl_over 5v0_addh_sc_tile_2/pti 0.16185f
C1098 5v0_addh_sc_tile_0/nti 5v0_nter2oter_code_sc_1/pti 0
C1099 5v0_addh_sc_tile_1/upstepper_test int_012 0.00268f
C1100 VDD_3V3_0 5v0_addh_sc_tile_2/a_382_n1095# 0.66129f
C1101 5v0_addh_sc_tile_1/m1_843_n857# 5v0_add_q_sc_0/nti 0
C1102 5v0_addh_sc_tile_0/a_382_n1095# in_0_sign 0.07412f
C1103 5v0_addh_sc_tile_2/a_n1205_n937# 5v0_addh_sc_tile_2/nti 0
C1104 5v0_addh_sc_tile_2/a_n1373_n454# 5v0_addh_sc_tile_2/downstepper_test 0.00442f
C1105 5v0_add_q_sc_0/inv_nti 5v0_add_q_sc_0/nti 0.20874f
C1106 5v0_addh_sc_tile_2/inv_pti VDD_1V65_4 0.14775f
C1107 5v0_addh_sc_tile_1/pti 5v0_addh_sc_tile_0/a_382_n1095# 0.00485f
C1108 VDD_3V3_0 int_012 2.39715f
C1109 c_2_o 5v0_add_q_sc_0/inv_pti 0.00278f
C1110 5v0_addh_sc_tile_2/ctrl_over 5v0_add_q_sc_0/5v0_half_adder_selector_sc_0/m1_n239_179# 0.00716f
C1111 5v0_addh_sc_tile_1/pti 5v0_add_q_sc_1/a_n1778_n454# 0
C1112 in_1 5v0_addh_sc_tile_1/ctrl_sign 0.01394f
C1113 5v0_addh_sc_tile_2/ctrl_sign 5v0_addh_sc_tile_1/ctrl_sign 0.036f
C1114 5v0_addh_sc_tile_0/a_382_n1095# m1_n2844_n810# 0.04011f
C1115 5v0_addh_sc_tile_1/a_382_n1095# VDD_3V3_1 0.02507f
C1116 5v0_addh_sc_tile_0/a_n1373_n454# VDD_3V3_1 0.00122f
C1117 in_0_over 5v0_add_q_sc_1/inv_nti 0.00113f
C1118 5v0_addh_sc_tile_2/5v0_half_adder_selector_sc_0/res_stage0 5v0_addh_sc_tile_2/pti 0.00979f
C1119 5v0_addh_sc_tile_1/m1_843_n857# 5v0_addh_sc_tile_1/pti 0.11666f
C1120 5v0_addh_sc_tile_2/ctrl_sign 5v0_addh_sc_tile_1/upstepper_test 0
C1121 5v0_nter2oter_code_sc_0/pti 5v0_addh_sc_tile_2/pti 0
C1122 5v0_addh_sc_tile_2/ctrl_sign 5v0_addh_sc_tile_2/upstepper_test 0.15846f
C1123 VDD_3V3_1 5v0_add_q_sc_1/inv_nti 0.56275f
C1124 5v0_add_q_sc_1/downstepper_test 5v0_addh_sc_tile_1/ctrl_sign 0.00227f
C1125 VDD_3V3_0 5v0_add_q_sc_0/5v0_half_adder_selector_sc_0/res_stage0 0.16909f
C1126 5v0_addh_sc_tile_2/a_n1778_n454# 5v0_addh_sc_tile_2/downstepper_test 0.0031f
C1127 5v0_addh_sc_tile_2/a_n1373_n454# 5v0_addh_sc_tile_2/nti 0
C1128 5v0_addh_sc_tile_2/ctrl_sign VDD_3V3_0 1.61336f
C1129 5v0_add_q_sc_0/a_n1778_n454# 5v0_add_q_sc_0/nti 0.00142f
C1130 5v0_addh_sc_tile_1/inv_pti 5v0_addh_sc_tile_1/5v0_half_adder_selector_sc_0/res_stage0 0.01365f
C1131 VDD_1V65_0 5v0_addh_sc_tile_0/downstepper_test 0.13024f
C1132 5v0_addh_sc_tile_0/a_382_n1095# 5v0_addh_sc_tile_0/carry_sign_probe 0.02324f
C1133 5v0_add_q_sc_1/a_n1373_n454# 5v0_add_q_sc_1/inv_nti 0
C1134 VDD_1V65_5 5v0_addh_sc_tile_1/ctrl_over 0
C1135 5v0_add_q_sc_0/ctrl_over 5v0_addh_sc_tile_2/m1_843_n857# 0.17802f
C1136 5v0_addh_sc_tile_2/a_382_n1095# 5v0_addh_sc_tile_2/5v0_half_adder_selector_sc_0/5v0_tgate_sel_2_sc_1/input_A 0.02928f
C1137 5v0_addh_sc_tile_1/nti 5v0_addh_sc_tile_2/m1_103_293# 0.00116f
C1138 in_2 5v0_nter2oter_code_sc_1/nti 0.19929f
C1139 5v0_addh_sc_tile_0/a_n1373_n454# 5v0_addh_sc_tile_0/inv_pti 0.00135f
C1140 5v0_addh_sc_tile_2/m1_843_n857# 5v0_addh_sc_tile_2/inv_nti 0.36668f
C1141 5v0_add_q_sc_0/inv_pti 5v0_add_q_sc_0/upstepper_test 0.0467f
C1142 5v0_addh_sc_tile_2/m1_843_n857# 5v0_add_q_sc_0/ctrl_sign 0.00871f
C1143 5v0_add_q_sc_0/ctrl_over res_0 0
C1144 c_2_s 5v0_addh_sc_tile_1/m1_103_293# 0.22665f
C1145 VDD_1V65_0 5v0_addh_sc_tile_0/upstepper_test 0.16859f
C1146 VDD_3V3_0 5v0_add_q_sc_0/downstepper_test 0.55841f
C1147 5v0_add_q_sc_0/upstepper_test 5v0_addh_sc_tile_2/pti 0
C1148 5v0_addh_sc_tile_2/a_n1778_n454# 5v0_addh_sc_tile_2/nti 0.00142f
C1149 5v0_add_q_sc_1/nti 5v0_addh_sc_tile_0/carry_0_probe 0.11161f
C1150 res_0 5v0_addh_sc_tile_2/inv_nti 0.01449f
C1151 int_c01 5v0_add_q_sc_1/nti 0.68929f
C1152 5v0_addh_sc_tile_2/m1_103_293# 5v0_addh_sc_tile_1/ctrl_over 0
C1153 5v0_add_q_sc_1/inv_pti VDD_1V65_1 0.14775f
C1154 c_2_s int_carry 0.00413f
C1155 VDD_3V3_1 VDD_1V65_2 0.01209f
C1156 5v0_add_q_sc_0/ctrl_over 5v0_add_q_sc_0/nti 0.00167f
C1157 in_2 5v0_addh_sc_tile_1/inv_pti 0
C1158 5v0_addh_sc_tile_1/a_382_n1095# 5v0_addh_sc_tile_1/ctrl_sign 0.07412f
C1159 5v0_addh_sc_tile_2/ctrl_sign 5v0_addh_sc_tile_2/5v0_half_adder_selector_sc_0/5v0_tgate_sel_2_sc_1/input_A 0
C1160 5v0_addh_sc_tile_1/inv_nti c_2_s 0.05407f
C1161 5v0_addh_sc_tile_0/a_382_n1095# 5v0_addh_sc_tile_0/5v0_half_adder_selector_sc_0/5v0_tgate_sel_2_sc_1/input_A 0.02928f
C1162 5v0_add_q_sc_0/pti 5v0_add_q_sc_0/downstepper_test 0.0825f
C1163 c_2_o 5v0_add_q_sc_0/inv_nti 0
C1164 5v0_addh_sc_tile_1/ctrl_sign 5v0_add_q_sc_1/inv_nti 0
C1165 5v0_addh_sc_tile_1/m1_843_n857# c_2_o 0.18406f
C1166 5v0_add_q_sc_0/upstepper_test 5v0_add_q_sc_0/5v0_half_adder_selector_sc_0/m1_n239_179# 0.07502f
C1167 5v0_nter2oter_code_sc_1/nti VDD_3V3_1 0.0701f
C1168 5v0_addh_sc_tile_0/nti 5v0_addh_sc_tile_0/a_382_n1095# 0
C1169 5v0_add_q_sc_0/ctrl_sign 5v0_add_q_sc_0/nti 0
C1170 VDD_3V3_0 5v0_addh_sc_tile_1/a_382_n1095# 0.61115f
C1171 5v0_addh_sc_tile_2/inv_pti 5v0_addh_sc_tile_2/downstepper_test 0.13388f
C1172 5v0_nter2oter_code_sc_1/pti 5v0_addh_sc_tile_2/pti 0.00125f
C1173 5v0_add_q_sc_0/a_n1205_n937# VDD_3V3_0 0.00891f
C1174 5v0_addh_sc_tile_1/nti 5v0_addh_sc_tile_1/ctrl_over 0.0773f
C1175 c_2_o 5v0_add_q_sc_1/5v0_half_adder_selector_sc_0/m1_n239_179# 0.00258f
C1176 5v0_addh_sc_tile_0/a_382_n1095# 5v0_addh_sc_tile_0/m1_103_293# 0.07764f
C1177 5v0_addh_sc_tile_2/a_382_n1095# 5v0_addh_sc_tile_2/m1_103_293# 0.07764f
C1178 5v0_addh_sc_tile_1/inv_pti in_0_over 0.00926f
C1179 5v0_add_q_sc_0/pti 5v0_addh_sc_tile_1/a_382_n1095# 0
C1180 5v0_addh_sc_tile_1/pti 5v0_add_q_sc_0/ctrl_sign 0
C1181 VDD_3V3_1 5v0_addh_sc_tile_1/inv_pti 0.81122f
C1182 5v0_addh_sc_tile_2/m1_103_293# int_012 0.00332f
C1183 5v0_addh_sc_tile_0/m1_843_n857# 5v0_addh_sc_tile_1/inv_pti 0.00739f
C1184 5v0_addh_sc_tile_1/upstepper_test 5v0_addh_sc_tile_1/a_n1778_n454# 0
C1185 VDD_1V65_2 VSS_3 0.07318f
C1186 5v0_addh_sc_tile_2/pti VSS_3 1.17571f
C1187 VDD_1V65_4 VSS_3 0.09068f
C1188 5v0_addh_sc_tile_2/inv_nti VSS_3 1.3751f
C1189 5v0_addh_sc_tile_2/m1_843_n857# VSS_3 0.16265f ; **FLOATING
C1190 5v0_addh_sc_tile_2/ctrl_sign VSS_3 1.27243f
C1191 5v0_addh_sc_tile_2/a_n1205_n937# VSS_3 0 ; **FLOATING
C1192 5v0_addh_sc_tile_2/a_n1373_n454# VSS_3 0.00335f ; **FLOATING
C1193 5v0_addh_sc_tile_2/a_n1778_n454# VSS_3 0.00573f ; **FLOATING
C1194 5v0_addh_sc_tile_2/inv_pti VSS_3 0.92511f
C1195 5v0_addh_sc_tile_2/5v0_half_adder_selector_sc_0/5v0_tgate_sel_2_sc_1/input_A VSS_3 0
C1196 5v0_addh_sc_tile_2/a_382_n1095# VSS_3 0.83941f ; **FLOATING
C1197 in_3 VSS_3 1.64882f
C1198 res_0 VSS_3 0.02768f
C1199 5v0_addh_sc_tile_2/ctrl_over VSS_3 0.80165f
C1200 5v0_addh_sc_tile_2/m1_103_293# VSS_3 0.74864f ; **FLOATING
C1201 5v0_addh_sc_tile_2/5v0_half_adder_selector_sc_0/res_stage0 VSS_3 0.50069f
C1202 5v0_addh_sc_tile_2/downstepper_test VSS_3 0.58281f
C1203 5v0_addh_sc_tile_2/upstepper_test VSS_3 0.53687f
C1204 5v0_addh_sc_tile_2/nti VSS_3 1.2554f
C1205 5v0_addh_sc_tile_1/pti VSS_3 1.17421f
C1206 VDD_1V65_3 VSS_3 0.09068f
C1207 5v0_addh_sc_tile_1/inv_nti VSS_3 1.35629f
C1208 5v0_addh_sc_tile_1/m1_843_n857# VSS_3 0.15965f ; **FLOATING
C1209 5v0_addh_sc_tile_1/ctrl_sign VSS_3 1.3078f
C1210 5v0_addh_sc_tile_1/a_n1205_n937# VSS_3 0 ; **FLOATING
C1211 5v0_addh_sc_tile_1/a_n1373_n454# VSS_3 0.00335f ; **FLOATING
C1212 5v0_addh_sc_tile_1/a_n1778_n454# VSS_3 0.00573f ; **FLOATING
C1213 5v0_addh_sc_tile_1/inv_pti VSS_3 0.92626f
C1214 VDD_3V3_1 VSS_3 38.76431f
C1215 5v0_addh_sc_tile_1/5v0_half_adder_selector_sc_0/5v0_tgate_sel_2_sc_1/input_A VSS_3 0
C1216 5v0_addh_sc_tile_1/a_382_n1095# VSS_3 0.81445f ; **FLOATING
C1217 res_01 VSS_3 1.54805f
C1218 int_012 VSS_3 1.10181f
C1219 5v0_addh_sc_tile_1/ctrl_over VSS_3 0.79116f
C1220 5v0_addh_sc_tile_1/m1_103_293# VSS_3 0.74864f ; **FLOATING
C1221 5v0_addh_sc_tile_1/5v0_half_adder_selector_sc_0/res_stage0 VSS_3 0.50069f
C1222 5v0_addh_sc_tile_1/downstepper_test VSS_3 0.58281f
C1223 5v0_addh_sc_tile_1/upstepper_test VSS_3 0.53687f
C1224 5v0_addh_sc_tile_1/nti VSS_3 1.26884f
C1225 5v0_addh_sc_tile_0/pti VSS_3 1.17947f
C1226 VDD_1V65_0 VSS_3 0.09068f
C1227 5v0_addh_sc_tile_0/inv_nti VSS_3 1.36063f
C1228 5v0_addh_sc_tile_0/m1_843_n857# VSS_3 0.15969f ; **FLOATING
C1229 in_0_sign VSS_3 0.87016f
C1230 5v0_addh_sc_tile_0/a_n1205_n937# VSS_3 0 ; **FLOATING
C1231 5v0_addh_sc_tile_0/a_n1373_n454# VSS_3 0.00335f ; **FLOATING
C1232 5v0_addh_sc_tile_0/a_n1778_n454# VSS_3 0.00573f ; **FLOATING
C1233 5v0_addh_sc_tile_0/inv_pti VSS_3 0.92409f
C1234 5v0_addh_sc_tile_0/carry_sign_probe VSS_3 0.24862f
C1235 5v0_addh_sc_tile_0/carry_0_probe VSS_3 0.62839f
C1236 5v0_addh_sc_tile_0/5v0_half_adder_selector_sc_0/5v0_tgate_sel_2_sc_1/input_A VSS_3 0
C1237 5v0_addh_sc_tile_0/a_382_n1095# VSS_3 0.81488f ; **FLOATING
C1238 in_1 VSS_3 1.70172f
C1239 in_0_over VSS_3 0.49348f
C1240 5v0_addh_sc_tile_0/m1_103_293# VSS_3 0.74828f ; **FLOATING
C1241 5v0_addh_sc_tile_0/5v0_half_adder_selector_sc_0/res_stage0 VSS_3 0.50069f
C1242 5v0_addh_sc_tile_0/downstepper_test VSS_3 0.58464f
C1243 5v0_addh_sc_tile_0/upstepper_test VSS_3 0.53687f
C1244 5v0_addh_sc_tile_0/nti VSS_3 1.25562f
C1245 in_2 VSS_3 0.95085f
C1246 5v0_nter2oter_code_sc_1/pti VSS_3 0.62525f
C1247 5v0_nter2oter_code_sc_1/nti VSS_3 0.65963f
C1248 5v0_nter2oter_code_sc_1/gf180mcu_fd_sc_mcu7t5v0__nor2_1_0/a_224_472# VSS_3 0 ; **FLOATING
C1249 5v0_nter2oter_code_sc_0/pti VSS_3 0.61125f
C1250 5v0_nter2oter_code_sc_0/nti VSS_3 0.66288f
C1251 5v0_nter2oter_code_sc_0/gf180mcu_fd_sc_mcu7t5v0__nor2_1_0/a_224_472# VSS_3 0 ; **FLOATING
C1252 5v0_add_q_sc_1/pti VSS_3 0.59838f
C1253 VDD_1V65_1 VSS_3 0.09068f
C1254 5v0_add_q_sc_1/inv_nti VSS_3 0.53562f
C1255 5v0_add_q_sc_1/inv_pti VSS_3 0.59603f
C1256 5v0_add_q_sc_1/a_n1205_n937# VSS_3 0 ; **FLOATING
C1257 5v0_add_q_sc_1/a_n1373_n454# VSS_3 0.00335f ; **FLOATING
C1258 5v0_add_q_sc_1/a_n1778_n454# VSS_3 0.00573f ; **FLOATING
C1259 5v0_add_q_sc_1/5v0_half_adder_selector_sc_0/5v0_tgate_sel_2_sc_1/input_A VSS_3 0
C1260 5v0_add_q_sc_1/5v0_half_adder_selector_sc_0/m1_n244_n517# VSS_3 0.29628f ; **FLOATING
C1261 int_c01 VSS_3 1.92885f
C1262 c_2_o VSS_3 0.97319f
C1263 5v0_add_q_sc_1/5v0_half_adder_selector_sc_0/m1_n239_179# VSS_3 0.29901f ; **FLOATING
C1264 5v0_add_q_sc_1/5v0_half_adder_selector_sc_0/res_stage0 VSS_3 0.50836f
C1265 5v0_add_q_sc_1/downstepper_test VSS_3 0.63842f
C1266 c_2_s VSS_3 1.02067f
C1267 5v0_add_q_sc_1/upstepper_test VSS_3 0.5468f
C1268 5v0_add_q_sc_1/nti VSS_3 1.26615f
C1269 5v0_add_q_sc_0/pti VSS_3 0.59945f
C1270 VDD_1V65_5 VSS_3 0.09068f
C1271 5v0_add_q_sc_0/inv_nti VSS_3 0.53562f
C1272 5v0_add_q_sc_0/inv_pti VSS_3 0.59603f
C1273 5v0_add_q_sc_0/a_n1205_n937# VSS_3 0 ; **FLOATING
C1274 5v0_add_q_sc_0/a_n1373_n454# VSS_3 0.00335f ; **FLOATING
C1275 5v0_add_q_sc_0/a_n1778_n454# VSS_3 0.00573f ; **FLOATING
C1276 5v0_add_q_sc_0/5v0_half_adder_selector_sc_0/5v0_tgate_sel_2_sc_1/input_A VSS_3 0
C1277 5v0_add_q_sc_0/5v0_half_adder_selector_sc_0/m1_n244_n517# VSS_3 0.29628f ; **FLOATING
C1278 int_carry VSS_3 2.49654f
C1279 res_c VSS_3 0.0293f
C1280 5v0_add_q_sc_0/ctrl_over VSS_3 0.73852f
C1281 5v0_add_q_sc_0/5v0_half_adder_selector_sc_0/m1_n239_179# VSS_3 0.29907f ; **FLOATING
C1282 5v0_add_q_sc_0/5v0_half_adder_selector_sc_0/res_stage0 VSS_3 0.50905f
C1283 5v0_add_q_sc_0/downstepper_test VSS_3 0.64239f
C1284 5v0_add_q_sc_0/ctrl_sign VSS_3 0.49276f
C1285 VDD_3V3_0 VSS_3 47.31763f
C1286 5v0_add_q_sc_0/upstepper_test VSS_3 0.54953f
C1287 5v0_add_q_sc_0/nti VSS_3 1.27003f
C1288 m1_n2844_n810# VSS_3 0.48934f ; **FLOATING
