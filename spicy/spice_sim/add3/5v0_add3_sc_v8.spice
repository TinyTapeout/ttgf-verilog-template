* NGSPICE file created from 5v0_add3_sc.ext - technology: gf180mcuD

.option scale=5n

X0 int_c01 m1_n2844_n810# c01 VSS_3 nfet_06v0 ad=14.432n pd=0.504m as=14.432n ps=0.504m w=164 l=120
X1 VDD_1V65_2 5v0_addh_sc_tile_0/carry_0_probe int_c01 VSS_3 nfet_06v0 ad=14.432n pd=0.504m as=14.432n ps=0.504m w=164 l=120
X2 5v0_add_q_sc_0/pti int_carry VSS_3 VSS_3 nfet_06v0 ad=6.336n pd=0.32m as=6.478n ps=0.255m w=72 l=578
X3 VDD_3V3_0 int_carry 5v0_add_q_sc_0/pti VDD_3V3_0 pfet_06v0 ad=12.81n pd=0.349m as=12.688n ps=0.348m w=244 l=100
X4 VDD_3V3_0 int_carry 5v0_add_q_sc_0/nti VDD_3V3_0 pfet_06v0 ad=13.616n pd=0.392m as=9.696n ps=0.394m w=96 l=150
X5 VSS_3 int_carry 5v0_add_q_sc_0/nti VSS_3 nfet_06v0 ad=6.478n pd=0.255m as=12.7n ps=0.454m w=127 l=120
X6 5v0_add_q_sc_0/pti int_carry VDD_3V3_0 VDD_3V3_0 pfet_06v0 ad=12.688n pd=0.348m as=13.616n ps=0.392m w=244 l=100
X7 5v0_add_q_sc_0/pti int_carry VDD_3V3_0 VDD_3V3_0 pfet_06v0 ad=27.328n pd=0.712m as=12.81n ps=0.349m w=244 l=100
X8 5v0_add_q_sc_0/5v0_half_adder_selector_sc_0/res_stage0 5v0_add_q_sc_0/5v0_half_adder_selector_sc_0/m1_n239_179# 5v0_add_q_sc_0/downstepper_test VSS_3 nfet_06v0 ad=14.432n pd=0.504m as=14.432n ps=0.504m w=164 l=120
X9 5v0_add_q_sc_0/5v0_half_adder_selector_sc_0/res_stage0 5v0_add_q_sc_0/5v0_half_adder_selector_sc_0/m1_n239_179# 5v0_add_q_sc_0/upstepper_test VDD_3V3_0 pfet_06v0 ad=21.472n pd=0.664m as=21.472n ps=0.664m w=244 l=100
X10 5v0_add_q_sc_0/5v0_half_adder_selector_sc_0/m1_n239_179# 5v0_add_q_sc_0/ctrl_sign VSS_3 VSS_3 nfet_06v0 ad=14.432n pd=0.504m as=14.432n ps=0.504m w=164 l=120
X11 5v0_add_q_sc_0/5v0_half_adder_selector_sc_0/m1_n239_179# 5v0_add_q_sc_0/ctrl_sign VDD_3V3_0 VDD_3V3_0 pfet_06v0 ad=21.472n pd=0.664m as=21.472n ps=0.664m w=244 l=100
X12 5v0_add_q_sc_0/5v0_half_adder_selector_sc_0/res_stage0 5v0_add_q_sc_0/ctrl_sign 5v0_add_q_sc_0/upstepper_test VSS_3 nfet_06v0 ad=31.489n pd=1.041m as=43.711n ps=1.504m w=164 l=120
X13 5v0_add_q_sc_0/5v0_half_adder_selector_sc_0/res_stage0 5v0_add_q_sc_0/ctrl_sign 5v0_add_q_sc_0/downstepper_test VDD_3V3_0 pfet_06v0 ad=46.849n pd=1.361m as=42.856n ps=1.326m w=244 l=100
X14 res_c 5v0_add_q_sc_0/5v0_half_adder_selector_sc_0/m1_n244_n517# 5v0_add_q_sc_0/5v0_half_adder_selector_sc_0/res_stage0 VSS_3 nfet_06v0 ad=17.057n pd=0.537m as=0 ps=0 w=164 l=120
X15 res_c 5v0_add_q_sc_0/5v0_half_adder_selector_sc_0/m1_n244_n517# int_carry VDD_3V3_0 pfet_06v0 ad=25.377n pd=0.697m as=46.849n ps=1.361m w=244 l=100
X16 5v0_add_q_sc_0/5v0_half_adder_selector_sc_0/m1_n244_n517# 5v0_add_q_sc_0/ctrl_over VSS_3 VSS_3 nfet_06v0 ad=14.432n pd=0.504m as=0.59241u ps=0.02092 w=164 l=120
X17 5v0_add_q_sc_0/5v0_half_adder_selector_sc_0/m1_n244_n517# 5v0_add_q_sc_0/ctrl_over VDD_3V3_0 VDD_3V3_0 pfet_06v0 ad=21.472n pd=0.664m as=0.50045u ps=0.0145 w=244 l=100
X18 res_c 5v0_add_q_sc_0/ctrl_over int_carry VSS_3 nfet_06v0 ad=0 pd=0 as=31.489n ps=1.041m w=164 l=120
X19 res_c 5v0_add_q_sc_0/ctrl_over 5v0_add_q_sc_0/5v0_half_adder_selector_sc_0/res_stage0 VDD_3V3_0 pfet_06v0 ad=0 pd=0 as=0 ps=0 w=244 l=100
X20 5v0_add_q_sc_0/inv_pti 5v0_add_q_sc_0/pti VSS_3 VSS_3 nfet_06v0 ad=14.432n pd=0.504m as=14.432n ps=0.504m w=164 l=120
X21 5v0_add_q_sc_0/inv_pti 5v0_add_q_sc_0/pti VDD_3V3_0 VDD_3V3_0 pfet_06v0 ad=21.472n pd=0.664m as=21.472n ps=0.664m w=244 l=100
X22 5v0_add_q_sc_0/a_n1373_n454# 5v0_add_q_sc_0/inv_nti 5v0_add_q_sc_0/downstepper_test VSS_3 nfet_06v0 ad=3.528n pd=0.195m as=8.599n ps=0.264m w=147 l=120
X23 5v0_add_q_sc_0/upstepper_test 5v0_add_q_sc_0/nti 5v0_add_q_sc_0/a_n1205_n937# VDD_3V3_0 pfet_06v0 ad=21.384n pd=0.662m as=5.832n ps=0.291m w=243 l=100
X24 5v0_add_q_sc_0/inv_nti 5v0_add_q_sc_0/nti VDD_3V3_0 VDD_3V3_0 pfet_06v0 ad=21.472n pd=0.664m as=21.472n ps=0.664m w=244 l=100
X25 5v0_add_q_sc_0/upstepper_test 5v0_add_q_sc_0/nti VDD_1V65_5 VSS_3 nfet_06v0 ad=14.847n pd=0.496m as=10.51n ps=0.29m w=147 l=120
X26 5v0_add_q_sc_0/a_n1205_n937# 5v0_add_q_sc_0/inv_pti VDD_3V3_0 VDD_3V3_0 pfet_06v0 ad=5.832n pd=0.291m as=21.384n ps=0.662m w=243 l=100
X27 5v0_add_q_sc_0/downstepper_test 5v0_add_q_sc_0/pti 5v0_add_q_sc_0/a_n1778_n454# VSS_3 nfet_06v0 ad=8.599n pd=0.264m as=3.528n ps=0.195m w=147 l=120
X28 5v0_add_q_sc_0/inv_nti 5v0_add_q_sc_0/nti VSS_3 VSS_3 nfet_06v0 ad=14.432n pd=0.504m as=14.432n ps=0.504m w=164 l=120
X29 5v0_add_q_sc_0/a_n1778_n454# 5v0_add_q_sc_0/inv_nti VSS_3 VSS_3 nfet_06v0 ad=3.528n pd=0.195m as=14.847n ps=0.496m w=147 l=120
X30 5v0_add_q_sc_0/upstepper_test 5v0_add_q_sc_0/inv_pti VSS_3 VSS_3 nfet_06v0 ad=14.432n pd=0.504m as=14.432n ps=0.504m w=164 l=120
X31 VDD_1V65_5 5v0_add_q_sc_0/inv_pti 5v0_add_q_sc_0/a_n1373_n454# VSS_3 nfet_06v0 ad=10.51n pd=0.29m as=3.528n ps=0.195m w=147 l=120
X32 5v0_add_q_sc_0/downstepper_test 5v0_add_q_sc_0/inv_nti VDD_3V3_0 VDD_3V3_0 pfet_06v0 ad=21.384n pd=0.662m as=21.384n ps=0.662m w=243 l=100
X33 5v0_add_q_sc_1/pti int_c01 VSS_3 VSS_3 nfet_06v0 ad=6.336n pd=0.32m as=0 ps=0 w=72 l=578
X34 VDD_3V3_1 int_c01 5v0_add_q_sc_1/pti VDD_3V3_1 pfet_06v0 ad=0.54021u pd=0.01553 as=52.704n ps=1.408m w=244 l=100
X35 VDD_3V3_1 int_c01 5v0_add_q_sc_1/nti VDD_3V3_1 pfet_06v0 ad=0 pd=0 as=9.696n ps=0.394m w=96 l=150
X36 VSS_3 int_c01 5v0_add_q_sc_1/nti VSS_3 nfet_06v0 ad=0 pd=0 as=12.7n ps=0.454m w=127 l=120
X37 5v0_add_q_sc_1/pti int_c01 VDD_3V3_1 VDD_3V3_1 pfet_06v0 ad=0 pd=0 as=0 ps=0 w=244 l=100
X38 5v0_add_q_sc_1/pti int_c01 VDD_3V3_1 VDD_3V3_1 pfet_06v0 ad=0 pd=0 as=0 ps=0 w=244 l=100
X39 5v0_add_q_sc_1/5v0_half_adder_selector_sc_0/res_stage0 5v0_add_q_sc_1/5v0_half_adder_selector_sc_0/m1_n239_179# 5v0_add_q_sc_1/downstepper_test VSS_3 nfet_06v0 ad=31.489n pd=1.041m as=31.631n ps=1.032m w=164 l=120
X40 5v0_add_q_sc_1/5v0_half_adder_selector_sc_0/res_stage0 5v0_add_q_sc_1/5v0_half_adder_selector_sc_0/m1_n239_179# 5v0_add_q_sc_1/upstepper_test VDD_3V3_1 pfet_06v0 ad=46.849n pd=1.361m as=42.856n ps=1.326m w=244 l=100
X41 5v0_add_q_sc_1/5v0_half_adder_selector_sc_0/m1_n239_179# c_2_s VSS_3 VSS_3 nfet_06v0 ad=14.432n pd=0.504m as=0 ps=0 w=164 l=120
X42 5v0_add_q_sc_1/5v0_half_adder_selector_sc_0/m1_n239_179# c_2_s VDD_3V3_1 VDD_3V3_1 pfet_06v0 ad=21.472n pd=0.664m as=0 ps=0 w=244 l=100
X43 5v0_add_q_sc_1/5v0_half_adder_selector_sc_0/res_stage0 c_2_s 5v0_add_q_sc_1/upstepper_test VSS_3 nfet_06v0 ad=0 pd=0 as=43.711n ps=1.504m w=164 l=120
X44 5v0_add_q_sc_1/5v0_half_adder_selector_sc_0/res_stage0 c_2_s 5v0_add_q_sc_1/downstepper_test VDD_3V3_1 pfet_06v0 ad=0 pd=0 as=42.856n ps=1.326m w=244 l=100
X45 int_carry 5v0_add_q_sc_1/5v0_half_adder_selector_sc_0/m1_n244_n517# 5v0_add_q_sc_1/5v0_half_adder_selector_sc_0/res_stage0 VSS_3 nfet_06v0 ad=0 pd=0 as=0 ps=0 w=164 l=120
X46 int_carry 5v0_add_q_sc_1/5v0_half_adder_selector_sc_0/m1_n244_n517# int_c01 VDD_3V3_1 pfet_06v0 ad=0 pd=0 as=42.946n ps=1.33m w=244 l=100
X47 5v0_add_q_sc_1/5v0_half_adder_selector_sc_0/m1_n244_n517# c_2_o VSS_3 VSS_3 nfet_06v0 ad=14.432n pd=0.504m as=0 ps=0 w=164 l=120
X48 5v0_add_q_sc_1/5v0_half_adder_selector_sc_0/m1_n244_n517# c_2_o VDD_3V3_1 VDD_3V3_1 pfet_06v0 ad=21.472n pd=0.664m as=0 ps=0 w=244 l=100
X49 int_carry c_2_o int_c01 VSS_3 nfet_06v0 ad=0 pd=0 as=31.489n ps=1.041m w=164 l=120
X50 int_carry c_2_o 5v0_add_q_sc_1/5v0_half_adder_selector_sc_0/res_stage0 VDD_3V3_1 pfet_06v0 ad=0 pd=0 as=0 ps=0 w=244 l=100
X51 5v0_add_q_sc_1/inv_pti 5v0_add_q_sc_1/pti VSS_3 VSS_3 nfet_06v0 ad=14.432n pd=0.504m as=0 ps=0 w=164 l=120
X52 5v0_add_q_sc_1/inv_pti 5v0_add_q_sc_1/pti VDD_3V3_1 VDD_3V3_1 pfet_06v0 ad=21.472n pd=0.664m as=0 ps=0 w=244 l=100
X53 5v0_add_q_sc_1/a_n1373_n454# 5v0_add_q_sc_1/inv_nti 5v0_add_q_sc_1/downstepper_test VSS_3 nfet_06v0 ad=7.056n pd=0.39m as=0 ps=0 w=147 l=120
X54 5v0_add_q_sc_1/upstepper_test 5v0_add_q_sc_1/nti 5v0_add_q_sc_1/a_n1205_n937# VDD_3V3_1 pfet_06v0 ad=0 pd=0 as=11.664n ps=0.582m w=243 l=100
X55 5v0_add_q_sc_1/inv_nti 5v0_add_q_sc_1/nti VDD_3V3_1 VDD_3V3_1 pfet_06v0 ad=21.472n pd=0.664m as=0 ps=0 w=244 l=100
X56 5v0_add_q_sc_1/upstepper_test 5v0_add_q_sc_1/nti VDD_1V65_1 VSS_3 nfet_06v0 ad=0 pd=0 as=21.021n ps=0.58m w=147 l=120
X57 5v0_add_q_sc_1/a_n1205_n937# 5v0_add_q_sc_1/inv_pti VDD_3V3_1 VDD_3V3_1 pfet_06v0 ad=0 pd=0 as=0 ps=0 w=243 l=100
X58 5v0_add_q_sc_1/downstepper_test 5v0_add_q_sc_1/pti 5v0_add_q_sc_1/a_n1778_n454# VSS_3 nfet_06v0 ad=0 pd=0 as=7.056n ps=0.39m w=147 l=120
X59 5v0_add_q_sc_1/inv_nti 5v0_add_q_sc_1/nti VSS_3 VSS_3 nfet_06v0 ad=14.432n pd=0.504m as=0 ps=0 w=164 l=120
X60 5v0_add_q_sc_1/a_n1778_n454# 5v0_add_q_sc_1/inv_nti VSS_3 VSS_3 nfet_06v0 ad=0 pd=0 as=0 ps=0 w=147 l=120
X61 5v0_add_q_sc_1/upstepper_test 5v0_add_q_sc_1/inv_pti VSS_3 VSS_3 nfet_06v0 ad=0 pd=0 as=0 ps=0 w=164 l=120
X62 VDD_1V65_1 5v0_add_q_sc_1/inv_pti 5v0_add_q_sc_1/a_n1373_n454# VSS_3 nfet_06v0 ad=0 pd=0 as=0 ps=0 w=147 l=120
X63 5v0_add_q_sc_1/downstepper_test 5v0_add_q_sc_1/inv_nti VDD_3V3_1 VDD_3V3_1 pfet_06v0 ad=0 pd=0 as=0 ps=0 w=243 l=100
X64 5v0_addh_sc_tile_2/ctrl_over 5v0_addh_sc_tile_2/ctrl_sign 5v0_nter2oter_code_sc_0/gf180mcu_fd_sc_mcu7t5v0__nor2_1_0/a_224_472# VDD_3V3_0 pfet_06v0 ad=21.472n pd=0.664m as=16.348n ps=0.378m w=244 l=100
X65 VSS_3 5v0_addh_sc_tile_2/ctrl_sign 5v0_addh_sc_tile_2/ctrl_over VSS_3 nfet_06v0 ad=9.944n pd=0.402m as=5.876n ps=0.217m w=113 l=120
X66 5v0_nter2oter_code_sc_0/gf180mcu_fd_sc_mcu7t5v0__nor2_1_0/a_224_472# 5v0_nter2oter_code_sc_0/nti VDD_3V3_0 VDD_3V3_0 pfet_06v0 ad=16.348n pd=0.378m as=20.932n ps=0.664m w=244 l=100
X67 5v0_addh_sc_tile_2/ctrl_over 5v0_nter2oter_code_sc_0/nti VSS_3 VSS_3 nfet_06v0 ad=5.876n pd=0.217m as=9.944n ps=0.402m w=113 l=120
X68 5v0_addh_sc_tile_2/ctrl_sign 5v0_nter2oter_code_sc_0/pti VSS_3 VSS_3 nfet_06v0 ad=14.432n pd=0.504m as=0 ps=0 w=164 l=120
X69 5v0_addh_sc_tile_2/ctrl_sign 5v0_nter2oter_code_sc_0/pti VDD_3V3_0 VDD_3V3_0 pfet_06v0 ad=21.472n pd=0.664m as=0 ps=0 w=244 l=100
X70 5v0_nter2oter_code_sc_0/pti int_012 VSS_3 VSS_3 nfet_06v0 ad=6.336n pd=0.32m as=6.478n ps=0.255m w=72 l=578
X71 VDD_3V3_1 int_012 5v0_nter2oter_code_sc_0/pti VDD_3V3_1 pfet_06v0 ad=12.81n pd=0.349m as=12.688n ps=0.348m w=244 l=100
X72 VDD_3V3_1 int_012 5v0_nter2oter_code_sc_0/nti VDD_3V3_1 pfet_06v0 ad=13.616n pd=0.392m as=9.696n ps=0.394m w=96 l=150
X73 VSS_3 int_012 5v0_nter2oter_code_sc_0/nti VSS_3 nfet_06v0 ad=6.478n pd=0.255m as=12.7n ps=0.454m w=127 l=120
X74 5v0_nter2oter_code_sc_0/pti int_012 VDD_3V3_1 VDD_3V3_1 pfet_06v0 ad=12.688n pd=0.348m as=13.616n ps=0.392m w=244 l=100
X75 5v0_nter2oter_code_sc_0/pti int_012 VDD_3V3_1 VDD_3V3_1 pfet_06v0 ad=27.328n pd=0.712m as=12.81n ps=0.349m w=244 l=100
X76 5v0_addh_sc_tile_1/ctrl_over 5v0_addh_sc_tile_1/ctrl_sign 5v0_nter2oter_code_sc_1/gf180mcu_fd_sc_mcu7t5v0__nor2_1_0/a_224_472# VDD_3V3_0 pfet_06v0 ad=21.472n pd=0.664m as=32.696n ps=0.756m w=244 l=100
X77 VSS_3 5v0_addh_sc_tile_1/ctrl_sign 5v0_addh_sc_tile_1/ctrl_over VSS_3 nfet_06v0 ad=0 pd=0 as=11.752n ps=0.434m w=113 l=120
X78 5v0_nter2oter_code_sc_1/gf180mcu_fd_sc_mcu7t5v0__nor2_1_0/a_224_472# 5v0_nter2oter_code_sc_1/nti VDD_3V3_0 VDD_3V3_0 pfet_06v0 ad=0 pd=0 as=0 ps=0 w=244 l=100
X79 5v0_addh_sc_tile_1/ctrl_over 5v0_nter2oter_code_sc_1/nti VSS_3 VSS_3 nfet_06v0 ad=0 pd=0 as=0 ps=0 w=113 l=120
X80 5v0_addh_sc_tile_1/ctrl_sign 5v0_nter2oter_code_sc_1/pti VSS_3 VSS_3 nfet_06v0 ad=14.432n pd=0.504m as=0 ps=0 w=164 l=120
X81 5v0_addh_sc_tile_1/ctrl_sign 5v0_nter2oter_code_sc_1/pti VDD_3V3_0 VDD_3V3_0 pfet_06v0 ad=21.472n pd=0.664m as=0 ps=0 w=244 l=100
X82 5v0_nter2oter_code_sc_1/pti in_2 VSS_3 VSS_3 nfet_06v0 ad=6.336n pd=0.32m as=0 ps=0 w=72 l=578
X83 VDD_3V3_1 in_2 5v0_nter2oter_code_sc_1/pti VDD_3V3_1 pfet_06v0 ad=0 pd=0 as=52.704n ps=1.408m w=244 l=100
X84 VDD_3V3_1 in_2 5v0_nter2oter_code_sc_1/nti VDD_3V3_1 pfet_06v0 ad=0 pd=0 as=9.696n ps=0.394m w=96 l=150
X85 VSS_3 in_2 5v0_nter2oter_code_sc_1/nti VSS_3 nfet_06v0 ad=0 pd=0 as=12.7n ps=0.454m w=127 l=120
X86 5v0_nter2oter_code_sc_1/pti in_2 VDD_3V3_1 VDD_3V3_1 pfet_06v0 ad=0 pd=0 as=0 ps=0 w=244 l=100
X87 5v0_nter2oter_code_sc_1/pti in_2 VDD_3V3_1 VDD_3V3_1 pfet_06v0 ad=0 pd=0 as=0 ps=0 w=244 l=100
X88 m1_n2844_n810# 5v0_addh_sc_tile_0/carry_0_probe VSS_3 VSS_3 nfet_06v0 ad=14.432n pd=0.504m as=0 ps=0 w=164 l=120
X89 m1_n2844_n810# 5v0_addh_sc_tile_0/carry_0_probe VDD_3V3_1 VDD_3V3_1 pfet_06v0 ad=21.472n pd=0.664m as=0 ps=0 w=244 l=100
X90 5v0_addh_sc_tile_0/pti in_1 VSS_3 VSS_3 nfet_06v0 ad=20.768n pd=0.824m as=0 ps=0 w=72 l=578
X91 VDD_3V3_1 in_1 5v0_addh_sc_tile_0/pti VDD_3V3_1 pfet_06v0 ad=0 pd=0 as=74.176n ps=2.072m w=244 l=100
X92 VDD_3V3_1 in_1 5v0_addh_sc_tile_0/nti VDD_3V3_1 pfet_06v0 ad=0 pd=0 as=9.696n ps=0.394m w=96 l=150
X93 VSS_3 in_1 5v0_addh_sc_tile_0/nti VSS_3 nfet_06v0 ad=0 pd=0 as=12.7n ps=0.454m w=127 l=120
X94 5v0_addh_sc_tile_0/pti in_1 VDD_3V3_1 VDD_3V3_1 pfet_06v0 ad=0 pd=0 as=0 ps=0 w=244 l=100
X95 5v0_addh_sc_tile_0/pti in_1 VDD_3V3_1 VDD_3V3_1 pfet_06v0 ad=0 pd=0 as=0 ps=0 w=244 l=100
X96 5v0_addh_sc_tile_0/5v0_half_adder_selector_sc_0/res_stage0 5v0_addh_sc_tile_0/m1_103_293# 5v0_addh_sc_tile_0/downstepper_test VSS_3 nfet_06v0 ad=31.489n pd=1.041m as=31.631n ps=1.032m w=164 l=120
X97 5v0_addh_sc_tile_0/5v0_half_adder_selector_sc_0/res_stage0 5v0_addh_sc_tile_0/m1_103_293# 5v0_addh_sc_tile_0/upstepper_test VDD_3V3_1 pfet_06v0 ad=46.849n pd=1.361m as=42.856n ps=1.326m w=244 l=100
X98 5v0_addh_sc_tile_0/m1_103_293# in_0_sign VSS_3 VSS_3 nfet_06v0 ad=14.432n pd=0.504m as=0 ps=0 w=164 l=120
X99 5v0_addh_sc_tile_0/m1_103_293# in_0_sign VDD_3V3_1 VDD_3V3_1 pfet_06v0 ad=21.472n pd=0.664m as=0 ps=0 w=244 l=100
X100 5v0_addh_sc_tile_0/5v0_half_adder_selector_sc_0/res_stage0 in_0_sign 5v0_addh_sc_tile_0/upstepper_test VSS_3 nfet_06v0 ad=0 pd=0 as=43.711n ps=1.504m w=164 l=120
X101 5v0_addh_sc_tile_0/5v0_half_adder_selector_sc_0/res_stage0 in_0_sign 5v0_addh_sc_tile_0/downstepper_test VDD_3V3_1 pfet_06v0 ad=0 pd=0 as=42.856n ps=1.326m w=244 l=100
X102 res_01 5v0_addh_sc_tile_0/a_382_n1095# 5v0_addh_sc_tile_0/5v0_half_adder_selector_sc_0/res_stage0 VSS_3 nfet_06v0 ad=31.489n pd=1.041m as=0 ps=0 w=164 l=120
X103 res_01 5v0_addh_sc_tile_0/a_382_n1095# in_1 VDD_3V3_1 pfet_06v0 ad=46.849n pd=1.361m as=21.472n ps=0.664m w=244 l=100
X104 5v0_addh_sc_tile_0/a_382_n1095# in_0_over VSS_3 VSS_3 nfet_06v0 ad=14.432n pd=0.504m as=0 ps=0 w=164 l=120
X105 5v0_addh_sc_tile_0/a_382_n1095# in_0_over VDD_3V3_1 VDD_3V3_1 pfet_06v0 ad=21.472n pd=0.664m as=0 ps=0 w=244 l=100
X106 res_01 in_0_over in_1 VSS_3 nfet_06v0 ad=0 pd=0 as=14.432n ps=0.504m w=164 l=120
X107 res_01 in_0_over 5v0_addh_sc_tile_0/5v0_half_adder_selector_sc_0/res_stage0 VDD_3V3_1 pfet_06v0 ad=0 pd=0 as=0 ps=0 w=244 l=100
X108 5v0_addh_sc_tile_0/inv_pti 5v0_addh_sc_tile_0/pti VSS_3 VSS_3 nfet_06v0 ad=28.864n pd=1.008m as=0 ps=0 w=164 l=120
X109 5v0_addh_sc_tile_0/inv_pti 5v0_addh_sc_tile_0/pti VDD_3V3_1 VDD_3V3_1 pfet_06v0 ad=42.944n pd=1.328m as=0 ps=0 w=244 l=100
X110 5v0_addh_sc_tile_0/carry_0_probe 5v0_addh_sc_tile_0/a_382_n1095# 5v0_addh_sc_tile_0/m1_843_n857# VSS_3 nfet_06v0 ad=14.432n pd=0.504m as=14.432n ps=0.504m w=164 l=120
X111 5v0_addh_sc_tile_0/carry_0_probe in_0_over 5v0_addh_sc_tile_0/m1_843_n857# VDD_3V3_1 pfet_06v0 ad=21.472n pd=0.664m as=21.472n ps=0.664m w=244 l=100
X112 5v0_addh_sc_tile_0/inv_nti in_0_sign c01 VDD_3V3_1 pfet_06v0 ad=21.472n pd=0.664m as=12.688n ps=0.348m w=244 l=100
X113 c01 5v0_addh_sc_tile_0/m1_103_293# 5v0_addh_sc_tile_0/inv_nti VSS_3 nfet_06v0 ad=8.528n pd=0.268m as=14.432n ps=0.504m w=164 l=120
X114 c01 5v0_addh_sc_tile_0/m1_103_293# 5v0_addh_sc_tile_0/inv_pti VDD_3V3_1 pfet_06v0 ad=12.688n pd=0.348m as=21.472n ps=0.664m w=244 l=100
X115 5v0_addh_sc_tile_0/inv_pti in_0_sign c01 VSS_3 nfet_06v0 ad=14.432n pd=0.504m as=8.528n ps=0.268m w=164 l=120
X116 5v0_addh_sc_tile_0/inv_nti in_0_sign 5v0_addh_sc_tile_0/m1_843_n857# VDD_3V3_1 pfet_06v0 ad=64.416n pd=1.992m as=46.848n ps=1.36m w=244 l=100
X117 5v0_addh_sc_tile_0/m1_843_n857# 5v0_addh_sc_tile_0/m1_103_293# 5v0_addh_sc_tile_0/inv_nti VSS_3 nfet_06v0 ad=31.488n pd=1.04m as=43.296n ps=1.512m w=164 l=120
X118 5v0_addh_sc_tile_0/m1_843_n857# 5v0_addh_sc_tile_0/m1_103_293# 5v0_addh_sc_tile_0/pti VDD_3V3_1 pfet_06v0 ad=0 pd=0 as=0 ps=0 w=244 l=100
X119 5v0_addh_sc_tile_0/pti in_0_sign 5v0_addh_sc_tile_0/m1_843_n857# VSS_3 nfet_06v0 ad=0 pd=0 as=0 ps=0 w=164 l=120
X120 5v0_addh_sc_tile_0/a_n1373_n454# 5v0_addh_sc_tile_0/inv_nti 5v0_addh_sc_tile_0/downstepper_test VSS_3 nfet_06v0 ad=3.528n pd=0.195m as=8.599n ps=0.264m w=147 l=120
X121 5v0_addh_sc_tile_0/upstepper_test 5v0_addh_sc_tile_0/nti 5v0_addh_sc_tile_0/a_n1205_n937# VDD_3V3_1 pfet_06v0 ad=21.384n pd=0.662m as=5.832n ps=0.291m w=243 l=100
X122 5v0_addh_sc_tile_0/inv_nti 5v0_addh_sc_tile_0/nti VDD_3V3_1 VDD_3V3_1 pfet_06v0 ad=21.472n pd=0.664m as=21.472n ps=0.664m w=244 l=100
X123 5v0_addh_sc_tile_0/upstepper_test 5v0_addh_sc_tile_0/nti VDD_1V65_0 VSS_3 nfet_06v0 ad=14.847n pd=0.496m as=10.51n ps=0.29m w=147 l=120
X124 5v0_addh_sc_tile_0/carry_0_probe 5v0_addh_sc_tile_0/a_382_n1095# VDD_3V3_1 VDD_3V3_1 pfet_06v0 ad=21.472n pd=0.664m as=21.472n ps=0.664m w=244 l=100
X125 5v0_addh_sc_tile_0/a_n1205_n937# 5v0_addh_sc_tile_0/inv_pti VDD_3V3_1 VDD_3V3_1 pfet_06v0 ad=5.832n pd=0.291m as=21.384n ps=0.662m w=243 l=100
X126 5v0_addh_sc_tile_0/downstepper_test 5v0_addh_sc_tile_0/pti 5v0_addh_sc_tile_0/a_n1778_n454# VSS_3 nfet_06v0 ad=8.599n pd=0.264m as=3.528n ps=0.195m w=147 l=120
X127 5v0_addh_sc_tile_0/inv_nti 5v0_addh_sc_tile_0/nti VSS_3 VSS_3 nfet_06v0 ad=14.432n pd=0.504m as=14.432n ps=0.504m w=164 l=120
X128 5v0_addh_sc_tile_0/a_n1778_n454# 5v0_addh_sc_tile_0/inv_nti VSS_3 VSS_3 nfet_06v0 ad=3.528n pd=0.195m as=14.847n ps=0.496m w=147 l=120
X129 5v0_addh_sc_tile_0/upstepper_test 5v0_addh_sc_tile_0/inv_pti VSS_3 VSS_3 nfet_06v0 ad=14.432n pd=0.504m as=14.432n ps=0.504m w=164 l=120
X130 VDD_1V65_0 5v0_addh_sc_tile_0/inv_pti 5v0_addh_sc_tile_0/a_n1373_n454# VSS_3 nfet_06v0 ad=10.51n pd=0.29m as=3.528n ps=0.195m w=147 l=120
X131 5v0_addh_sc_tile_0/downstepper_test 5v0_addh_sc_tile_0/inv_nti VDD_3V3_1 VDD_3V3_1 pfet_06v0 ad=21.384n pd=0.662m as=21.384n ps=0.662m w=243 l=100
X132 5v0_addh_sc_tile_1/pti res_01 VSS_3 VSS_3 nfet_06v0 ad=20.768n pd=0.824m as=0 ps=0 w=72 l=578
X133 VDD_3V3_1 res_01 5v0_addh_sc_tile_1/pti VDD_3V3_1 pfet_06v0 ad=0 pd=0 as=74.176n ps=2.072m w=244 l=100
X134 VDD_3V3_1 res_01 5v0_addh_sc_tile_1/nti VDD_3V3_1 pfet_06v0 ad=0 pd=0 as=9.696n ps=0.394m w=96 l=150
X135 VSS_3 res_01 5v0_addh_sc_tile_1/nti VSS_3 nfet_06v0 ad=0 pd=0 as=12.7n ps=0.454m w=127 l=120
X136 5v0_addh_sc_tile_1/pti res_01 VDD_3V3_1 VDD_3V3_1 pfet_06v0 ad=0 pd=0 as=0 ps=0 w=244 l=100
X137 5v0_addh_sc_tile_1/pti res_01 VDD_3V3_1 VDD_3V3_1 pfet_06v0 ad=0 pd=0 as=0 ps=0 w=244 l=100
X138 5v0_addh_sc_tile_1/5v0_half_adder_selector_sc_0/res_stage0 5v0_addh_sc_tile_1/m1_103_293# 5v0_addh_sc_tile_1/downstepper_test VSS_3 nfet_06v0 ad=31.489n pd=1.041m as=31.631n ps=1.032m w=164 l=120
X139 5v0_addh_sc_tile_1/5v0_half_adder_selector_sc_0/res_stage0 5v0_addh_sc_tile_1/m1_103_293# 5v0_addh_sc_tile_1/upstepper_test VDD_3V3_1 pfet_06v0 ad=46.849n pd=1.361m as=42.856n ps=1.326m w=244 l=100
X140 5v0_addh_sc_tile_1/m1_103_293# 5v0_addh_sc_tile_1/ctrl_sign VSS_3 VSS_3 nfet_06v0 ad=14.432n pd=0.504m as=0 ps=0 w=164 l=120
X141 5v0_addh_sc_tile_1/m1_103_293# 5v0_addh_sc_tile_1/ctrl_sign VDD_3V3_1 VDD_3V3_1 pfet_06v0 ad=21.472n pd=0.664m as=0 ps=0 w=244 l=100
X142 5v0_addh_sc_tile_1/5v0_half_adder_selector_sc_0/res_stage0 5v0_addh_sc_tile_1/ctrl_sign 5v0_addh_sc_tile_1/upstepper_test VSS_3 nfet_06v0 ad=0 pd=0 as=43.711n ps=1.504m w=164 l=120
X143 5v0_addh_sc_tile_1/5v0_half_adder_selector_sc_0/res_stage0 5v0_addh_sc_tile_1/ctrl_sign 5v0_addh_sc_tile_1/downstepper_test VDD_3V3_1 pfet_06v0 ad=0 pd=0 as=42.856n ps=1.326m w=244 l=100
X144 int_012 5v0_addh_sc_tile_1/a_382_n1095# 5v0_addh_sc_tile_1/5v0_half_adder_selector_sc_0/res_stage0 VSS_3 nfet_06v0 ad=17.057n pd=0.537m as=0 ps=0 w=164 l=120
X145 int_012 5v0_addh_sc_tile_1/a_382_n1095# res_01 VDD_3V3_0 pfet_06v0 ad=25.377n pd=0.697m as=0 ps=0 w=244 l=100
X146 5v0_addh_sc_tile_1/a_382_n1095# 5v0_addh_sc_tile_1/ctrl_over VSS_3 VSS_3 nfet_06v0 ad=14.432n pd=0.504m as=0 ps=0 w=164 l=120
X147 5v0_addh_sc_tile_1/a_382_n1095# 5v0_addh_sc_tile_1/ctrl_over VDD_3V3_0 VDD_3V3_0 pfet_06v0 ad=21.472n pd=0.664m as=0 ps=0 w=244 l=100
X148 int_012 5v0_addh_sc_tile_1/ctrl_over res_01 VSS_3 nfet_06v0 ad=0 pd=0 as=0 ps=0 w=164 l=120
X149 int_012 5v0_addh_sc_tile_1/ctrl_over 5v0_addh_sc_tile_1/5v0_half_adder_selector_sc_0/res_stage0 VDD_3V3_0 pfet_06v0 ad=0 pd=0 as=0 ps=0 w=244 l=100
X150 5v0_addh_sc_tile_1/inv_pti 5v0_addh_sc_tile_1/pti VSS_3 VSS_3 nfet_06v0 ad=28.864n pd=1.008m as=0 ps=0 w=164 l=120
X151 5v0_addh_sc_tile_1/inv_pti 5v0_addh_sc_tile_1/pti VDD_3V3_1 VDD_3V3_1 pfet_06v0 ad=42.944n pd=1.328m as=0 ps=0 w=244 l=100
X152 c_2_o 5v0_addh_sc_tile_1/a_382_n1095# 5v0_addh_sc_tile_1/m1_843_n857# VSS_3 nfet_06v0 ad=14.432n pd=0.504m as=31.488n ps=1.04m w=164 l=120
X153 c_2_o 5v0_addh_sc_tile_1/ctrl_over 5v0_addh_sc_tile_1/m1_843_n857# VDD_3V3_0 pfet_06v0 ad=42.944n pd=1.328m as=46.848n ps=1.36m w=244 l=100
X154 5v0_addh_sc_tile_1/inv_nti 5v0_addh_sc_tile_1/ctrl_sign c_2_s VDD_3V3_1 pfet_06v0 ad=64.416n pd=1.992m as=25.376n ps=0.696m w=244 l=100
X155 c_2_s 5v0_addh_sc_tile_1/m1_103_293# 5v0_addh_sc_tile_1/inv_nti VSS_3 nfet_06v0 ad=17.056n pd=0.536m as=43.296n ps=1.512m w=164 l=120
X156 c_2_s 5v0_addh_sc_tile_1/m1_103_293# 5v0_addh_sc_tile_1/inv_pti VDD_3V3_1 pfet_06v0 ad=0 pd=0 as=0 ps=0 w=244 l=100
X157 5v0_addh_sc_tile_1/inv_pti 5v0_addh_sc_tile_1/ctrl_sign c_2_s VSS_3 nfet_06v0 ad=0 pd=0 as=0 ps=0 w=164 l=120
X158 5v0_addh_sc_tile_1/inv_nti 5v0_addh_sc_tile_1/ctrl_sign 5v0_addh_sc_tile_1/m1_843_n857# VDD_3V3_0 pfet_06v0 ad=0 pd=0 as=0 ps=0 w=244 l=100
X159 5v0_addh_sc_tile_1/m1_843_n857# 5v0_addh_sc_tile_1/m1_103_293# 5v0_addh_sc_tile_1/inv_nti VSS_3 nfet_06v0 ad=0 pd=0 as=0 ps=0 w=164 l=120
X160 5v0_addh_sc_tile_1/m1_843_n857# 5v0_addh_sc_tile_1/m1_103_293# 5v0_addh_sc_tile_1/pti VDD_3V3_0 pfet_06v0 ad=0 pd=0 as=0 ps=0 w=244 l=100
X161 5v0_addh_sc_tile_1/pti 5v0_addh_sc_tile_1/ctrl_sign 5v0_addh_sc_tile_1/m1_843_n857# VSS_3 nfet_06v0 ad=0 pd=0 as=0 ps=0 w=164 l=120
X162 5v0_addh_sc_tile_1/a_n1373_n454# 5v0_addh_sc_tile_1/inv_nti 5v0_addh_sc_tile_1/downstepper_test VSS_3 nfet_06v0 ad=7.056n pd=0.39m as=0 ps=0 w=147 l=120
X163 5v0_addh_sc_tile_1/upstepper_test 5v0_addh_sc_tile_1/nti 5v0_addh_sc_tile_1/a_n1205_n937# VDD_3V3_0 pfet_06v0 ad=0 pd=0 as=11.664n ps=0.582m w=243 l=100
X164 5v0_addh_sc_tile_1/inv_nti 5v0_addh_sc_tile_1/nti VDD_3V3_0 VDD_3V3_0 pfet_06v0 ad=0 pd=0 as=0 ps=0 w=244 l=100
X165 5v0_addh_sc_tile_1/upstepper_test 5v0_addh_sc_tile_1/nti VDD_1V65_3 VSS_3 nfet_06v0 ad=0 pd=0 as=21.021n ps=0.58m w=147 l=120
X166 c_2_o 5v0_addh_sc_tile_1/a_382_n1095# VDD_3V3_0 VDD_3V3_0 pfet_06v0 ad=0 pd=0 as=0 ps=0 w=244 l=100
X167 5v0_addh_sc_tile_1/a_n1205_n937# 5v0_addh_sc_tile_1/inv_pti VDD_3V3_0 VDD_3V3_0 pfet_06v0 ad=0 pd=0 as=0 ps=0 w=243 l=100
X168 5v0_addh_sc_tile_1/downstepper_test 5v0_addh_sc_tile_1/pti 5v0_addh_sc_tile_1/a_n1778_n454# VSS_3 nfet_06v0 ad=0 pd=0 as=7.056n ps=0.39m w=147 l=120
X169 5v0_addh_sc_tile_1/inv_nti 5v0_addh_sc_tile_1/nti VSS_3 VSS_3 nfet_06v0 ad=0 pd=0 as=0 ps=0 w=164 l=120
X170 5v0_addh_sc_tile_1/a_n1778_n454# 5v0_addh_sc_tile_1/inv_nti VSS_3 VSS_3 nfet_06v0 ad=0 pd=0 as=0 ps=0 w=147 l=120
X171 5v0_addh_sc_tile_1/upstepper_test 5v0_addh_sc_tile_1/inv_pti VSS_3 VSS_3 nfet_06v0 ad=0 pd=0 as=0 ps=0 w=164 l=120
X172 VDD_1V65_3 5v0_addh_sc_tile_1/inv_pti 5v0_addh_sc_tile_1/a_n1373_n454# VSS_3 nfet_06v0 ad=0 pd=0 as=0 ps=0 w=147 l=120
X173 5v0_addh_sc_tile_1/downstepper_test 5v0_addh_sc_tile_1/inv_nti VDD_3V3_0 VDD_3V3_0 pfet_06v0 ad=0 pd=0 as=0 ps=0 w=243 l=100
X174 5v0_addh_sc_tile_2/pti in_3 VSS_3 VSS_3 nfet_06v0 ad=20.768n pd=0.824m as=0 ps=0 w=72 l=578
X175 VDD_3V3_0 in_3 5v0_addh_sc_tile_2/pti VDD_3V3_0 pfet_06v0 ad=0 pd=0 as=74.176n ps=2.072m w=244 l=100
X176 VDD_3V3_0 in_3 5v0_addh_sc_tile_2/nti VDD_3V3_0 pfet_06v0 ad=0 pd=0 as=9.696n ps=0.394m w=96 l=150
X177 VSS_3 in_3 5v0_addh_sc_tile_2/nti VSS_3 nfet_06v0 ad=0 pd=0 as=12.7n ps=0.454m w=127 l=120
X178 5v0_addh_sc_tile_2/pti in_3 VDD_3V3_0 VDD_3V3_0 pfet_06v0 ad=0 pd=0 as=0 ps=0 w=244 l=100
X179 5v0_addh_sc_tile_2/pti in_3 VDD_3V3_0 VDD_3V3_0 pfet_06v0 ad=0 pd=0 as=0 ps=0 w=244 l=100
X180 5v0_addh_sc_tile_2/5v0_half_adder_selector_sc_0/res_stage0 5v0_addh_sc_tile_2/m1_103_293# 5v0_addh_sc_tile_2/downstepper_test VSS_3 nfet_06v0 ad=31.489n pd=1.041m as=31.631n ps=1.032m w=164 l=120
X181 5v0_addh_sc_tile_2/5v0_half_adder_selector_sc_0/res_stage0 5v0_addh_sc_tile_2/m1_103_293# 5v0_addh_sc_tile_2/upstepper_test VDD_3V3_0 pfet_06v0 ad=46.849n pd=1.361m as=42.856n ps=1.326m w=244 l=100
X182 5v0_addh_sc_tile_2/m1_103_293# 5v0_addh_sc_tile_2/ctrl_sign VSS_3 VSS_3 nfet_06v0 ad=14.432n pd=0.504m as=0 ps=0 w=164 l=120
X183 5v0_addh_sc_tile_2/m1_103_293# 5v0_addh_sc_tile_2/ctrl_sign VDD_3V3_0 VDD_3V3_0 pfet_06v0 ad=21.472n pd=0.664m as=0 ps=0 w=244 l=100
X184 5v0_addh_sc_tile_2/5v0_half_adder_selector_sc_0/res_stage0 5v0_addh_sc_tile_2/ctrl_sign 5v0_addh_sc_tile_2/upstepper_test VSS_3 nfet_06v0 ad=0 pd=0 as=43.711n ps=1.504m w=164 l=120
X185 5v0_addh_sc_tile_2/5v0_half_adder_selector_sc_0/res_stage0 5v0_addh_sc_tile_2/ctrl_sign 5v0_addh_sc_tile_2/downstepper_test VDD_3V3_0 pfet_06v0 ad=0 pd=0 as=42.856n ps=1.326m w=244 l=100
X186 res_0 5v0_addh_sc_tile_2/a_382_n1095# 5v0_addh_sc_tile_2/5v0_half_adder_selector_sc_0/res_stage0 VSS_3 nfet_06v0 ad=17.057n pd=0.537m as=0 ps=0 w=164 l=120
X187 res_0 5v0_addh_sc_tile_2/a_382_n1095# in_3 VDD_3V3_0 pfet_06v0 ad=25.377n pd=0.697m as=21.472n ps=0.664m w=244 l=100
X188 5v0_addh_sc_tile_2/a_382_n1095# 5v0_addh_sc_tile_2/ctrl_over VSS_3 VSS_3 nfet_06v0 ad=14.432n pd=0.504m as=0 ps=0 w=164 l=120
X189 5v0_addh_sc_tile_2/a_382_n1095# 5v0_addh_sc_tile_2/ctrl_over VDD_3V3_0 VDD_3V3_0 pfet_06v0 ad=21.472n pd=0.664m as=0 ps=0 w=244 l=100
X190 res_0 5v0_addh_sc_tile_2/ctrl_over in_3 VSS_3 nfet_06v0 ad=0 pd=0 as=14.432n ps=0.504m w=164 l=120
X191 res_0 5v0_addh_sc_tile_2/ctrl_over 5v0_addh_sc_tile_2/5v0_half_adder_selector_sc_0/res_stage0 VDD_3V3_0 pfet_06v0 ad=0 pd=0 as=0 ps=0 w=244 l=100
X192 5v0_addh_sc_tile_2/inv_pti 5v0_addh_sc_tile_2/pti VSS_3 VSS_3 nfet_06v0 ad=28.864n pd=1.008m as=0 ps=0 w=164 l=120
X193 5v0_addh_sc_tile_2/inv_pti 5v0_addh_sc_tile_2/pti VDD_3V3_0 VDD_3V3_0 pfet_06v0 ad=42.944n pd=1.328m as=0 ps=0 w=244 l=100
X194 5v0_add_q_sc_0/ctrl_over 5v0_addh_sc_tile_2/a_382_n1095# 5v0_addh_sc_tile_2/m1_843_n857# VSS_3 nfet_06v0 ad=14.432n pd=0.504m as=31.488n ps=1.04m w=164 l=120
X195 5v0_add_q_sc_0/ctrl_over 5v0_addh_sc_tile_2/ctrl_over 5v0_addh_sc_tile_2/m1_843_n857# VDD_3V3_0 pfet_06v0 ad=42.944n pd=1.328m as=46.848n ps=1.36m w=244 l=100
X196 5v0_addh_sc_tile_2/inv_nti 5v0_addh_sc_tile_2/ctrl_sign 5v0_add_q_sc_0/ctrl_sign VDD_3V3_0 pfet_06v0 ad=64.416n pd=1.992m as=25.376n ps=0.696m w=244 l=100
X197 5v0_add_q_sc_0/ctrl_sign 5v0_addh_sc_tile_2/m1_103_293# 5v0_addh_sc_tile_2/inv_nti VSS_3 nfet_06v0 ad=17.056n pd=0.536m as=43.296n ps=1.512m w=164 l=120
X198 5v0_add_q_sc_0/ctrl_sign 5v0_addh_sc_tile_2/m1_103_293# 5v0_addh_sc_tile_2/inv_pti VDD_3V3_0 pfet_06v0 ad=0 pd=0 as=0 ps=0 w=244 l=100
X199 5v0_addh_sc_tile_2/inv_pti 5v0_addh_sc_tile_2/ctrl_sign 5v0_add_q_sc_0/ctrl_sign VSS_3 nfet_06v0 ad=0 pd=0 as=0 ps=0 w=164 l=120
X200 5v0_addh_sc_tile_2/inv_nti 5v0_addh_sc_tile_2/ctrl_sign 5v0_addh_sc_tile_2/m1_843_n857# VDD_3V3_0 pfet_06v0 ad=0 pd=0 as=0 ps=0 w=244 l=100
X201 5v0_addh_sc_tile_2/m1_843_n857# 5v0_addh_sc_tile_2/m1_103_293# 5v0_addh_sc_tile_2/inv_nti VSS_3 nfet_06v0 ad=0 pd=0 as=0 ps=0 w=164 l=120
X202 5v0_addh_sc_tile_2/m1_843_n857# 5v0_addh_sc_tile_2/m1_103_293# 5v0_addh_sc_tile_2/pti VDD_3V3_0 pfet_06v0 ad=0 pd=0 as=0 ps=0 w=244 l=100
X203 5v0_addh_sc_tile_2/pti 5v0_addh_sc_tile_2/ctrl_sign 5v0_addh_sc_tile_2/m1_843_n857# VSS_3 nfet_06v0 ad=0 pd=0 as=0 ps=0 w=164 l=120
X204 5v0_addh_sc_tile_2/a_n1373_n454# 5v0_addh_sc_tile_2/inv_nti 5v0_addh_sc_tile_2/downstepper_test VSS_3 nfet_06v0 ad=7.056n pd=0.39m as=0 ps=0 w=147 l=120
X205 5v0_addh_sc_tile_2/upstepper_test 5v0_addh_sc_tile_2/nti 5v0_addh_sc_tile_2/a_n1205_n937# VDD_3V3_0 pfet_06v0 ad=0 pd=0 as=11.664n ps=0.582m w=243 l=100
X206 5v0_addh_sc_tile_2/inv_nti 5v0_addh_sc_tile_2/nti VDD_3V3_0 VDD_3V3_0 pfet_06v0 ad=0 pd=0 as=0 ps=0 w=244 l=100
X207 5v0_addh_sc_tile_2/upstepper_test 5v0_addh_sc_tile_2/nti VDD_1V65_4 VSS_3 nfet_06v0 ad=0 pd=0 as=21.021n ps=0.58m w=147 l=120
X208 5v0_add_q_sc_0/ctrl_over 5v0_addh_sc_tile_2/a_382_n1095# VDD_3V3_0 VDD_3V3_0 pfet_06v0 ad=0 pd=0 as=0 ps=0 w=244 l=100
X209 5v0_addh_sc_tile_2/a_n1205_n937# 5v0_addh_sc_tile_2/inv_pti VDD_3V3_0 VDD_3V3_0 pfet_06v0 ad=0 pd=0 as=0 ps=0 w=243 l=100
X210 5v0_addh_sc_tile_2/downstepper_test 5v0_addh_sc_tile_2/pti 5v0_addh_sc_tile_2/a_n1778_n454# VSS_3 nfet_06v0 ad=0 pd=0 as=7.056n ps=0.39m w=147 l=120
X211 5v0_addh_sc_tile_2/inv_nti 5v0_addh_sc_tile_2/nti VSS_3 VSS_3 nfet_06v0 ad=0 pd=0 as=0 ps=0 w=164 l=120
X212 5v0_addh_sc_tile_2/a_n1778_n454# 5v0_addh_sc_tile_2/inv_nti VSS_3 VSS_3 nfet_06v0 ad=0 pd=0 as=0 ps=0 w=147 l=120
X213 5v0_addh_sc_tile_2/upstepper_test 5v0_addh_sc_tile_2/inv_pti VSS_3 VSS_3 nfet_06v0 ad=0 pd=0 as=0 ps=0 w=164 l=120
X214 VDD_1V65_4 5v0_addh_sc_tile_2/inv_pti 5v0_addh_sc_tile_2/a_n1373_n454# VSS_3 nfet_06v0 ad=0 pd=0 as=0 ps=0 w=147 l=120
X215 5v0_addh_sc_tile_2/downstepper_test 5v0_addh_sc_tile_2/inv_nti VDD_3V3_0 VDD_3V3_0 pfet_06v0 ad=0 pd=0 as=0 ps=0 w=243 l=100
C0 5v0_addh_sc_tile_2/pti 5v0_add_q_sc_0/upstepper_test 0
C1 5v0_addh_sc_tile_1/a_382_n1095# VDD_1V65_1 0
C2 5v0_addh_sc_tile_1/m1_843_n857# int_carry 0.00836f
C3 5v0_addh_sc_tile_0/m1_843_n857# 5v0_addh_sc_tile_1/pti 0
C4 5v0_add_q_sc_0/5v0_half_adder_selector_sc_0/m1_n244_n517# 5v0_add_q_sc_0/nti 0
C5 in_3 5v0_nter2oter_code_sc_0/pti 0.00219f
C6 c_2_s VDD_3V3_1 1.0828f
C7 5v0_add_q_sc_0/ctrl_sign 5v0_addh_sc_tile_2/a_382_n1095# 0.00651f
C8 in_0_over in_1 0.13684f
C9 5v0_addh_sc_tile_0/m1_843_n857# 5v0_addh_sc_tile_1/ctrl_sign 0
C10 5v0_addh_sc_tile_2/pti 5v0_add_q_sc_0/ctrl_over 0.13176f
C11 5v0_addh_sc_tile_0/inv_nti in_1 0.28245f
C12 5v0_addh_sc_tile_0/pti in_1 0.66373f
C13 5v0_add_q_sc_0/5v0_half_adder_selector_sc_0/m1_n239_179# 5v0_addh_sc_tile_2/inv_nti 0
C14 5v0_add_q_sc_1/upstepper_test 5v0_add_q_sc_1/a_n1778_n454# 0
C15 5v0_addh_sc_tile_1/a_n1778_n454# VDD_1V65_3 0
C16 5v0_add_q_sc_1/a_n1205_n937# 5v0_add_q_sc_1/inv_nti 0
C17 5v0_add_q_sc_0/ctrl_sign int_carry 0.00264f
C18 5v0_add_q_sc_0/downstepper_test res_c 0.00302f
C19 5v0_addh_sc_tile_2/5v0_half_adder_selector_sc_0/res_stage0 5v0_add_q_sc_0/ctrl_over 0
C20 5v0_add_q_sc_1/nti 5v0_add_q_sc_1/a_n1373_n454# 0
C21 res_01 5v0_addh_sc_tile_2/m1_103_293# 0
C22 5v0_addh_sc_tile_1/pti VDD_3V3_1 0.57114f
C23 5v0_addh_sc_tile_1/inv_nti 5v0_add_q_sc_1/nti 0
C24 VDD_3V3_0 5v0_addh_sc_tile_2/downstepper_test 0.5243f
C25 VDD_3V3_0 5v0_nter2oter_code_sc_0/nti 0.31492f
C26 5v0_addh_sc_tile_0/nti 5v0_addh_sc_tile_0/5v0_half_adder_selector_sc_0/res_stage0 0.00372f
C27 5v0_add_q_sc_1/inv_pti VDD_3V3_1 0.40305f
C28 5v0_addh_sc_tile_0/inv_pti in_0_over 0
C29 5v0_addh_sc_tile_1/ctrl_sign VDD_3V3_1 0.87932f
C30 5v0_addh_sc_tile_1/ctrl_over 5v0_addh_sc_tile_2/pti 0
C31 5v0_addh_sc_tile_0/m1_843_n857# res_01 0
C32 5v0_add_q_sc_0/downstepper_test VDD_1V65_5 0.13024f
C33 5v0_add_q_sc_0/inv_pti 5v0_add_q_sc_0/pti 0.19726f
C34 5v0_addh_sc_tile_0/a_n1373_n454# VDD_1V65_0 0.00232f
C35 5v0_addh_sc_tile_0/inv_pti 5v0_addh_sc_tile_0/inv_nti 0.25737f
C36 5v0_addh_sc_tile_0/inv_pti 5v0_addh_sc_tile_0/pti 0.44081f
C37 5v0_add_q_sc_0/a_n1373_n454# 5v0_add_q_sc_0/nti 0
C38 5v0_addh_sc_tile_2/ctrl_sign 5v0_addh_sc_tile_2/m1_103_293# 0.61512f
C39 5v0_add_q_sc_0/5v0_half_adder_selector_sc_0/res_stage0 5v0_add_q_sc_0/upstepper_test 0.27475f
C40 5v0_addh_sc_tile_2/downstepper_test 5v0_addh_sc_tile_2/a_382_n1095# 0.00679f
C41 5v0_add_q_sc_1/5v0_half_adder_selector_sc_0/5v0_tgate_sel_2_sc_1/input_A VDD_3V3_1 0.02871f
C42 5v0_addh_sc_tile_0/downstepper_test 5v0_addh_sc_tile_0/5v0_half_adder_selector_sc_0/res_stage0 0.25483f
C43 5v0_add_q_sc_0/inv_pti c_2_o 0.00278f
C44 5v0_addh_sc_tile_1/inv_pti 5v0_addh_sc_tile_2/pti 0
C45 5v0_nter2oter_code_sc_1/nti 5v0_addh_sc_tile_2/pti 0
C46 5v0_add_q_sc_1/upstepper_test 5v0_add_q_sc_1/downstepper_test 0.38867f
C47 5v0_add_q_sc_0/ctrl_sign res_c 0
C48 5v0_add_q_sc_0/5v0_half_adder_selector_sc_0/res_stage0 5v0_add_q_sc_0/ctrl_over 0.09148f
C49 5v0_addh_sc_tile_1/ctrl_over in_1 0
C50 VDD_3V3_1 res_01 1.22329f
C51 5v0_add_q_sc_1/upstepper_test 5v0_add_q_sc_1/5v0_half_adder_selector_sc_0/res_stage0 0.27475f
C52 5v0_add_q_sc_1/inv_nti c_2_s 0.10096f
C53 5v0_addh_sc_tile_0/nti 5v0_addh_sc_tile_0/downstepper_test 0.06935f
C54 5v0_add_q_sc_1/5v0_half_adder_selector_sc_0/m1_n244_n517# VDD_3V3_1 0.28925f
C55 5v0_nter2oter_code_sc_1/nti in_1 0
C56 5v0_addh_sc_tile_0/nti 5v0_nter2oter_code_sc_0/pti 0
C57 int_012 c_2_o 0
C58 5v0_add_q_sc_1/upstepper_test 5v0_add_q_sc_1/5v0_half_adder_selector_sc_0/m1_n239_179# 0.07502f
C59 5v0_addh_sc_tile_1/nti int_012 0.0044f
C60 5v0_addh_sc_tile_0/a_n1778_n454# VDD_1V65_0 0
C61 5v0_addh_sc_tile_2/ctrl_sign VDD_3V3_1 0.00526f
C62 5v0_addh_sc_tile_1/ctrl_over 5v0_add_q_sc_0/5v0_half_adder_selector_sc_0/res_stage0 0
C63 in_2 5v0_addh_sc_tile_2/pti 0
C64 5v0_addh_sc_tile_1/inv_nti 5v0_addh_sc_tile_2/m1_103_293# 0.00513f
C65 5v0_add_q_sc_0/downstepper_test 5v0_add_q_sc_0/upstepper_test 0.38867f
C66 5v0_nter2oter_code_sc_1/pti 5v0_addh_sc_tile_2/downstepper_test 0
C67 5v0_addh_sc_tile_1/a_382_n1095# 5v0_add_q_sc_0/upstepper_test 0.0104f
C68 c_2_s 5v0_addh_sc_tile_0/a_382_n1095# 0
C69 5v0_addh_sc_tile_1/pti 5v0_add_q_sc_1/inv_nti 0.00257f
C70 5v0_nter2oter_code_sc_0/pti 5v0_addh_sc_tile_0/downstepper_test 0.0027f
C71 5v0_add_q_sc_1/inv_pti 5v0_add_q_sc_1/inv_nti 0.08256f
C72 5v0_addh_sc_tile_1/ctrl_sign 5v0_add_q_sc_1/inv_nti 0
C73 5v0_add_q_sc_0/downstepper_test 5v0_add_q_sc_0/ctrl_over 0.02328f
C74 5v0_addh_sc_tile_1/a_382_n1095# 5v0_add_q_sc_0/ctrl_over 0
C75 in_3 5v0_addh_sc_tile_2/inv_pti 0.05631f
C76 5v0_addh_sc_tile_1/m1_843_n857# 5v0_add_q_sc_0/upstepper_test 0.0015f
C77 in_2 in_1 0
C78 5v0_addh_sc_tile_2/upstepper_test 5v0_addh_sc_tile_2/5v0_half_adder_selector_sc_0/5v0_tgate_sel_2_sc_1/input_A 0
C79 5v0_add_q_sc_1/pti c_2_s 0.15254f
C80 5v0_addh_sc_tile_1/pti 5v0_addh_sc_tile_0/a_382_n1095# 0.00485f
C81 5v0_addh_sc_tile_2/ctrl_over 5v0_addh_sc_tile_2/a_n1205_n937# 0
C82 5v0_add_q_sc_1/a_n1373_n454# VDD_3V3_1 0.00122f
C83 5v0_addh_sc_tile_2/upstepper_test res_01 0
C84 5v0_addh_sc_tile_1/ctrl_sign 5v0_addh_sc_tile_0/a_382_n1095# 0.01186f
C85 5v0_addh_sc_tile_0/a_n1205_n937# VDD_3V3_1 0.00891f
C86 5v0_add_q_sc_0/a_n1373_n454# 5v0_add_q_sc_0/pti 0
C87 5v0_addh_sc_tile_1/inv_nti VDD_3V3_1 0.11496f
C88 5v0_addh_sc_tile_1/ctrl_over 5v0_add_q_sc_0/downstepper_test 0
C89 5v0_add_q_sc_0/ctrl_sign 5v0_add_q_sc_0/upstepper_test 0.08746f
C90 int_c01 VDD_1V65_2 0.02356f
C91 5v0_addh_sc_tile_1/ctrl_over 5v0_addh_sc_tile_1/a_382_n1095# 0.70472f
C92 5v0_addh_sc_tile_1/downstepper_test VDD_3V3_0 0.41827f
C93 5v0_addh_sc_tile_1/pti 5v0_add_q_sc_1/pti 0
C94 5v0_addh_sc_tile_1/downstepper_test 5v0_nter2oter_code_sc_1/gf180mcu_fd_sc_mcu7t5v0__nor2_1_0/a_224_472# 0
C95 in_2 5v0_addh_sc_tile_0/inv_pti 0.00153f
C96 5v0_addh_sc_tile_2/upstepper_test 5v0_addh_sc_tile_2/ctrl_sign 0.15846f
C97 VDD_1V65_0 in_1 0.01451f
C98 5v0_addh_sc_tile_1/nti 5v0_addh_sc_tile_2/inv_nti 0
C99 5v0_addh_sc_tile_1/ctrl_sign 5v0_add_q_sc_1/pti 0
C100 5v0_add_q_sc_1/a_n1205_n937# VDD_1V65_1 0.00354f
C101 5v0_add_q_sc_1/inv_pti 5v0_add_q_sc_1/pti 0.19726f
C102 5v0_add_q_sc_0/ctrl_sign 5v0_add_q_sc_0/ctrl_over 0.02618f
C103 5v0_addh_sc_tile_1/a_382_n1095# 5v0_add_q_sc_1/downstepper_test 0.00433f
C104 5v0_addh_sc_tile_1/a_382_n1095# 5v0_addh_sc_tile_1/inv_pti 0.00129f
C105 5v0_addh_sc_tile_1/downstepper_test 5v0_addh_sc_tile_2/a_382_n1095# 0.0018f
C106 5v0_addh_sc_tile_1/ctrl_over 5v0_addh_sc_tile_1/m1_843_n857# 0.10251f
C107 res_01 5v0_addh_sc_tile_0/a_382_n1095# 0.17536f
C108 5v0_addh_sc_tile_0/inv_pti VDD_1V65_0 0.14775f
C109 5v0_addh_sc_tile_1/inv_pti 5v0_addh_sc_tile_1/m1_843_n857# 0
C110 5v0_addh_sc_tile_1/ctrl_over 5v0_add_q_sc_0/ctrl_sign 0.00366f
C111 VDD_3V3_0 5v0_addh_sc_tile_1/pti 0.08682f
C112 5v0_add_q_sc_0/a_n1778_n454# 5v0_add_q_sc_0/inv_nti 0.00214f
C113 5v0_addh_sc_tile_2/ctrl_over 5v0_addh_sc_tile_2/pti 0.16185f
C114 c_2_s int_carry 0.00413f
C115 VDD_3V3_0 5v0_addh_sc_tile_1/ctrl_sign 0.42962f
C116 5v0_addh_sc_tile_1/inv_pti 5v0_add_q_sc_0/ctrl_sign 0
C117 in_0_sign c_2_s 0
C118 5v0_addh_sc_tile_1/ctrl_sign 5v0_nter2oter_code_sc_1/gf180mcu_fd_sc_mcu7t5v0__nor2_1_0/a_224_472# 0
C119 5v0_add_q_sc_1/a_n1373_n454# 5v0_add_q_sc_1/inv_nti 0
C120 VDD_1V65_2 5v0_addh_sc_tile_1/m1_103_293# 0
C121 5v0_addh_sc_tile_2/5v0_half_adder_selector_sc_0/res_stage0 5v0_addh_sc_tile_2/ctrl_over 0.09179f
C122 5v0_addh_sc_tile_1/inv_nti 5v0_add_q_sc_1/inv_nti 0
C123 5v0_addh_sc_tile_2/upstepper_test 5v0_addh_sc_tile_2/nti 0.11981f
C124 VDD_1V65_1 c_2_s 0
C125 VDD_3V3_0 5v0_addh_sc_tile_2/5v0_half_adder_selector_sc_0/5v0_tgate_sel_2_sc_1/input_A 0.02871f
C126 5v0_addh_sc_tile_1/pti int_carry 0
C127 m1_n2844_n810# VDD_1V65_2 0.00448f
C128 5v0_addh_sc_tile_1/ctrl_sign int_carry 0
C129 in_0_sign 5v0_addh_sc_tile_1/pti 0
C130 5v0_add_q_sc_0/5v0_half_adder_selector_sc_0/m1_n244_n517# 5v0_add_q_sc_0/5v0_half_adder_selector_sc_0/5v0_tgate_sel_2_sc_1/input_A 0.02928f
C131 5v0_addh_sc_tile_1/ctrl_over 5v0_nter2oter_code_sc_0/nti 0
C132 5v0_addh_sc_tile_1/inv_nti 5v0_addh_sc_tile_0/a_382_n1095# 0
C133 VDD_3V3_0 res_01 0.0901f
C134 5v0_addh_sc_tile_2/5v0_half_adder_selector_sc_0/5v0_tgate_sel_2_sc_1/input_A 5v0_addh_sc_tile_2/a_382_n1095# 0.02928f
C135 in_0_sign 5v0_addh_sc_tile_1/ctrl_sign 0
C136 5v0_addh_sc_tile_0/carry_0_probe VDD_1V65_2 0.03841f
C137 5v0_addh_sc_tile_2/m1_843_n857# 5v0_addh_sc_tile_2/inv_nti 0.36668f
C138 VDD_3V3_0 res_0 0.09575f
C139 in_3 5v0_addh_sc_tile_2/m1_103_293# 0
C140 5v0_add_q_sc_1/a_n1373_n454# 5v0_add_q_sc_1/pti 0
C141 5v0_add_q_sc_1/inv_pti VDD_1V65_1 0.14775f
C142 5v0_addh_sc_tile_2/a_382_n1095# res_01 0
C143 5v0_addh_sc_tile_2/ctrl_over 5v0_add_q_sc_0/5v0_half_adder_selector_sc_0/res_stage0 0.00474f
C144 VDD_3V3_0 5v0_addh_sc_tile_2/ctrl_sign 1.61336f
C145 5v0_addh_sc_tile_2/ctrl_sign 5v0_nter2oter_code_sc_1/gf180mcu_fd_sc_mcu7t5v0__nor2_1_0/a_224_472# 0.00629f
C146 5v0_addh_sc_tile_1/inv_nti 5v0_add_q_sc_1/pti 0
C147 5v0_add_q_sc_1/upstepper_test int_c01 0.02545f
C148 5v0_add_q_sc_0/5v0_half_adder_selector_sc_0/m1_n239_179# 5v0_addh_sc_tile_2/pti 0
C149 res_0 5v0_addh_sc_tile_2/a_382_n1095# 0.16245f
C150 5v0_add_q_sc_0/a_n1778_n454# int_carry 0.00116f
C151 5v0_nter2oter_code_sc_1/pti 5v0_addh_sc_tile_1/ctrl_sign 0.28956f
C152 5v0_add_q_sc_0/a_n1373_n454# 5v0_add_q_sc_0/inv_pti 0.00135f
C153 5v0_addh_sc_tile_2/ctrl_sign 5v0_addh_sc_tile_2/a_382_n1095# 0.07412f
C154 in_0_sign res_01 0
C155 5v0_add_q_sc_1/5v0_half_adder_selector_sc_0/m1_n244_n517# int_carry 0.16119f
C156 5v0_addh_sc_tile_2/ctrl_sign int_carry 0
C157 5v0_addh_sc_tile_1/downstepper_test in_0_over 0
C158 in_2 5v0_nter2oter_code_sc_0/nti 0
C159 int_012 5v0_addh_sc_tile_2/inv_nti 0
C160 5v0_addh_sc_tile_2/ctrl_over 5v0_add_q_sc_0/downstepper_test 0.01272f
C161 5v0_nter2oter_code_sc_1/pti res_01 0
C162 VDD_3V3_0 5v0_addh_sc_tile_1/inv_nti 0.66943f
C163 5v0_addh_sc_tile_1/5v0_half_adder_selector_sc_0/res_stage0 VDD_3V3_1 0.01812f
C164 c_2_s in_0_over 0.00327f
C165 5v0_addh_sc_tile_0/pti c_2_s 0.00768f
C166 5v0_addh_sc_tile_0/inv_nti c_2_s 0.00142f
C167 5v0_add_q_sc_0/5v0_half_adder_selector_sc_0/m1_n244_n517# 5v0_addh_sc_tile_2/inv_nti 0
C168 VDD_3V3_0 5v0_addh_sc_tile_2/nti 0.7527f
C169 5v0_nter2oter_code_sc_1/pti 5v0_addh_sc_tile_2/ctrl_sign 0.0299f
C170 5v0_addh_sc_tile_0/inv_pti int_c01 0.00639f
C171 5v0_add_q_sc_0/5v0_half_adder_selector_sc_0/res_stage0 5v0_add_q_sc_0/5v0_half_adder_selector_sc_0/m1_n239_179# 0.18379f
C172 5v0_addh_sc_tile_0/upstepper_test 5v0_addh_sc_tile_0/a_n1373_n454# 0
C173 5v0_add_q_sc_1/a_n1205_n937# 5v0_add_q_sc_1/downstepper_test 0.00453f
C174 5v0_addh_sc_tile_1/pti in_0_over 0.00417f
C175 5v0_addh_sc_tile_2/nti 5v0_addh_sc_tile_2/a_382_n1095# 0
C176 5v0_addh_sc_tile_1/inv_nti int_carry 0.0263f
C177 5v0_add_q_sc_0/a_n1778_n454# VDD_1V65_5 0
C178 5v0_addh_sc_tile_2/ctrl_over VDD_1V65_4 0.00145f
C179 5v0_addh_sc_tile_0/inv_pti c01 0.17523f
C180 5v0_addh_sc_tile_1/pti 5v0_addh_sc_tile_0/pti 0
C181 5v0_addh_sc_tile_1/pti 5v0_addh_sc_tile_0/inv_nti 0
C182 5v0_addh_sc_tile_1/ctrl_sign in_0_over 0.03467f
C183 5v0_add_q_sc_1/a_n1778_n454# c_2_s 0
C184 5v0_add_q_sc_1/5v0_half_adder_selector_sc_0/res_stage0 5v0_add_q_sc_1/a_n1205_n937# 0
C185 5v0_add_q_sc_1/a_n1373_n454# VDD_1V65_1 0.00232f
C186 5v0_addh_sc_tile_1/pti 5v0_add_q_sc_0/upstepper_test 0.0029f
C187 5v0_addh_sc_tile_0/pti 5v0_addh_sc_tile_1/ctrl_sign 0.00125f
C188 5v0_addh_sc_tile_0/inv_nti 5v0_addh_sc_tile_1/ctrl_sign 0.02895f
C189 5v0_addh_sc_tile_2/ctrl_over 5v0_add_q_sc_0/ctrl_sign 0.2177f
C190 5v0_addh_sc_tile_1/ctrl_over 5v0_addh_sc_tile_1/downstepper_test 0.16058f
C191 5v0_addh_sc_tile_0/5v0_half_adder_selector_sc_0/res_stage0 VDD_3V3_1 0.16177f
C192 5v0_addh_sc_tile_2/upstepper_test in_3 0.01604f
C193 5v0_add_q_sc_0/5v0_half_adder_selector_sc_0/res_stage0 5v0_add_q_sc_0/nti 0.00372f
C194 5v0_addh_sc_tile_1/ctrl_sign 5v0_add_q_sc_0/upstepper_test 0
C195 5v0_add_q_sc_0/downstepper_test 5v0_add_q_sc_0/5v0_half_adder_selector_sc_0/m1_n239_179# 0.09961f
C196 5v0_addh_sc_tile_1/downstepper_test 5v0_nter2oter_code_sc_1/nti 0
C197 5v0_addh_sc_tile_1/ctrl_over c_2_s 0
C198 5v0_addh_sc_tile_1/downstepper_test 5v0_addh_sc_tile_1/inv_pti 0.1369f
C199 5v0_addh_sc_tile_1/a_382_n1095# 5v0_add_q_sc_0/5v0_half_adder_selector_sc_0/m1_n239_179# 0.0035f
C200 5v0_add_q_sc_1/a_n1778_n454# 5v0_addh_sc_tile_1/pti 0
C201 5v0_addh_sc_tile_0/upstepper_test 5v0_addh_sc_tile_0/a_n1778_n454# 0
C202 in_0_over res_01 0.21152f
C203 5v0_addh_sc_tile_0/nti VDD_3V3_1 0.74269f
C204 5v0_nter2oter_code_sc_1/pti 5v0_addh_sc_tile_2/nti 0
C205 5v0_addh_sc_tile_0/pti res_01 0
C206 5v0_addh_sc_tile_1/inv_pti c_2_s 0.12531f
C207 5v0_addh_sc_tile_0/inv_nti res_01 0.0179f
C208 c_2_s 5v0_add_q_sc_1/downstepper_test 0.25694f
C209 5v0_addh_sc_tile_0/carry_0_probe in_1 0.00136f
C210 5v0_add_q_sc_0/a_n1778_n454# 5v0_add_q_sc_0/upstepper_test 0
C211 5v0_addh_sc_tile_2/5v0_half_adder_selector_sc_0/5v0_tgate_sel_2_sc_1/input_A 5v0_add_q_sc_0/ctrl_over 0
C212 5v0_addh_sc_tile_2/ctrl_over 5v0_addh_sc_tile_2/downstepper_test 0.02378f
C213 5v0_addh_sc_tile_1/ctrl_over 5v0_addh_sc_tile_1/pti 0.11567f
C214 5v0_addh_sc_tile_2/ctrl_over 5v0_nter2oter_code_sc_0/nti 0.22761f
C215 5v0_addh_sc_tile_0/downstepper_test VDD_3V3_1 0.51279f
C216 5v0_addh_sc_tile_1/5v0_half_adder_selector_sc_0/res_stage0 5v0_addh_sc_tile_0/a_382_n1095# 0
C217 5v0_addh_sc_tile_0/m1_103_293# in_1 0
C218 5v0_add_q_sc_0/downstepper_test 5v0_add_q_sc_0/nti 0.07205f
C219 5v0_addh_sc_tile_1/ctrl_over 5v0_addh_sc_tile_1/ctrl_sign 0.49329f
C220 5v0_nter2oter_code_sc_0/pti VDD_3V3_1 0.29053f
C221 5v0_add_q_sc_1/upstepper_test c_2_o 0.00943f
C222 5v0_addh_sc_tile_1/a_382_n1095# 5v0_add_q_sc_0/nti 0
C223 5v0_addh_sc_tile_0/inv_pti m1_n2844_n810# 0.00753f
C224 5v0_addh_sc_tile_0/inv_nti 5v0_addh_sc_tile_2/ctrl_sign 0
C225 5v0_add_q_sc_1/5v0_half_adder_selector_sc_0/res_stage0 c_2_s 0.22434f
C226 5v0_addh_sc_tile_1/nti 5v0_addh_sc_tile_2/pti 0
C227 5v0_add_q_sc_0/ctrl_over res_01 0
C228 5v0_addh_sc_tile_1/pti 5v0_add_q_sc_1/downstepper_test 0.00147f
C229 5v0_nter2oter_code_sc_1/nti 5v0_addh_sc_tile_1/pti 0
C230 5v0_addh_sc_tile_1/inv_pti 5v0_addh_sc_tile_1/pti 0.37325f
C231 5v0_add_q_sc_0/ctrl_sign 5v0_add_q_sc_0/5v0_half_adder_selector_sc_0/m1_n239_179# 0.307f
C232 c_2_s 5v0_add_q_sc_1/5v0_half_adder_selector_sc_0/m1_n239_179# 0.30422f
C233 5v0_addh_sc_tile_1/nti 5v0_addh_sc_tile_2/5v0_half_adder_selector_sc_0/res_stage0 0
C234 5v0_addh_sc_tile_1/ctrl_sign 5v0_add_q_sc_1/downstepper_test 0.00227f
C235 5v0_addh_sc_tile_0/carry_0_probe 5v0_addh_sc_tile_0/inv_pti 0.01451f
C236 res_0 5v0_add_q_sc_0/ctrl_over 0
C237 5v0_addh_sc_tile_1/inv_pti 5v0_addh_sc_tile_1/ctrl_sign 0.41772f
C238 5v0_addh_sc_tile_1/5v0_half_adder_selector_sc_0/5v0_tgate_sel_2_sc_1/input_A 5v0_addh_sc_tile_1/a_382_n1095# 0.02928f
C239 5v0_add_q_sc_1/inv_pti 5v0_add_q_sc_1/downstepper_test 0.07669f
C240 5v0_nter2oter_code_sc_1/nti 5v0_addh_sc_tile_1/ctrl_sign 0.13214f
C241 5v0_addh_sc_tile_1/m1_843_n857# 5v0_add_q_sc_0/nti 0
C242 5v0_addh_sc_tile_2/ctrl_sign 5v0_add_q_sc_0/ctrl_over 0.00758f
C243 5v0_add_q_sc_0/downstepper_test 5v0_addh_sc_tile_1/m1_103_293# 0
C244 5v0_addh_sc_tile_0/inv_pti 5v0_addh_sc_tile_0/m1_103_293# 0.17653f
C245 5v0_add_q_sc_1/5v0_half_adder_selector_sc_0/5v0_tgate_sel_2_sc_1/input_A 5v0_add_q_sc_1/downstepper_test 0
C246 5v0_addh_sc_tile_1/nti in_1 0.00579f
C247 5v0_addh_sc_tile_1/a_382_n1095# 5v0_addh_sc_tile_1/m1_103_293# 0.07764f
C248 5v0_addh_sc_tile_0/upstepper_test in_1 0.01604f
C249 5v0_addh_sc_tile_1/ctrl_over res_01 0.25947f
C250 5v0_add_q_sc_1/5v0_half_adder_selector_sc_0/res_stage0 5v0_add_q_sc_1/inv_pti 0
C251 5v0_addh_sc_tile_0/a_n1205_n937# in_0_over 0
C252 VDD_3V3_0 VDD_1V65_3 0.04264f
C253 5v0_addh_sc_tile_1/inv_nti in_0_over 0
C254 5v0_addh_sc_tile_0/a_n1205_n937# 5v0_addh_sc_tile_0/inv_nti 0
C255 5v0_addh_sc_tile_0/5v0_half_adder_selector_sc_0/res_stage0 5v0_addh_sc_tile_0/a_382_n1095# 0.08951f
C256 5v0_add_q_sc_1/inv_pti 5v0_add_q_sc_1/5v0_half_adder_selector_sc_0/m1_n239_179# 0
C257 5v0_add_q_sc_0/ctrl_sign 5v0_add_q_sc_0/nti 0
C258 5v0_addh_sc_tile_0/pti 5v0_addh_sc_tile_1/inv_nti 0
C259 5v0_add_q_sc_1/5v0_half_adder_selector_sc_0/res_stage0 5v0_add_q_sc_1/5v0_half_adder_selector_sc_0/5v0_tgate_sel_2_sc_1/input_A 0.00253f
C260 5v0_nter2oter_code_sc_1/nti res_01 0.01204f
C261 5v0_addh_sc_tile_1/ctrl_over 5v0_addh_sc_tile_2/ctrl_sign 0.019f
C262 VDD_3V3_0 in_3 1.10285f
C263 5v0_addh_sc_tile_1/inv_pti res_01 0.05503f
C264 5v0_addh_sc_tile_1/m1_843_n857# 5v0_addh_sc_tile_1/m1_103_293# 0.20659f
C265 5v0_addh_sc_tile_1/inv_nti 5v0_add_q_sc_0/upstepper_test 0.00109f
C266 in_2 5v0_addh_sc_tile_1/ctrl_sign 0.1696f
C267 5v0_addh_sc_tile_0/5v0_half_adder_selector_sc_0/res_stage0 5v0_addh_sc_tile_0/5v0_half_adder_selector_sc_0/5v0_tgate_sel_2_sc_1/input_A 0.00253f
C268 5v0_addh_sc_tile_0/carry_0_probe 5v0_addh_sc_tile_1/a_382_n1095# 0
C269 5v0_addh_sc_tile_0/upstepper_test 5v0_addh_sc_tile_0/inv_pti 0.07282f
C270 5v0_add_q_sc_1/5v0_half_adder_selector_sc_0/m1_n244_n517# 5v0_add_q_sc_1/downstepper_test 0.00507f
C271 VDD_3V3_0 5v0_addh_sc_tile_1/5v0_half_adder_selector_sc_0/res_stage0 0.11354f
C272 in_3 5v0_addh_sc_tile_2/a_382_n1095# 0.09307f
C273 5v0_addh_sc_tile_1/inv_pti 5v0_addh_sc_tile_2/ctrl_sign 0
C274 5v0_nter2oter_code_sc_1/nti 5v0_addh_sc_tile_2/ctrl_sign 0.01527f
C275 5v0_addh_sc_tile_0/nti 5v0_addh_sc_tile_0/a_382_n1095# 0
C276 5v0_addh_sc_tile_2/inv_pti 5v0_addh_sc_tile_2/m1_103_293# 0.17639f
C277 5v0_add_q_sc_0/a_n1205_n937# 5v0_add_q_sc_0/5v0_half_adder_selector_sc_0/res_stage0 0
C278 in_0_sign VDD_1V65_3 0
C279 5v0_addh_sc_tile_1/5v0_half_adder_selector_sc_0/res_stage0 5v0_addh_sc_tile_2/a_382_n1095# 0
C280 5v0_add_q_sc_1/5v0_half_adder_selector_sc_0/res_stage0 5v0_add_q_sc_1/5v0_half_adder_selector_sc_0/m1_n244_n517# 0.08646f
C281 VDD_1V65_0 5v0_addh_sc_tile_1/ctrl_sign 0
C282 5v0_addh_sc_tile_2/nti 5v0_add_q_sc_0/ctrl_over 0
C283 5v0_add_q_sc_0/pti 5v0_add_q_sc_0/downstepper_test 0.0825f
C284 5v0_addh_sc_tile_1/a_382_n1095# 5v0_add_q_sc_0/pti 0
C285 in_2 res_01 0.02606f
C286 5v0_addh_sc_tile_2/pti 5v0_addh_sc_tile_2/m1_843_n857# 0.11666f
C287 5v0_addh_sc_tile_0/downstepper_test 5v0_addh_sc_tile_0/a_382_n1095# 0.00679f
C288 VDD_3V3_0 5v0_nter2oter_code_sc_0/gf180mcu_fd_sc_mcu7t5v0__nor2_1_0/a_224_472# 0.01413f
C289 5v0_add_q_sc_1/5v0_half_adder_selector_sc_0/m1_n244_n517# 5v0_add_q_sc_1/5v0_half_adder_selector_sc_0/m1_n239_179# 0.00585f
C290 VDD_3V3_0 5v0_addh_sc_tile_1/a_n1205_n937# 0.00891f
C291 5v0_add_q_sc_0/downstepper_test c_2_o 0.0085f
C292 5v0_addh_sc_tile_1/ctrl_over 5v0_addh_sc_tile_1/inv_nti 0.47006f
C293 5v0_addh_sc_tile_1/downstepper_test 5v0_addh_sc_tile_2/ctrl_over 0.01399f
C294 5v0_addh_sc_tile_1/a_382_n1095# c_2_o 0.08702f
C295 5v0_addh_sc_tile_0/downstepper_test 5v0_addh_sc_tile_0/5v0_half_adder_selector_sc_0/5v0_tgate_sel_2_sc_1/input_A 0
C296 in_2 5v0_addh_sc_tile_2/ctrl_sign 0.0048f
C297 5v0_addh_sc_tile_1/nti 5v0_addh_sc_tile_1/a_382_n1095# 0
C298 5v0_add_q_sc_1/a_n1373_n454# 5v0_add_q_sc_1/downstepper_test 0.00442f
C299 5v0_addh_sc_tile_1/ctrl_over 5v0_addh_sc_tile_2/nti 0
C300 5v0_add_q_sc_0/pti 5v0_addh_sc_tile_1/m1_843_n857# 0.00111f
C301 5v0_nter2oter_code_sc_1/nti 5v0_addh_sc_tile_1/inv_nti 0.00264f
C302 5v0_addh_sc_tile_1/inv_nti 5v0_add_q_sc_1/downstepper_test 0.00441f
C303 5v0_addh_sc_tile_1/inv_pti 5v0_addh_sc_tile_1/inv_nti 0.26136f
C304 5v0_add_q_sc_0/a_n1205_n937# 5v0_add_q_sc_0/downstepper_test 0.00453f
C305 5v0_addh_sc_tile_1/m1_843_n857# c_2_o 0.18406f
C306 5v0_add_q_sc_1/a_n1205_n937# int_c01 0
C307 5v0_add_q_sc_0/pti 5v0_add_q_sc_0/ctrl_sign 0
C308 VDD_3V3_0 5v0_addh_sc_tile_0/nti 0
C309 5v0_addh_sc_tile_2/inv_nti 5v0_addh_sc_tile_2/a_n1205_n937# 0
C310 int_012 5v0_addh_sc_tile_2/pti 0.00286f
C311 VDD_3V3_0 5v0_addh_sc_tile_1/a_n1373_n454# 0.00122f
C312 5v0_addh_sc_tile_2/ctrl_over 5v0_addh_sc_tile_1/pti 0
C313 in_0_sign 5v0_addh_sc_tile_0/5v0_half_adder_selector_sc_0/res_stage0 0.22359f
C314 5v0_addh_sc_tile_1/nti 5v0_add_q_sc_0/ctrl_sign 0
C315 VDD_3V3_0 5v0_addh_sc_tile_0/downstepper_test 0
C316 5v0_addh_sc_tile_1/downstepper_test 5v0_addh_sc_tile_1/upstepper_test 0.38867f
C317 5v0_addh_sc_tile_2/ctrl_over 5v0_addh_sc_tile_1/ctrl_sign 0
C318 5v0_add_q_sc_0/5v0_half_adder_selector_sc_0/m1_n244_n517# 5v0_addh_sc_tile_2/pti 0.00139f
C319 VDD_3V3_0 5v0_nter2oter_code_sc_0/pti 0.17187f
C320 5v0_add_q_sc_0/inv_pti 5v0_add_q_sc_0/5v0_half_adder_selector_sc_0/res_stage0 0
C321 5v0_addh_sc_tile_1/upstepper_test c_2_s 0
C322 int_012 in_1 0.00145f
C323 5v0_addh_sc_tile_2/ctrl_over 5v0_addh_sc_tile_2/5v0_half_adder_selector_sc_0/5v0_tgate_sel_2_sc_1/input_A 0.04656f
C324 5v0_addh_sc_tile_2/upstepper_test 5v0_addh_sc_tile_2/inv_pti 0.07254f
C325 5v0_addh_sc_tile_0/nti in_0_sign 0
C326 5v0_addh_sc_tile_0/a_n1205_n937# VDD_1V65_0 0.00354f
C327 5v0_add_q_sc_1/nti VDD_3V3_1 0.5318f
C328 5v0_add_q_sc_0/5v0_half_adder_selector_sc_0/5v0_tgate_sel_2_sc_1/input_A 5v0_add_q_sc_0/5v0_half_adder_selector_sc_0/res_stage0 0.00253f
C329 5v0_addh_sc_tile_2/inv_nti 5v0_addh_sc_tile_2/a_n1373_n454# 0
C330 int_c01 c_2_s 0.20636f
C331 5v0_addh_sc_tile_2/ctrl_over res_01 0.00181f
C332 5v0_addh_sc_tile_1/nti 5v0_addh_sc_tile_2/downstepper_test 0
C333 in_0_sign 5v0_addh_sc_tile_0/downstepper_test 0.14463f
C334 c_2_s c01 0.00205f
C335 5v0_addh_sc_tile_1/upstepper_test 5v0_addh_sc_tile_1/pti 0.02161f
C336 5v0_addh_sc_tile_1/5v0_half_adder_selector_sc_0/res_stage0 in_0_over 0
C337 5v0_addh_sc_tile_2/ctrl_over res_0 0.20137f
C338 5v0_nter2oter_code_sc_1/pti 5v0_addh_sc_tile_0/nti 0
C339 5v0_addh_sc_tile_1/upstepper_test 5v0_addh_sc_tile_1/ctrl_sign 0.10431f
C340 5v0_addh_sc_tile_2/pti 5v0_addh_sc_tile_2/inv_nti 0.42143f
C341 5v0_addh_sc_tile_2/ctrl_over 5v0_addh_sc_tile_2/ctrl_sign 0.63344f
C342 5v0_addh_sc_tile_1/pti 5v0_add_q_sc_0/5v0_half_adder_selector_sc_0/m1_n239_179# 0
C343 5v0_add_q_sc_0/inv_pti 5v0_add_q_sc_0/downstepper_test 0.07797f
C344 5v0_add_q_sc_0/5v0_half_adder_selector_sc_0/m1_n244_n517# 5v0_add_q_sc_0/5v0_half_adder_selector_sc_0/res_stage0 0.08646f
C345 5v0_addh_sc_tile_1/downstepper_test 5v0_addh_sc_tile_1/5v0_half_adder_selector_sc_0/5v0_tgate_sel_2_sc_1/input_A 0
C346 5v0_add_q_sc_1/inv_pti int_c01 0.08427f
C347 5v0_add_q_sc_0/inv_pti 5v0_addh_sc_tile_1/a_382_n1095# 0
C348 5v0_addh_sc_tile_1/ctrl_sign int_c01 0
C349 5v0_add_q_sc_0/5v0_half_adder_selector_sc_0/m1_n239_179# 5v0_addh_sc_tile_1/ctrl_sign 0
C350 5v0_nter2oter_code_sc_1/pti 5v0_addh_sc_tile_0/downstepper_test 0.00775f
C351 5v0_addh_sc_tile_2/5v0_half_adder_selector_sc_0/res_stage0 5v0_addh_sc_tile_2/inv_nti 0.02878f
C352 in_3 5v0_add_q_sc_0/ctrl_over 0.00136f
C353 5v0_nter2oter_code_sc_1/pti 5v0_nter2oter_code_sc_0/pti 0.20957f
C354 5v0_add_q_sc_0/5v0_half_adder_selector_sc_0/5v0_tgate_sel_2_sc_1/input_A 5v0_add_q_sc_0/downstepper_test 0
C355 5v0_addh_sc_tile_2/inv_nti 5v0_addh_sc_tile_2/a_n1778_n454# 0.00226f
C356 5v0_addh_sc_tile_1/downstepper_test 5v0_addh_sc_tile_1/m1_103_293# 0.10533f
C357 5v0_add_q_sc_0/ctrl_sign 5v0_addh_sc_tile_2/m1_843_n857# 0.00871f
C358 5v0_addh_sc_tile_1/ctrl_over VDD_1V65_3 0.02438f
C359 5v0_add_q_sc_0/inv_pti 5v0_addh_sc_tile_1/m1_843_n857# 0
C360 5v0_addh_sc_tile_1/upstepper_test res_01 0.01604f
C361 5v0_addh_sc_tile_1/pti 5v0_add_q_sc_0/nti 0
C362 5v0_addh_sc_tile_0/5v0_half_adder_selector_sc_0/res_stage0 in_0_over 0.09179f
C363 5v0_addh_sc_tile_1/a_382_n1095# int_012 0.16245f
C364 5v0_addh_sc_tile_1/downstepper_test m1_n2844_n810# 0
C365 c_2_s 5v0_addh_sc_tile_1/m1_103_293# 0.22665f
C366 5v0_addh_sc_tile_1/ctrl_sign 5v0_add_q_sc_0/nti 0
C367 5v0_add_q_sc_0/5v0_half_adder_selector_sc_0/m1_n239_179# res_01 0
C368 5v0_addh_sc_tile_1/inv_pti VDD_1V65_3 0.14775f
C369 5v0_addh_sc_tile_0/inv_nti 5v0_addh_sc_tile_0/5v0_half_adder_selector_sc_0/res_stage0 0.02878f
C370 5v0_addh_sc_tile_0/pti 5v0_addh_sc_tile_0/5v0_half_adder_selector_sc_0/res_stage0 0.01078f
C371 5v0_addh_sc_tile_2/ctrl_over 5v0_addh_sc_tile_1/inv_nti 0.00155f
C372 5v0_addh_sc_tile_0/m1_843_n857# VDD_3V3_1 0.22222f
C373 5v0_add_q_sc_1/nti 5v0_add_q_sc_1/inv_nti 0.20056f
C374 5v0_addh_sc_tile_1/upstepper_test 5v0_addh_sc_tile_2/ctrl_sign 0
C375 5v0_addh_sc_tile_1/ctrl_over 5v0_addh_sc_tile_1/5v0_half_adder_selector_sc_0/res_stage0 0.11033f
C376 5v0_add_q_sc_0/inv_pti 5v0_add_q_sc_0/ctrl_sign 0.00263f
C377 5v0_add_q_sc_0/5v0_half_adder_selector_sc_0/m1_n244_n517# 5v0_add_q_sc_0/downstepper_test 0.00507f
C378 5v0_add_q_sc_0/5v0_half_adder_selector_sc_0/m1_n244_n517# 5v0_addh_sc_tile_1/a_382_n1095# 0
C379 5v0_add_q_sc_1/a_n1205_n937# c_2_o 0
C380 5v0_addh_sc_tile_1/downstepper_test 5v0_addh_sc_tile_0/carry_0_probe 0.01317f
C381 5v0_add_q_sc_1/5v0_half_adder_selector_sc_0/m1_n244_n517# int_c01 0.07888f
C382 5v0_add_q_sc_0/5v0_half_adder_selector_sc_0/res_stage0 5v0_addh_sc_tile_2/inv_nti 0
C383 m1_n2844_n810# c_2_s 0.00441f
C384 5v0_nter2oter_code_sc_1/nti in_3 0
C385 5v0_addh_sc_tile_2/ctrl_over 5v0_addh_sc_tile_2/nti 0.007f
C386 5v0_addh_sc_tile_1/5v0_half_adder_selector_sc_0/5v0_tgate_sel_2_sc_1/input_A 5v0_addh_sc_tile_1/ctrl_sign 0
C387 5v0_addh_sc_tile_1/pti 5v0_addh_sc_tile_1/m1_103_293# 0.10002f
C388 5v0_addh_sc_tile_0/nti in_0_over 0.00162f
C389 5v0_add_q_sc_0/5v0_half_adder_selector_sc_0/5v0_tgate_sel_2_sc_1/input_A 5v0_add_q_sc_0/ctrl_sign 0
C390 5v0_add_q_sc_1/nti 5v0_addh_sc_tile_0/a_382_n1095# 0
C391 VDD_3V3_0 5v0_addh_sc_tile_2/inv_pti 1.08715f
C392 5v0_addh_sc_tile_0/carry_0_probe c_2_s 0.01575f
C393 5v0_addh_sc_tile_1/inv_pti 5v0_addh_sc_tile_1/5v0_half_adder_selector_sc_0/res_stage0 0.01365f
C394 5v0_nter2oter_code_sc_1/gf180mcu_fd_sc_mcu7t5v0__nor2_1_0/a_224_472# 5v0_addh_sc_tile_2/inv_pti 0
C395 5v0_addh_sc_tile_0/nti 5v0_addh_sc_tile_0/pti 0.24563f
C396 5v0_addh_sc_tile_1/ctrl_sign 5v0_addh_sc_tile_1/m1_103_293# 0.60951f
C397 5v0_addh_sc_tile_0/nti 5v0_addh_sc_tile_0/inv_nti 0.22786f
C398 5v0_add_q_sc_0/a_n1778_n454# 5v0_add_q_sc_0/nti 0.00142f
C399 int_012 5v0_add_q_sc_0/ctrl_sign 0.01026f
C400 5v0_addh_sc_tile_1/ctrl_over 5v0_nter2oter_code_sc_0/gf180mcu_fd_sc_mcu7t5v0__nor2_1_0/a_224_472# 0
C401 c_2_s 5v0_addh_sc_tile_0/m1_103_293# 0
C402 5v0_addh_sc_tile_0/downstepper_test in_0_over 0.02344f
C403 5v0_addh_sc_tile_2/a_382_n1095# 5v0_addh_sc_tile_2/inv_pti 0.00129f
C404 5v0_addh_sc_tile_1/ctrl_over 5v0_addh_sc_tile_1/a_n1205_n937# 0.00169f
C405 5v0_addh_sc_tile_0/pti 5v0_addh_sc_tile_0/downstepper_test 0.20149f
C406 5v0_addh_sc_tile_1/ctrl_sign m1_n2844_n810# 0.00105f
C407 5v0_addh_sc_tile_0/inv_nti 5v0_addh_sc_tile_0/downstepper_test 0.29989f
C408 5v0_add_q_sc_1/nti 5v0_add_q_sc_1/pti 0.15563f
C409 5v0_addh_sc_tile_1/downstepper_test c_2_o 0
C410 5v0_addh_sc_tile_0/inv_nti 5v0_nter2oter_code_sc_0/pti 0.00589f
C411 5v0_addh_sc_tile_2/upstepper_test 5v0_addh_sc_tile_2/m1_103_293# 0.07773f
C412 5v0_addh_sc_tile_1/ctrl_over 5v0_addh_sc_tile_0/5v0_half_adder_selector_sc_0/res_stage0 0
C413 5v0_addh_sc_tile_0/carry_0_probe 5v0_addh_sc_tile_1/pti 0.0051f
C414 5v0_addh_sc_tile_1/upstepper_test 5v0_addh_sc_tile_1/inv_nti 0.00736f
C415 5v0_add_q_sc_0/a_n1373_n454# 5v0_add_q_sc_0/downstepper_test 0.00442f
C416 5v0_add_q_sc_0/5v0_half_adder_selector_sc_0/m1_n244_n517# 5v0_add_q_sc_0/ctrl_sign 0
C417 5v0_add_q_sc_0/downstepper_test 5v0_addh_sc_tile_2/inv_nti 0
C418 5v0_addh_sc_tile_1/nti 5v0_addh_sc_tile_1/downstepper_test 0.06935f
C419 5v0_add_q_sc_1/a_n1373_n454# int_c01 0.00136f
C420 5v0_addh_sc_tile_0/carry_0_probe 5v0_addh_sc_tile_1/ctrl_sign 0.02297f
C421 5v0_addh_sc_tile_1/inv_nti int_c01 0
C422 5v0_addh_sc_tile_1/pti 5v0_addh_sc_tile_0/m1_103_293# 0.00135f
C423 res_01 5v0_addh_sc_tile_1/m1_103_293# 0
C424 5v0_add_q_sc_0/5v0_half_adder_selector_sc_0/m1_n239_179# 5v0_addh_sc_tile_1/inv_nti 0
C425 c_2_o c_2_s 0.02923f
C426 5v0_addh_sc_tile_1/ctrl_sign 5v0_addh_sc_tile_0/m1_103_293# 0.00101f
C427 5v0_addh_sc_tile_1/ctrl_over 5v0_addh_sc_tile_0/nti 0
C428 int_012 5v0_nter2oter_code_sc_0/nti 0.23186f
C429 VDD_1V65_4 5v0_addh_sc_tile_2/inv_nti 0.08611f
C430 5v0_addh_sc_tile_1/pti c_2_o 0.16959f
C431 5v0_addh_sc_tile_0/carry_0_probe res_01 0.00236f
C432 5v0_addh_sc_tile_1/nti 5v0_addh_sc_tile_1/pti 0.24193f
C433 5v0_addh_sc_tile_0/m1_843_n857# 5v0_addh_sc_tile_0/a_382_n1095# 0.05013f
C434 5v0_addh_sc_tile_1/inv_nti 5v0_add_q_sc_0/nti 0
C435 5v0_addh_sc_tile_1/ctrl_over 5v0_addh_sc_tile_0/downstepper_test 0
C436 5v0_nter2oter_code_sc_1/nti 5v0_addh_sc_tile_0/nti 0
C437 5v0_add_q_sc_1/inv_pti c_2_o 0.0024f
C438 5v0_add_q_sc_0/ctrl_sign 5v0_addh_sc_tile_2/inv_nti 0.12058f
C439 5v0_addh_sc_tile_1/ctrl_sign c_2_o 0.01552f
C440 5v0_addh_sc_tile_1/ctrl_over 5v0_nter2oter_code_sc_0/pti 0.00235f
C441 5v0_addh_sc_tile_0/upstepper_test 5v0_addh_sc_tile_1/ctrl_sign 0
C442 5v0_addh_sc_tile_1/inv_pti 5v0_addh_sc_tile_1/a_n1373_n454# 0.00135f
C443 5v0_addh_sc_tile_1/nti 5v0_addh_sc_tile_1/ctrl_sign 0.14557f
C444 5v0_addh_sc_tile_0/m1_103_293# res_01 0
C445 5v0_add_q_sc_1/inv_nti VDD_3V3_1 0.56275f
C446 5v0_add_q_sc_1/5v0_half_adder_selector_sc_0/5v0_tgate_sel_2_sc_1/input_A c_2_o 0.04656f
C447 5v0_nter2oter_code_sc_1/nti 5v0_addh_sc_tile_0/downstepper_test 0
C448 5v0_add_q_sc_0/pti 5v0_add_q_sc_0/a_n1778_n454# 0.00135f
C449 5v0_add_q_sc_1/nti int_carry 0
C450 VDD_3V3_1 5v0_addh_sc_tile_0/a_382_n1095# 0.63349f
C451 in_0_sign 5v0_add_q_sc_1/nti 0
C452 5v0_addh_sc_tile_1/inv_nti 5v0_addh_sc_tile_1/m1_103_293# 0.35313f
C453 in_2 5v0_addh_sc_tile_0/nti 0.0018f
C454 c_2_o res_01 0.00136f
C455 5v0_addh_sc_tile_2/5v0_half_adder_selector_sc_0/res_stage0 5v0_addh_sc_tile_2/a_n1205_n937# 0
C456 5v0_addh_sc_tile_1/nti res_01 0.54752f
C457 VDD_3V3_1 5v0_addh_sc_tile_0/5v0_half_adder_selector_sc_0/5v0_tgate_sel_2_sc_1/input_A 0.02871f
C458 5v0_add_q_sc_1/nti VDD_1V65_1 0.21326f
C459 5v0_addh_sc_tile_0/a_n1373_n454# in_1 0.00163f
C460 5v0_add_q_sc_1/5v0_half_adder_selector_sc_0/m1_n244_n517# c_2_o 0.34508f
C461 5v0_addh_sc_tile_2/downstepper_test 5v0_addh_sc_tile_2/inv_nti 0.29987f
C462 VDD_3V3_0 5v0_addh_sc_tile_2/m1_103_293# 0.75958f
C463 5v0_addh_sc_tile_1/nti res_0 0
C464 in_2 5v0_addh_sc_tile_0/downstepper_test 0.0129f
C465 5v0_addh_sc_tile_2/ctrl_over in_3 0.1551f
C466 5v0_add_q_sc_1/pti VDD_3V3_1 0.56896f
C467 in_2 5v0_nter2oter_code_sc_0/pti 0.00216f
C468 5v0_addh_sc_tile_1/nti 5v0_addh_sc_tile_2/ctrl_sign 0.01236f
C469 5v0_addh_sc_tile_0/carry_0_probe 5v0_addh_sc_tile_1/inv_nti 0
C470 5v0_addh_sc_tile_2/ctrl_over 5v0_addh_sc_tile_1/5v0_half_adder_selector_sc_0/res_stage0 0.00478f
C471 5v0_addh_sc_tile_2/a_382_n1095# 5v0_addh_sc_tile_2/m1_103_293# 0.07764f
C472 5v0_addh_sc_tile_0/nti VDD_1V65_0 0.21326f
C473 5v0_addh_sc_tile_2/pti 5v0_addh_sc_tile_2/a_n1373_n454# 0
C474 5v0_add_q_sc_0/upstepper_test 5v0_addh_sc_tile_2/inv_pti 0
C475 5v0_addh_sc_tile_0/inv_pti 5v0_addh_sc_tile_0/a_n1373_n454# 0.00135f
C476 VDD_1V65_0 5v0_addh_sc_tile_0/downstepper_test 0.13024f
C477 5v0_addh_sc_tile_1/upstepper_test VDD_1V65_3 0.16859f
C478 VDD_3V3_0 VDD_3V3_1 0.00215f
C479 5v0_addh_sc_tile_0/a_n1778_n454# in_1 0.00182f
C480 5v0_nter2oter_code_sc_0/gf180mcu_fd_sc_mcu7t5v0__nor2_1_0/a_224_472# 5v0_addh_sc_tile_2/ctrl_over 0.0326f
C481 5v0_addh_sc_tile_1/downstepper_test int_012 0.03365f
C482 5v0_add_q_sc_1/inv_nti 5v0_addh_sc_tile_0/a_382_n1095# 0
C483 5v0_addh_sc_tile_1/inv_nti c_2_o 0.03482f
C484 5v0_addh_sc_tile_0/a_n1205_n937# 5v0_addh_sc_tile_0/upstepper_test 0.00334f
C485 in_0_sign 5v0_addh_sc_tile_0/m1_843_n857# 0.24363f
C486 5v0_addh_sc_tile_1/nti 5v0_addh_sc_tile_1/inv_nti 0.22702f
C487 5v0_add_q_sc_0/inv_pti 5v0_addh_sc_tile_1/pti 0
C488 5v0_addh_sc_tile_2/5v0_half_adder_selector_sc_0/res_stage0 5v0_addh_sc_tile_2/pti 0.00979f
C489 5v0_addh_sc_tile_1/upstepper_test 5v0_addh_sc_tile_1/5v0_half_adder_selector_sc_0/res_stage0 0.27475f
C490 5v0_add_q_sc_0/inv_pti 5v0_addh_sc_tile_1/ctrl_sign 0
C491 5v0_addh_sc_tile_1/ctrl_over 5v0_addh_sc_tile_2/inv_pti 0.00359f
C492 5v0_addh_sc_tile_2/pti 5v0_addh_sc_tile_2/a_n1778_n454# 0.00135f
C493 int_carry VDD_3V3_1 0.20806f
C494 5v0_add_q_sc_1/nti in_0_over 0.00117f
C495 5v0_add_q_sc_1/inv_nti 5v0_add_q_sc_1/pti 0.10916f
C496 5v0_addh_sc_tile_0/pti 5v0_add_q_sc_1/nti 0.00264f
C497 in_0_sign VDD_3V3_1 0.65887f
C498 int_012 5v0_addh_sc_tile_1/pti 0
C499 5v0_addh_sc_tile_0/a_382_n1095# 5v0_addh_sc_tile_0/5v0_half_adder_selector_sc_0/5v0_tgate_sel_2_sc_1/input_A 0.02928f
C500 5v0_addh_sc_tile_1/inv_pti 5v0_addh_sc_tile_2/inv_pti 0
C501 5v0_nter2oter_code_sc_1/nti 5v0_addh_sc_tile_2/inv_pti 0
C502 VDD_1V65_1 VDD_3V3_1 0.0427f
C503 5v0_addh_sc_tile_2/ctrl_sign 5v0_addh_sc_tile_2/m1_843_n857# 0.24363f
C504 int_012 5v0_addh_sc_tile_1/ctrl_sign 0.01034f
C505 5v0_add_q_sc_1/pti 5v0_addh_sc_tile_0/a_382_n1095# 0
C506 5v0_addh_sc_tile_1/upstepper_test 5v0_addh_sc_tile_1/a_n1205_n937# 0.00334f
C507 5v0_add_q_sc_0/5v0_half_adder_selector_sc_0/res_stage0 5v0_addh_sc_tile_2/pti 0
C508 VDD_3V3_0 5v0_addh_sc_tile_2/upstepper_test 0.46517f
C509 5v0_nter2oter_code_sc_1/pti VDD_3V3_1 0.29062f
C510 5v0_addh_sc_tile_2/ctrl_over 5v0_nter2oter_code_sc_0/pti 0.00125f
C511 5v0_addh_sc_tile_1/downstepper_test 5v0_addh_sc_tile_2/inv_nti 0.00392f
C512 5v0_add_q_sc_1/a_n1778_n454# 5v0_add_q_sc_1/nti 0
C513 VDD_1V65_4 5v0_addh_sc_tile_2/a_n1205_n937# 0.00354f
C514 in_2 5v0_addh_sc_tile_2/inv_pti 0
C515 5v0_addh_sc_tile_1/5v0_half_adder_selector_sc_0/5v0_tgate_sel_2_sc_1/input_A 5v0_addh_sc_tile_1/5v0_half_adder_selector_sc_0/res_stage0 0.00253f
C516 int_012 res_01 0.17192f
C517 5v0_addh_sc_tile_0/inv_pti in_1 0.05631f
C518 5v0_addh_sc_tile_1/ctrl_over 5v0_add_q_sc_1/nti 0
C519 VDD_3V3_0 5v0_addh_sc_tile_0/a_382_n1095# 0
C520 5v0_addh_sc_tile_0/5v0_half_adder_selector_sc_0/res_stage0 c01 0
C521 5v0_addh_sc_tile_1/5v0_half_adder_selector_sc_0/res_stage0 5v0_addh_sc_tile_1/m1_103_293# 0.18549f
C522 5v0_addh_sc_tile_1/upstepper_test 5v0_addh_sc_tile_1/a_n1373_n454# 0
C523 5v0_add_q_sc_0/downstepper_test 5v0_addh_sc_tile_2/pti 0
C524 int_012 5v0_addh_sc_tile_2/ctrl_sign 0.30294f
C525 5v0_addh_sc_tile_0/m1_843_n857# in_0_over 0.09998f
C526 5v0_addh_sc_tile_1/inv_pti 5v0_add_q_sc_1/nti 0.00413f
C527 5v0_add_q_sc_1/nti 5v0_add_q_sc_1/downstepper_test 0.06596f
C528 5v0_addh_sc_tile_0/m1_843_n857# 5v0_addh_sc_tile_0/pti 0.11666f
C529 5v0_addh_sc_tile_0/m1_843_n857# 5v0_addh_sc_tile_0/inv_nti 0.36668f
C530 5v0_addh_sc_tile_1/ctrl_sign 5v0_addh_sc_tile_2/inv_nti 0
C531 VDD_1V65_4 5v0_addh_sc_tile_2/a_n1373_n454# 0.00232f
C532 5v0_add_q_sc_0/inv_pti 5v0_addh_sc_tile_1/inv_nti 0
C533 VDD_3V3_0 5v0_add_q_sc_0/inv_nti 0.56502f
C534 5v0_addh_sc_tile_2/downstepper_test 5v0_addh_sc_tile_2/a_n1205_n937# 0.00453f
C535 5v0_add_q_sc_0/ctrl_over 5v0_addh_sc_tile_2/m1_103_293# 0.01398f
C536 5v0_add_q_sc_1/inv_nti VDD_1V65_1 0.01114f
C537 5v0_addh_sc_tile_0/carry_0_probe 5v0_addh_sc_tile_1/5v0_half_adder_selector_sc_0/res_stage0 0.00121f
C538 5v0_add_q_sc_1/5v0_half_adder_selector_sc_0/res_stage0 5v0_add_q_sc_1/nti 0.00372f
C539 in_0_sign 5v0_addh_sc_tile_0/a_382_n1095# 0.07412f
C540 in_0_over VDD_3V3_1 0.64118f
C541 5v0_addh_sc_tile_0/downstepper_test c01 0
C542 VDD_1V65_4 5v0_addh_sc_tile_2/pti 0.00234f
C543 5v0_addh_sc_tile_0/pti VDD_3V3_1 0.68621f
C544 5v0_addh_sc_tile_0/inv_nti VDD_3V3_1 0.85215f
C545 5v0_addh_sc_tile_1/upstepper_test 5v0_addh_sc_tile_1/a_n1778_n454# 0
C546 5v0_addh_sc_tile_1/nti VDD_1V65_3 0.21326f
C547 in_0_sign 5v0_addh_sc_tile_0/5v0_half_adder_selector_sc_0/5v0_tgate_sel_2_sc_1/input_A 0
C548 5v0_add_q_sc_0/upstepper_test VDD_3V3_1 0
C549 5v0_add_q_sc_0/ctrl_sign 5v0_addh_sc_tile_2/pti 0.011f
C550 int_012 5v0_addh_sc_tile_1/inv_nti 0.01488f
C551 5v0_addh_sc_tile_1/ctrl_over 5v0_addh_sc_tile_2/m1_103_293# 0
C552 5v0_add_q_sc_0/inv_nti int_carry 0.02537f
C553 5v0_add_q_sc_0/downstepper_test 5v0_add_q_sc_0/5v0_half_adder_selector_sc_0/res_stage0 0.25483f
C554 5v0_addh_sc_tile_1/a_382_n1095# 5v0_add_q_sc_0/5v0_half_adder_selector_sc_0/res_stage0 0.00175f
C555 int_012 5v0_addh_sc_tile_2/nti 0.00515f
C556 VDD_1V65_4 5v0_addh_sc_tile_2/a_n1778_n454# 0
C557 res_0 5v0_addh_sc_tile_2/inv_nti 0.01449f
C558 VDD_3V3_0 5v0_nter2oter_code_sc_1/gf180mcu_fd_sc_mcu7t5v0__nor2_1_0/a_224_472# 0.01644f
C559 c_2_o 5v0_addh_sc_tile_1/5v0_half_adder_selector_sc_0/res_stage0 0
C560 5v0_addh_sc_tile_1/inv_pti 5v0_addh_sc_tile_2/m1_103_293# 0
C561 VDD_1V65_1 5v0_add_q_sc_1/pti 0.00115f
C562 5v0_addh_sc_tile_2/downstepper_test 5v0_addh_sc_tile_2/a_n1373_n454# 0.00442f
C563 5v0_addh_sc_tile_2/ctrl_sign 5v0_addh_sc_tile_2/inv_nti 0.24905f
C564 5v0_addh_sc_tile_1/nti 5v0_addh_sc_tile_1/5v0_half_adder_selector_sc_0/res_stage0 0.00372f
C565 VDD_3V3_0 5v0_addh_sc_tile_2/a_382_n1095# 0.66129f
C566 5v0_addh_sc_tile_2/ctrl_over 5v0_addh_sc_tile_2/inv_pti 0.0554f
C567 5v0_addh_sc_tile_0/m1_843_n857# 5v0_addh_sc_tile_1/inv_pti 0.00739f
C568 5v0_addh_sc_tile_0/5v0_half_adder_selector_sc_0/res_stage0 5v0_addh_sc_tile_0/m1_103_293# 0.18549f
C569 VDD_3V3_0 int_carry 1.5908f
C570 5v0_addh_sc_tile_1/ctrl_over VDD_3V3_1 0.02424f
C571 VDD_3V3_0 in_0_sign 0
C572 5v0_addh_sc_tile_2/downstepper_test 5v0_addh_sc_tile_2/pti 0.20149f
C573 5v0_addh_sc_tile_0/carry_0_probe 5v0_addh_sc_tile_0/nti 0
C574 5v0_addh_sc_tile_2/a_382_n1095# int_carry 0.0013f
C575 m1_n2844_n810# 5v0_addh_sc_tile_0/downstepper_test 0
C576 5v0_add_q_sc_0/ctrl_sign 5v0_add_q_sc_0/5v0_half_adder_selector_sc_0/res_stage0 0.22359f
C577 5v0_addh_sc_tile_2/5v0_half_adder_selector_sc_0/res_stage0 5v0_addh_sc_tile_2/downstepper_test 0.24494f
C578 5v0_addh_sc_tile_1/nti 5v0_addh_sc_tile_1/a_n1205_n937# 0
C579 5v0_addh_sc_tile_1/a_382_n1095# 5v0_add_q_sc_0/downstepper_test 0.00203f
C580 5v0_add_q_sc_1/inv_nti in_0_over 0.00113f
C581 c_2_s VDD_1V65_2 0.00149f
C582 5v0_addh_sc_tile_1/inv_pti VDD_3V3_1 0.81122f
C583 5v0_nter2oter_code_sc_1/nti VDD_3V3_1 0.0701f
C584 5v0_add_q_sc_1/downstepper_test VDD_3V3_1 0.52531f
C585 5v0_addh_sc_tile_1/inv_nti 5v0_addh_sc_tile_2/inv_nti 0
C586 5v0_addh_sc_tile_0/inv_nti 5v0_add_q_sc_1/inv_nti 0
C587 5v0_addh_sc_tile_0/pti 5v0_add_q_sc_1/inv_nti 0.00104f
C588 5v0_addh_sc_tile_2/downstepper_test 5v0_addh_sc_tile_2/a_n1778_n454# 0.0031f
C589 5v0_addh_sc_tile_0/upstepper_test 5v0_addh_sc_tile_0/5v0_half_adder_selector_sc_0/res_stage0 0.27475f
C590 VDD_3V3_0 5v0_nter2oter_code_sc_1/pti 0.19634f
C591 5v0_add_q_sc_0/inv_nti VDD_1V65_5 0.01114f
C592 5v0_addh_sc_tile_2/nti 5v0_addh_sc_tile_2/inv_nti 0.22786f
C593 in_0_over 5v0_addh_sc_tile_0/a_382_n1095# 0.63576f
C594 5v0_addh_sc_tile_0/downstepper_test 5v0_addh_sc_tile_0/m1_103_293# 0.10533f
C595 5v0_add_q_sc_1/5v0_half_adder_selector_sc_0/res_stage0 VDD_3V3_1 0.14945f
C596 5v0_addh_sc_tile_1/a_382_n1095# 5v0_addh_sc_tile_1/m1_843_n857# 0.05013f
C597 VDD_3V3_0 res_c 0.09697f
C598 5v0_addh_sc_tile_0/pti 5v0_addh_sc_tile_0/a_382_n1095# 0.12627f
C599 5v0_addh_sc_tile_0/inv_nti 5v0_addh_sc_tile_0/a_382_n1095# 0.28672f
C600 5v0_add_q_sc_1/5v0_half_adder_selector_sc_0/m1_n239_179# VDD_3V3_1 0.29031f
C601 5v0_add_q_sc_0/5v0_half_adder_selector_sc_0/m1_n239_179# 5v0_addh_sc_tile_2/inv_pti 0.00128f
C602 in_0_over 5v0_addh_sc_tile_0/5v0_half_adder_selector_sc_0/5v0_tgate_sel_2_sc_1/input_A 0.04656f
C603 in_3 5v0_addh_sc_tile_2/m1_843_n857# 0
C604 5v0_addh_sc_tile_0/upstepper_test 5v0_addh_sc_tile_0/nti 0.11981f
C605 5v0_add_q_sc_1/a_n1778_n454# 5v0_add_q_sc_1/inv_nti 0.00214f
C606 in_2 VDD_3V3_1 0.90866f
C607 5v0_add_q_sc_0/ctrl_sign 5v0_add_q_sc_0/downstepper_test 0.14564f
C608 5v0_addh_sc_tile_1/a_382_n1095# 5v0_add_q_sc_0/ctrl_sign 0.0169f
C609 5v0_addh_sc_tile_1/nti 5v0_addh_sc_tile_1/a_n1373_n454# 0
C610 5v0_addh_sc_tile_1/ctrl_over 5v0_addh_sc_tile_2/upstepper_test 0
C611 VDD_3V3_0 VDD_1V65_5 0.04709f
C612 5v0_addh_sc_tile_0/upstepper_test 5v0_addh_sc_tile_0/downstepper_test 0.38867f
C613 5v0_add_q_sc_1/upstepper_test 5v0_add_q_sc_1/a_n1205_n937# 0.00334f
C614 res_c int_carry 0.167f
C615 5v0_add_q_sc_0/upstepper_test 5v0_add_q_sc_0/inv_nti 0.0011f
C616 5v0_nter2oter_code_sc_1/nti 5v0_addh_sc_tile_2/upstepper_test 0
C617 VDD_1V65_0 VDD_3V3_1 0.04264f
C618 5v0_addh_sc_tile_1/inv_pti 5v0_add_q_sc_1/inv_nti 0.00455f
C619 5v0_add_q_sc_1/inv_nti 5v0_add_q_sc_1/downstepper_test 0.17947f
C620 5v0_addh_sc_tile_1/ctrl_over 5v0_addh_sc_tile_0/a_382_n1095# 0
C621 VDD_1V65_5 int_carry 0.03394f
C622 5v0_add_q_sc_1/a_n1778_n454# 5v0_add_q_sc_1/pti 0.00135f
C623 VDD_3V3_0 in_0_over 0
C624 5v0_addh_sc_tile_1/nti 5v0_addh_sc_tile_1/a_n1778_n454# 0.00142f
C625 int_012 in_3 0.01005f
C626 5v0_addh_sc_tile_1/inv_pti 5v0_addh_sc_tile_0/a_382_n1095# 0
C627 5v0_addh_sc_tile_2/ctrl_over 5v0_addh_sc_tile_2/m1_103_293# 0.05856f
C628 VDD_3V3_0 5v0_add_q_sc_0/upstepper_test 0.55779f
C629 int_012 5v0_addh_sc_tile_1/5v0_half_adder_selector_sc_0/res_stage0 0.1871f
C630 5v0_add_q_sc_1/nti int_c01 0.68929f
C631 5v0_addh_sc_tile_1/ctrl_over 5v0_add_q_sc_0/inv_nti 0
C632 5v0_add_q_sc_1/nti c01 0
C633 5v0_add_q_sc_1/upstepper_test c_2_s 0.13566f
C634 VDD_3V3_0 5v0_add_q_sc_0/ctrl_over 0.91135f
C635 5v0_add_q_sc_0/upstepper_test 5v0_addh_sc_tile_2/a_382_n1095# 0
C636 5v0_addh_sc_tile_1/inv_pti 5v0_add_q_sc_1/pti 0
C637 5v0_add_q_sc_1/pti 5v0_add_q_sc_1/downstepper_test 0.08084f
C638 5v0_addh_sc_tile_2/downstepper_test VDD_1V65_4 0.13024f
C639 in_0_sign in_0_over 0.05861f
C640 5v0_add_q_sc_0/upstepper_test int_carry 0.02583f
C641 5v0_add_q_sc_0/ctrl_sign 5v0_addh_sc_tile_2/downstepper_test 0
C642 in_0_sign 5v0_addh_sc_tile_0/pti 0.27027f
C643 in_0_sign 5v0_addh_sc_tile_0/inv_nti 0.24892f
C644 5v0_addh_sc_tile_2/a_382_n1095# 5v0_add_q_sc_0/ctrl_over 0.06871f
C645 5v0_addh_sc_tile_1/pti 5v0_addh_sc_tile_2/pti 0
C646 5v0_addh_sc_tile_2/ctrl_over VDD_3V3_1 0.00186f
C647 5v0_addh_sc_tile_1/ctrl_over VDD_3V3_0 1.20698f
C648 5v0_addh_sc_tile_1/ctrl_sign 5v0_addh_sc_tile_2/pti 0.00148f
C649 5v0_add_q_sc_1/upstepper_test 5v0_add_q_sc_1/inv_pti 0.0467f
C650 5v0_add_q_sc_0/ctrl_over int_carry 0.15164f
C651 5v0_addh_sc_tile_1/ctrl_over 5v0_nter2oter_code_sc_1/gf180mcu_fd_sc_mcu7t5v0__nor2_1_0/a_224_472# 0.02885f
C652 5v0_nter2oter_code_sc_1/pti 5v0_addh_sc_tile_0/pti 0
C653 in_3 5v0_addh_sc_tile_2/inv_nti 0.28245f
C654 5v0_nter2oter_code_sc_1/pti 5v0_addh_sc_tile_0/inv_nti 0.00491f
C655 5v0_addh_sc_tile_1/ctrl_over 5v0_addh_sc_tile_2/a_382_n1095# 0
C656 5v0_addh_sc_tile_1/upstepper_test 5v0_addh_sc_tile_0/m1_843_n857# 0.00724f
C657 VDD_3V3_0 5v0_addh_sc_tile_1/inv_pti 0.1766f
C658 5v0_add_q_sc_1/upstepper_test 5v0_add_q_sc_1/5v0_half_adder_selector_sc_0/5v0_tgate_sel_2_sc_1/input_A 0
C659 5v0_add_q_sc_1/nti 5v0_addh_sc_tile_1/m1_103_293# 0.00685f
C660 VDD_3V3_0 5v0_nter2oter_code_sc_1/nti 0.31259f
C661 5v0_nter2oter_code_sc_1/nti 5v0_nter2oter_code_sc_1/gf180mcu_fd_sc_mcu7t5v0__nor2_1_0/a_224_472# 0.00898f
C662 5v0_addh_sc_tile_0/inv_pti c_2_s 0
C663 5v0_addh_sc_tile_1/nti 5v0_addh_sc_tile_2/inv_pti 0
C664 5v0_add_q_sc_1/a_n1778_n454# VDD_1V65_1 0
C665 5v0_addh_sc_tile_1/ctrl_over int_carry 0.01695f
C666 5v0_addh_sc_tile_1/ctrl_sign in_1 0.01394f
C667 5v0_addh_sc_tile_0/nti int_012 0.0033f
C668 5v0_addh_sc_tile_1/inv_pti 5v0_addh_sc_tile_2/a_382_n1095# 0
C669 5v0_add_q_sc_1/nti m1_n2844_n810# 0.00573f
C670 5v0_addh_sc_tile_2/5v0_half_adder_selector_sc_0/res_stage0 5v0_addh_sc_tile_2/5v0_half_adder_selector_sc_0/5v0_tgate_sel_2_sc_1/input_A 0.00253f
C671 5v0_addh_sc_tile_0/m1_843_n857# c01 0.00703f
C672 5v0_addh_sc_tile_2/nti 5v0_addh_sc_tile_2/a_n1205_n937# 0
C673 5v0_addh_sc_tile_1/upstepper_test VDD_3V3_1 0.39457f
C674 5v0_addh_sc_tile_1/inv_pti int_carry 0.00157f
C675 5v0_add_q_sc_1/downstepper_test int_carry 0.00477f
C676 5v0_add_q_sc_0/ctrl_over res_c 0.20136f
C677 5v0_addh_sc_tile_2/5v0_half_adder_selector_sc_0/res_stage0 res_01 0
C678 5v0_addh_sc_tile_0/carry_0_probe 5v0_add_q_sc_1/nti 0.11161f
C679 res_0 5v0_addh_sc_tile_2/pti 0
C680 int_012 5v0_nter2oter_code_sc_0/pti 0.58802f
C681 in_2 VDD_3V3_0 0.0135f
C682 5v0_add_q_sc_0/upstepper_test VDD_1V65_5 0.16859f
C683 in_0_sign 5v0_addh_sc_tile_1/inv_pti 0.00171f
C684 5v0_addh_sc_tile_2/upstepper_test 5v0_addh_sc_tile_2/ctrl_over 0.16997f
C685 5v0_addh_sc_tile_1/downstepper_test 5v0_addh_sc_tile_1/a_382_n1095# 0.00679f
C686 int_c01 VDD_3V3_1 1.23209f
C687 5v0_addh_sc_tile_2/ctrl_sign 5v0_addh_sc_tile_2/pti 0.28211f
C688 5v0_addh_sc_tile_2/5v0_half_adder_selector_sc_0/res_stage0 res_0 0.08533f
C689 5v0_addh_sc_tile_1/ctrl_over 5v0_nter2oter_code_sc_1/pti 0.00583f
C690 res_01 in_1 0.18462f
C691 5v0_add_q_sc_1/5v0_half_adder_selector_sc_0/res_stage0 int_carry 0.17113f
C692 5v0_addh_sc_tile_2/5v0_half_adder_selector_sc_0/res_stage0 5v0_addh_sc_tile_2/ctrl_sign 0.25152f
C693 VDD_1V65_1 5v0_add_q_sc_1/downstepper_test 0.13024f
C694 VDD_1V65_5 5v0_add_q_sc_0/ctrl_over 0
C695 5v0_addh_sc_tile_1/a_382_n1095# c_2_s 0.00155f
C696 c01 VDD_3V3_1 0.17781f
C697 5v0_addh_sc_tile_1/ctrl_over res_c 0
C698 5v0_nter2oter_code_sc_1/pti 5v0_nter2oter_code_sc_1/nti 0.00234f
C699 5v0_addh_sc_tile_0/pti in_0_over 0.10966f
C700 5v0_addh_sc_tile_0/inv_nti in_0_over 0.21462f
C701 5v0_addh_sc_tile_2/nti 5v0_addh_sc_tile_2/a_n1373_n454# 0
C702 5v0_addh_sc_tile_0/inv_nti 5v0_addh_sc_tile_0/pti 0.4209f
C703 5v0_add_q_sc_1/nti c_2_o 0.00725f
C704 5v0_add_q_sc_1/upstepper_test 5v0_add_q_sc_1/a_n1373_n454# 0
C705 5v0_addh_sc_tile_1/m1_843_n857# c_2_s 0.0069f
C706 5v0_addh_sc_tile_1/ctrl_over VDD_1V65_5 0
C707 5v0_addh_sc_tile_1/downstepper_test 5v0_add_q_sc_0/ctrl_sign 0.00426f
C708 5v0_addh_sc_tile_1/a_382_n1095# 5v0_addh_sc_tile_1/pti 0.12627f
C709 5v0_addh_sc_tile_1/inv_nti 5v0_addh_sc_tile_2/pti 0
C710 5v0_addh_sc_tile_1/a_382_n1095# 5v0_add_q_sc_1/inv_pti 0
C711 5v0_addh_sc_tile_1/a_382_n1095# 5v0_addh_sc_tile_1/ctrl_sign 0.07412f
C712 5v0_addh_sc_tile_0/m1_843_n857# m1_n2844_n810# 0.00191f
C713 5v0_addh_sc_tile_2/m1_843_n857# 5v0_addh_sc_tile_2/inv_pti 0
C714 5v0_addh_sc_tile_2/nti 5v0_addh_sc_tile_2/pti 0.24563f
C715 in_2 5v0_nter2oter_code_sc_1/pti 0.46231f
C716 5v0_addh_sc_tile_1/pti 5v0_addh_sc_tile_1/m1_843_n857# 0.11666f
C717 VDD_3V3_1 5v0_addh_sc_tile_1/m1_103_293# 0.62378f
C718 5v0_addh_sc_tile_0/carry_0_probe 5v0_addh_sc_tile_0/m1_843_n857# 0.18376f
C719 5v0_add_q_sc_0/upstepper_test 5v0_add_q_sc_0/ctrl_over 0.00167f
C720 5v0_addh_sc_tile_1/m1_843_n857# 5v0_add_q_sc_1/inv_pti 0
C721 5v0_addh_sc_tile_2/5v0_half_adder_selector_sc_0/res_stage0 5v0_addh_sc_tile_2/nti 0.00372f
C722 5v0_addh_sc_tile_1/ctrl_sign 5v0_addh_sc_tile_1/m1_843_n857# 0.24363f
C723 int_c01 5v0_add_q_sc_1/inv_nti 0.02537f
C724 5v0_addh_sc_tile_0/m1_843_n857# 5v0_addh_sc_tile_0/m1_103_293# 0.20659f
C725 5v0_add_q_sc_0/downstepper_test 5v0_add_q_sc_0/a_n1778_n454# 0.0031f
C726 5v0_addh_sc_tile_1/ctrl_over in_0_over 0
C727 5v0_addh_sc_tile_2/nti 5v0_addh_sc_tile_2/a_n1778_n454# 0.00142f
C728 m1_n2844_n810# VDD_3V3_1 0.14825f
C729 5v0_addh_sc_tile_1/ctrl_sign VDD_1V65_4 0
C730 5v0_addh_sc_tile_1/upstepper_test 5v0_addh_sc_tile_0/a_382_n1095# 0.00208f
C731 5v0_addh_sc_tile_1/pti 5v0_add_q_sc_0/ctrl_sign 0
C732 5v0_addh_sc_tile_1/a_382_n1095# res_01 0.09307f
C733 5v0_addh_sc_tile_1/ctrl_over 5v0_addh_sc_tile_0/inv_nti 0
C734 5v0_add_q_sc_0/ctrl_sign 5v0_addh_sc_tile_1/ctrl_sign 0
C735 5v0_addh_sc_tile_1/ctrl_over 5v0_add_q_sc_0/upstepper_test 0.00229f
C736 in_0_over 5v0_add_q_sc_1/downstepper_test 0
C737 5v0_addh_sc_tile_1/inv_pti in_0_over 0.00926f
C738 VDD_3V3_0 5v0_addh_sc_tile_2/ctrl_over 2.0131f
C739 5v0_addh_sc_tile_0/carry_0_probe VDD_3V3_1 0.82134f
C740 5v0_addh_sc_tile_1/nti 5v0_addh_sc_tile_2/m1_103_293# 0.00116f
C741 5v0_addh_sc_tile_1/inv_pti 5v0_addh_sc_tile_0/inv_nti 0
C742 5v0_addh_sc_tile_1/inv_pti 5v0_addh_sc_tile_0/pti 0.00107f
C743 5v0_nter2oter_code_sc_1/nti 5v0_addh_sc_tile_0/inv_nti 0.00216f
C744 5v0_addh_sc_tile_1/m1_843_n857# res_01 0
C745 5v0_addh_sc_tile_0/m1_103_293# VDD_3V3_1 0.73472f
C746 5v0_addh_sc_tile_1/ctrl_over 5v0_add_q_sc_0/ctrl_over 0
C747 int_012 5v0_addh_sc_tile_2/inv_pti 0.00498f
C748 5v0_addh_sc_tile_1/nti 5v0_addh_sc_tile_0/m1_843_n857# 0
C749 c01 5v0_addh_sc_tile_0/a_382_n1095# 0.02324f
C750 5v0_addh_sc_tile_2/ctrl_over 5v0_addh_sc_tile_2/a_382_n1095# 0.69037f
C751 int_c01 5v0_add_q_sc_1/pti 0.54174f
C752 5v0_add_q_sc_0/ctrl_sign res_01 0.00787f
C753 5v0_addh_sc_tile_2/ctrl_over int_carry 0.00714f
C754 res_0 VDD_1V65_4 0
C755 5v0_add_q_sc_1/a_n1778_n454# 5v0_add_q_sc_1/downstepper_test 0.0031f
C756 5v0_add_q_sc_1/pti c01 0
C757 c_2_o VDD_3V3_1 0.6465f
C758 5v0_addh_sc_tile_2/ctrl_sign VDD_1V65_4 0
C759 5v0_nter2oter_code_sc_0/nti 5v0_addh_sc_tile_1/ctrl_sign 0
C760 in_2 5v0_addh_sc_tile_0/pti 0
C761 5v0_add_q_sc_1/inv_nti 5v0_addh_sc_tile_1/m1_103_293# 0.00334f
C762 in_2 5v0_addh_sc_tile_0/inv_nti 0.0153f
C763 5v0_addh_sc_tile_1/nti VDD_3V3_1 0.14047f
C764 5v0_addh_sc_tile_0/upstepper_test VDD_3V3_1 0.45677f
C765 5v0_add_q_sc_0/downstepper_test 5v0_addh_sc_tile_1/inv_nti 0
C766 5v0_add_q_sc_0/ctrl_sign 5v0_addh_sc_tile_2/ctrl_sign 0.27145f
C767 5v0_addh_sc_tile_1/upstepper_test VDD_3V3_0 0.13286f
C768 5v0_addh_sc_tile_1/a_382_n1095# 5v0_addh_sc_tile_1/inv_nti 0.28394f
C769 5v0_add_q_sc_1/inv_nti m1_n2844_n810# 0.00427f
C770 5v0_addh_sc_tile_1/ctrl_over 5v0_addh_sc_tile_1/inv_pti 0.0052f
C771 5v0_addh_sc_tile_1/ctrl_over 5v0_nter2oter_code_sc_1/nti 0.2759f
C772 5v0_addh_sc_tile_2/downstepper_test 5v0_addh_sc_tile_2/5v0_half_adder_selector_sc_0/5v0_tgate_sel_2_sc_1/input_A 0
C773 5v0_add_q_sc_0/nti 5v0_add_q_sc_0/inv_nti 0.20874f
C774 5v0_nter2oter_code_sc_1/pti 5v0_addh_sc_tile_2/ctrl_over 0
C775 VDD_3V3_0 5v0_add_q_sc_0/5v0_half_adder_selector_sc_0/m1_n239_179# 0.30519f
C776 VDD_1V65_0 in_0_over 0.00145f
C777 5v0_addh_sc_tile_0/carry_0_probe 5v0_add_q_sc_1/inv_nti 0.00204f
C778 VDD_1V65_0 5v0_addh_sc_tile_0/pti 0.00234f
C779 in_3 5v0_addh_sc_tile_2/a_n1373_n454# 0.00163f
C780 5v0_addh_sc_tile_1/m1_843_n857# 5v0_addh_sc_tile_1/inv_nti 0.36668f
C781 5v0_addh_sc_tile_0/inv_nti VDD_1V65_0 0.08611f
C782 5v0_addh_sc_tile_2/ctrl_over res_c 0.00127f
C783 5v0_addh_sc_tile_1/inv_pti 5v0_add_q_sc_1/downstepper_test 0.00756f
C784 m1_n2844_n810# 5v0_addh_sc_tile_0/a_382_n1095# 0.04011f
C785 5v0_addh_sc_tile_2/inv_nti 5v0_addh_sc_tile_2/inv_pti 0.2615f
C786 5v0_addh_sc_tile_2/m1_843_n857# 5v0_addh_sc_tile_2/m1_103_293# 0.20659f
C787 5v0_addh_sc_tile_2/downstepper_test res_0 0.00302f
C788 5v0_addh_sc_tile_2/downstepper_test 5v0_addh_sc_tile_2/ctrl_sign 0.20835f
C789 5v0_addh_sc_tile_0/carry_0_probe 5v0_addh_sc_tile_0/a_382_n1095# 0.08241f
C790 int_c01 int_carry 0.17661f
C791 5v0_add_q_sc_0/ctrl_sign 5v0_addh_sc_tile_1/inv_nti 0
C792 5v0_addh_sc_tile_1/ctrl_over in_2 0.01618f
C793 5v0_nter2oter_code_sc_0/nti 5v0_addh_sc_tile_2/ctrl_sign 0.03693f
C794 5v0_add_q_sc_1/5v0_half_adder_selector_sc_0/res_stage0 5v0_add_q_sc_1/downstepper_test 0.25483f
C795 5v0_add_q_sc_0/5v0_half_adder_selector_sc_0/m1_n239_179# int_carry 0.00189f
C796 VDD_3V3_0 5v0_add_q_sc_0/nti 0.63773f
C797 5v0_addh_sc_tile_2/ctrl_over VDD_1V65_5 0
C798 5v0_addh_sc_tile_2/nti VDD_1V65_4 0.21326f
C799 in_3 5v0_addh_sc_tile_2/pti 0.66373f
C800 in_0_sign int_c01 0
C801 5v0_addh_sc_tile_1/nti 5v0_addh_sc_tile_2/upstepper_test 0.00102f
C802 5v0_addh_sc_tile_0/a_n1373_n454# 5v0_addh_sc_tile_0/nti 0
C803 5v0_addh_sc_tile_0/m1_103_293# 5v0_addh_sc_tile_0/a_382_n1095# 0.07764f
C804 5v0_add_q_sc_1/5v0_half_adder_selector_sc_0/m1_n239_179# 5v0_add_q_sc_1/downstepper_test 0.09961f
C805 5v0_addh_sc_tile_0/carry_0_probe 5v0_addh_sc_tile_0/5v0_half_adder_selector_sc_0/5v0_tgate_sel_2_sc_1/input_A 0
C806 5v0_addh_sc_tile_2/5v0_half_adder_selector_sc_0/res_stage0 in_3 0.26626f
C807 5v0_addh_sc_tile_1/5v0_half_adder_selector_sc_0/5v0_tgate_sel_2_sc_1/input_A VDD_3V3_0 0.02871f
C808 int_c01 VDD_1V65_1 0.03394f
C809 5v0_add_q_sc_0/nti 5v0_addh_sc_tile_2/a_382_n1095# 0
C810 in_2 5v0_addh_sc_tile_1/inv_pti 0
C811 c_2_o 5v0_add_q_sc_1/inv_nti 0.00311f
C812 in_2 5v0_nter2oter_code_sc_1/nti 0.19929f
C813 5v0_addh_sc_tile_0/carry_0_probe 5v0_add_q_sc_1/pti 0
C814 5v0_addh_sc_tile_1/downstepper_test c_2_s 0
C815 in_0_sign c01 0.24834f
C816 in_3 5v0_addh_sc_tile_2/a_n1778_n454# 0.00182f
C817 5v0_addh_sc_tile_0/a_n1373_n454# 5v0_addh_sc_tile_0/downstepper_test 0.00442f
C818 5v0_addh_sc_tile_1/ctrl_over VDD_1V65_0 0
C819 5v0_add_q_sc_1/5v0_half_adder_selector_sc_0/res_stage0 5v0_add_q_sc_1/5v0_half_adder_selector_sc_0/m1_n239_179# 0.18379f
C820 VDD_3V3_0 5v0_addh_sc_tile_1/m1_103_293# 0.14668f
C821 5v0_add_q_sc_0/nti int_carry 0.62238f
C822 5v0_addh_sc_tile_1/nti 5v0_addh_sc_tile_0/a_382_n1095# 0.01157f
C823 int_012 5v0_addh_sc_tile_2/m1_103_293# 0.00332f
C824 5v0_nter2oter_code_sc_1/nti VDD_1V65_0 0
C825 5v0_addh_sc_tile_1/downstepper_test 5v0_addh_sc_tile_1/pti 0.19626f
C826 5v0_add_q_sc_0/pti 5v0_add_q_sc_0/inv_nti 0.11055f
C827 5v0_addh_sc_tile_0/a_n1778_n454# 5v0_addh_sc_tile_0/nti 0.00142f
C828 5v0_addh_sc_tile_2/ctrl_over 5v0_add_q_sc_0/upstepper_test 0.00252f
C829 5v0_nter2oter_code_sc_0/nti 5v0_addh_sc_tile_2/nti 0.00237f
C830 5v0_addh_sc_tile_2/downstepper_test 5v0_addh_sc_tile_2/nti 0.06935f
C831 5v0_addh_sc_tile_1/downstepper_test 5v0_addh_sc_tile_1/ctrl_sign 0.20144f
C832 5v0_addh_sc_tile_0/upstepper_test 5v0_addh_sc_tile_0/5v0_half_adder_selector_sc_0/5v0_tgate_sel_2_sc_1/input_A 0
C833 5v0_addh_sc_tile_0/carry_0_probe VDD_3V3_0 0
C834 int_carry 5v0_addh_sc_tile_1/m1_103_293# 0
C835 c_2_o 5v0_add_q_sc_1/pti 0
C836 5v0_addh_sc_tile_1/pti c_2_s 0.01108f
C837 c_2_o 5v0_add_q_sc_0/inv_nti 0
C838 5v0_addh_sc_tile_0/a_n1778_n454# 5v0_addh_sc_tile_0/downstepper_test 0.0031f
C839 5v0_add_q_sc_1/inv_pti c_2_s 0.05919f
C840 5v0_addh_sc_tile_2/ctrl_over 5v0_add_q_sc_0/ctrl_over 0.15107f
C841 5v0_addh_sc_tile_1/ctrl_sign c_2_s 0.24986f
C842 5v0_add_q_sc_0/nti res_c 0
C843 in_2 VDD_1V65_0 0
C844 5v0_addh_sc_tile_0/5v0_half_adder_selector_sc_0/res_stage0 in_1 0.2646f
C845 int_012 VDD_3V3_1 0.92139f
C846 5v0_add_q_sc_1/5v0_half_adder_selector_sc_0/5v0_tgate_sel_2_sc_1/input_A c_2_s 0
C847 in_0_sign m1_n2844_n810# 0.0018f
C848 5v0_add_q_sc_0/a_n1205_n937# 5v0_add_q_sc_0/inv_nti 0
C849 VDD_3V3_0 5v0_add_q_sc_0/pti 0.57843f
C850 5v0_addh_sc_tile_1/upstepper_test in_0_over 0.01202f
C851 5v0_addh_sc_tile_1/downstepper_test res_01 0.18203f
C852 5v0_addh_sc_tile_1/ctrl_over 5v0_addh_sc_tile_2/ctrl_over 0.02247f
C853 5v0_addh_sc_tile_1/pti 5v0_addh_sc_tile_1/ctrl_sign 0.48393f
C854 5v0_addh_sc_tile_0/carry_0_probe in_0_sign 0.01009f
C855 VDD_3V3_0 c_2_o 0.33124f
C856 5v0_add_q_sc_0/nti VDD_1V65_5 0.21326f
C857 5v0_addh_sc_tile_1/nti VDD_3V3_0 0.44319f
C858 5v0_nter2oter_code_sc_0/pti 5v0_addh_sc_tile_2/pti 0
C859 5v0_addh_sc_tile_0/pti int_c01 0.00103f
C860 5v0_addh_sc_tile_2/inv_nti 5v0_addh_sc_tile_2/m1_103_293# 0.35313f
C861 5v0_addh_sc_tile_1/downstepper_test 5v0_addh_sc_tile_2/ctrl_sign 0.00468f
C862 5v0_addh_sc_tile_0/inv_nti int_c01 0.001f
C863 in_0_sign 5v0_addh_sc_tile_0/m1_103_293# 0.60072f
C864 5v0_addh_sc_tile_0/nti in_1 0.52138f
C865 5v0_addh_sc_tile_1/a_382_n1095# 5v0_addh_sc_tile_1/5v0_half_adder_selector_sc_0/res_stage0 0.08951f
C866 5v0_addh_sc_tile_0/inv_pti 5v0_addh_sc_tile_0/5v0_half_adder_selector_sc_0/res_stage0 0.01365f
C867 5v0_add_q_sc_1/5v0_half_adder_selector_sc_0/m1_n244_n517# c_2_s 0
C868 5v0_addh_sc_tile_2/ctrl_over 5v0_addh_sc_tile_1/inv_pti 0
C869 5v0_nter2oter_code_sc_1/nti 5v0_addh_sc_tile_2/ctrl_over 0
C870 c01 in_0_over 0.00413f
C871 5v0_add_q_sc_0/5v0_half_adder_selector_sc_0/m1_n239_179# 5v0_add_q_sc_0/upstepper_test 0.07502f
C872 5v0_add_q_sc_0/pti int_carry 0.6113f
C873 5v0_addh_sc_tile_1/nti 5v0_addh_sc_tile_2/a_382_n1095# 0
C874 5v0_add_q_sc_0/a_n1205_n937# VDD_3V3_0 0.00891f
C875 5v0_addh_sc_tile_0/pti c01 0.01168f
C876 5v0_addh_sc_tile_0/inv_nti c01 0.17527f
C877 5v0_addh_sc_tile_0/downstepper_test in_1 0.18203f
C878 5v0_addh_sc_tile_1/pti res_01 0.67368f
C879 c_2_o int_carry 0.30261f
C880 5v0_nter2oter_code_sc_0/pti in_1 0
C881 5v0_add_q_sc_0/5v0_half_adder_selector_sc_0/m1_n239_179# 5v0_add_q_sc_0/ctrl_over 0.00258f
C882 in_3 VDD_1V65_4 0.01451f
C883 5v0_add_q_sc_1/a_n1778_n454# int_c01 0.00116f
C884 5v0_addh_sc_tile_1/ctrl_sign res_01 0.17378f
C885 5v0_addh_sc_tile_0/inv_pti 5v0_addh_sc_tile_0/nti 0.24025f
C886 5v0_addh_sc_tile_1/nti in_0_sign 0
C887 5v0_addh_sc_tile_0/upstepper_test in_0_sign 0.08746f
C888 5v0_addh_sc_tile_1/ctrl_over 5v0_addh_sc_tile_1/upstepper_test 0.0043f
C889 5v0_addh_sc_tile_1/pti 5v0_addh_sc_tile_2/ctrl_sign 0
C890 5v0_add_q_sc_0/nti 5v0_add_q_sc_0/upstepper_test 0.11981f
C891 in_2 5v0_addh_sc_tile_2/ctrl_over 0
C892 5v0_addh_sc_tile_1/downstepper_test 5v0_addh_sc_tile_1/inv_nti 0.29493f
C893 c_2_o VDD_1V65_1 0.04751f
C894 5v0_add_q_sc_0/a_n1205_n937# int_carry 0
C895 5v0_add_q_sc_0/ctrl_sign 5v0_addh_sc_tile_1/5v0_half_adder_selector_sc_0/res_stage0 0
C896 5v0_addh_sc_tile_1/ctrl_sign 5v0_addh_sc_tile_2/ctrl_sign 0.036f
C897 5v0_addh_sc_tile_0/inv_pti 5v0_addh_sc_tile_0/downstepper_test 0.14186f
C898 5v0_addh_sc_tile_1/ctrl_over 5v0_add_q_sc_0/5v0_half_adder_selector_sc_0/m1_n239_179# 0.00107f
C899 5v0_add_q_sc_1/5v0_half_adder_selector_sc_0/m1_n244_n517# 5v0_add_q_sc_1/5v0_half_adder_selector_sc_0/5v0_tgate_sel_2_sc_1/input_A 0.02928f
C900 5v0_addh_sc_tile_1/nti 5v0_nter2oter_code_sc_1/pti 0
C901 5v0_addh_sc_tile_1/upstepper_test 5v0_addh_sc_tile_1/inv_pti 0.06901f
C902 5v0_add_q_sc_0/nti 5v0_add_q_sc_0/ctrl_over 0.00167f
C903 5v0_addh_sc_tile_1/inv_nti c_2_s 0.05407f
C904 5v0_add_q_sc_1/nti VDD_1V65_2 0.02331f
C905 5v0_addh_sc_tile_1/inv_pti int_c01 0.00686f
C906 int_c01 5v0_add_q_sc_1/downstepper_test 0.16195f
C907 5v0_add_q_sc_0/inv_pti 5v0_add_q_sc_0/inv_nti 0.08256f
C908 5v0_add_q_sc_0/upstepper_test 5v0_addh_sc_tile_1/m1_103_293# 0.00268f
C909 5v0_addh_sc_tile_2/5v0_half_adder_selector_sc_0/5v0_tgate_sel_2_sc_1/input_A 5v0_addh_sc_tile_2/ctrl_sign 0
C910 m1_n2844_n810# in_0_over 0.00329f
C911 5v0_add_q_sc_0/pti VDD_1V65_5 0.00115f
C912 5v0_addh_sc_tile_0/pti m1_n2844_n810# 0.00645f
C913 VDD_3V3_0 5v0_addh_sc_tile_2/m1_843_n857# 0.17677f
C914 5v0_addh_sc_tile_0/inv_nti m1_n2844_n810# 0.02458f
C915 5v0_addh_sc_tile_2/downstepper_test in_3 0.18203f
C916 5v0_addh_sc_tile_2/ctrl_sign res_01 0
C917 5v0_nter2oter_code_sc_0/nti in_3 0.00248f
C918 5v0_add_q_sc_1/a_n1373_n454# 5v0_add_q_sc_1/inv_pti 0.00135f
C919 5v0_addh_sc_tile_0/carry_0_probe in_0_over 0.12282f
C920 5v0_addh_sc_tile_1/ctrl_over 5v0_add_q_sc_0/nti 0
C921 5v0_addh_sc_tile_1/pti 5v0_addh_sc_tile_1/inv_nti 0.42143f
C922 5v0_add_q_sc_1/5v0_half_adder_selector_sc_0/res_stage0 int_c01 0.27251f
C923 5v0_addh_sc_tile_2/inv_pti 5v0_addh_sc_tile_2/a_n1373_n454# 0.00135f
C924 5v0_addh_sc_tile_0/carry_0_probe 5v0_addh_sc_tile_0/pti 0.14485f
C925 5v0_addh_sc_tile_0/carry_0_probe 5v0_addh_sc_tile_0/inv_nti 0.03001f
C926 5v0_addh_sc_tile_2/m1_843_n857# 5v0_addh_sc_tile_2/a_382_n1095# 0.05013f
C927 5v0_addh_sc_tile_1/ctrl_sign 5v0_addh_sc_tile_1/inv_nti 0.25029f
C928 int_c01 5v0_add_q_sc_1/5v0_half_adder_selector_sc_0/m1_n239_179# 0.00189f
C929 5v0_addh_sc_tile_0/m1_103_293# in_0_over 0.02633f
C930 5v0_addh_sc_tile_1/ctrl_over 5v0_addh_sc_tile_1/5v0_half_adder_selector_sc_0/5v0_tgate_sel_2_sc_1/input_A 0.04656f
C931 5v0_addh_sc_tile_2/upstepper_test 5v0_addh_sc_tile_2/inv_nti 0.00736f
C932 5v0_add_q_sc_0/inv_pti VDD_3V3_0 0.40694f
C933 5v0_addh_sc_tile_0/pti 5v0_addh_sc_tile_0/m1_103_293# 0.10002f
C934 5v0_addh_sc_tile_0/inv_nti 5v0_addh_sc_tile_0/m1_103_293# 0.35313f
C935 5v0_addh_sc_tile_2/nti 5v0_addh_sc_tile_1/ctrl_sign 0
C936 5v0_addh_sc_tile_2/m1_843_n857# int_carry 0
C937 5v0_addh_sc_tile_2/pti 5v0_addh_sc_tile_2/inv_pti 0.44081f
C938 5v0_add_q_sc_0/a_n1205_n937# VDD_1V65_5 0.00354f
C939 5v0_addh_sc_tile_1/ctrl_over 5v0_addh_sc_tile_1/m1_103_293# 0.02786f
C940 5v0_add_q_sc_0/5v0_half_adder_selector_sc_0/5v0_tgate_sel_2_sc_1/input_A VDD_3V3_0 0.02871f
C941 5v0_nter2oter_code_sc_0/gf180mcu_fd_sc_mcu7t5v0__nor2_1_0/a_224_472# 5v0_nter2oter_code_sc_0/nti 0.00842f
C942 5v0_addh_sc_tile_2/5v0_half_adder_selector_sc_0/res_stage0 5v0_addh_sc_tile_2/inv_pti 0.01003f
C943 5v0_add_q_sc_0/pti 5v0_add_q_sc_0/upstepper_test 0
C944 5v0_addh_sc_tile_1/inv_nti res_01 0.28104f
C945 5v0_addh_sc_tile_1/nti in_0_over 0.00205f
C946 5v0_addh_sc_tile_0/upstepper_test in_0_over 0.00168f
C947 5v0_addh_sc_tile_1/inv_pti 5v0_addh_sc_tile_1/m1_103_293# 0.17653f
C948 VDD_3V3_0 int_012 2.39715f
C949 5v0_add_q_sc_0/inv_pti int_carry 0.08665f
C950 5v0_addh_sc_tile_1/nti 5v0_addh_sc_tile_0/pti 0
C951 5v0_addh_sc_tile_0/upstepper_test 5v0_addh_sc_tile_0/pti 0.02426f
C952 int_012 5v0_nter2oter_code_sc_1/gf180mcu_fd_sc_mcu7t5v0__nor2_1_0/a_224_472# 0
C953 5v0_addh_sc_tile_1/nti 5v0_addh_sc_tile_0/inv_nti 0
C954 5v0_addh_sc_tile_0/upstepper_test 5v0_addh_sc_tile_0/inv_nti 0.00736f
C955 c_2_o 5v0_add_q_sc_0/upstepper_test 0.01814f
C956 5v0_add_q_sc_0/pti 5v0_add_q_sc_0/ctrl_over 0
C957 5v0_addh_sc_tile_1/ctrl_over 5v0_addh_sc_tile_0/carry_0_probe 0
C958 5v0_addh_sc_tile_1/inv_nti 5v0_addh_sc_tile_2/ctrl_sign 0.00386f
C959 5v0_add_q_sc_0/5v0_half_adder_selector_sc_0/m1_n244_n517# VDD_3V3_0 0.29978f
C960 int_012 5v0_addh_sc_tile_2/a_382_n1095# 0
C961 5v0_addh_sc_tile_1/inv_pti m1_n2844_n810# 0
C962 5v0_addh_sc_tile_2/nti res_0 0
C963 5v0_add_q_sc_0/a_n1373_n454# 5v0_add_q_sc_0/inv_nti 0
C964 5v0_addh_sc_tile_2/nti 5v0_addh_sc_tile_2/ctrl_sign 0.01914f
C965 5v0_addh_sc_tile_0/carry_0_probe 5v0_addh_sc_tile_1/inv_pti 0.01474f
C966 5v0_add_q_sc_0/a_n1205_n937# 5v0_add_q_sc_0/upstepper_test 0.00334f
C967 VDD_3V3_1 VDD_1V65_2 0.01209f
C968 5v0_add_q_sc_0/5v0_half_adder_selector_sc_0/m1_n244_n517# 5v0_addh_sc_tile_2/a_382_n1095# 0
C969 5v0_addh_sc_tile_0/nti 5v0_nter2oter_code_sc_0/nti 0.00244f
C970 5v0_addh_sc_tile_1/ctrl_over 5v0_add_q_sc_0/pti 0.00209f
C971 5v0_addh_sc_tile_1/inv_pti 5v0_addh_sc_tile_0/m1_103_293# 0.00205f
C972 5v0_addh_sc_tile_1/downstepper_test VDD_1V65_3 0.13024f
C973 5v0_add_q_sc_1/upstepper_test 5v0_add_q_sc_1/nti 0.11962f
C974 5v0_add_q_sc_0/5v0_half_adder_selector_sc_0/m1_n244_n517# int_carry 0.07888f
C975 5v0_addh_sc_tile_1/ctrl_over c_2_o 0.12383f
C976 5v0_nter2oter_code_sc_0/nti 5v0_nter2oter_code_sc_0/pti 0.00234f
C977 5v0_addh_sc_tile_1/nti 5v0_addh_sc_tile_1/ctrl_over 0.0773f
C978 5v0_addh_sc_tile_1/ctrl_over 5v0_addh_sc_tile_0/upstepper_test 0
C979 5v0_addh_sc_tile_1/upstepper_test 5v0_addh_sc_tile_2/ctrl_over 0
C980 5v0_add_q_sc_0/a_n1373_n454# VDD_3V3_0 0.00122f
C981 5v0_nter2oter_code_sc_1/pti int_012 0.00485f
C982 VDD_3V3_0 5v0_addh_sc_tile_2/inv_nti 0.88474f
C983 5v0_addh_sc_tile_1/downstepper_test 5v0_addh_sc_tile_1/5v0_half_adder_selector_sc_0/res_stage0 0.25483f
C984 5v0_addh_sc_tile_0/a_n1373_n454# VDD_3V3_1 0.00122f
C985 5v0_add_q_sc_0/inv_pti VDD_1V65_5 0.14775f
C986 5v0_addh_sc_tile_1/inv_pti c_2_o 0.01474f
C987 c_2_o 5v0_add_q_sc_1/downstepper_test 0.12191f
C988 5v0_addh_sc_tile_2/ctrl_over 5v0_add_q_sc_0/5v0_half_adder_selector_sc_0/m1_n239_179# 0.00716f
C989 5v0_addh_sc_tile_0/upstepper_test 5v0_nter2oter_code_sc_1/nti 0
C990 5v0_addh_sc_tile_1/nti 5v0_nter2oter_code_sc_1/nti 0.20212f
C991 5v0_addh_sc_tile_1/nti 5v0_addh_sc_tile_1/inv_pti 0.23171f
C992 5v0_addh_sc_tile_2/inv_nti 5v0_addh_sc_tile_2/a_382_n1095# 0.28654f
C993 c_2_s 5v0_addh_sc_tile_1/5v0_half_adder_selector_sc_0/res_stage0 0
C994 5v0_addh_sc_tile_1/pti VDD_1V65_3 0.00234f
C995 5v0_add_q_sc_1/5v0_half_adder_selector_sc_0/res_stage0 c_2_o 0.11645f
C996 5v0_add_q_sc_0/a_n1373_n454# int_carry 0.00136f
C997 5v0_add_q_sc_0/5v0_half_adder_selector_sc_0/m1_n244_n517# res_c 0.16119f
C998 5v0_addh_sc_tile_2/inv_nti int_carry 0
C999 c_2_o 5v0_add_q_sc_1/5v0_half_adder_selector_sc_0/m1_n239_179# 0.00258f
C1000 5v0_addh_sc_tile_0/inv_pti 5v0_add_q_sc_1/nti 0
C1001 5v0_addh_sc_tile_2/pti 5v0_addh_sc_tile_2/m1_103_293# 0.10002f
C1002 5v0_addh_sc_tile_1/downstepper_test 5v0_addh_sc_tile_1/a_n1205_n937# 0.00453f
C1003 5v0_addh_sc_tile_2/ctrl_over 5v0_add_q_sc_0/nti 0
C1004 in_3 5v0_addh_sc_tile_1/ctrl_sign 0
C1005 5v0_addh_sc_tile_1/nti in_2 0.00613f
C1006 5v0_addh_sc_tile_0/upstepper_test in_2 0
C1007 5v0_addh_sc_tile_2/m1_843_n857# 5v0_add_q_sc_0/ctrl_over 0.17802f
C1008 5v0_addh_sc_tile_1/pti 5v0_addh_sc_tile_1/5v0_half_adder_selector_sc_0/res_stage0 0.01078f
C1009 VDD_1V65_4 5v0_addh_sc_tile_2/inv_pti 0.14775f
C1010 5v0_addh_sc_tile_2/5v0_half_adder_selector_sc_0/res_stage0 5v0_addh_sc_tile_2/m1_103_293# 0.18487f
C1011 5v0_addh_sc_tile_1/ctrl_sign 5v0_addh_sc_tile_1/5v0_half_adder_selector_sc_0/res_stage0 0.22639f
C1012 5v0_add_q_sc_0/inv_pti 5v0_add_q_sc_0/upstepper_test 0.0467f
C1013 5v0_add_q_sc_0/ctrl_sign 5v0_addh_sc_tile_2/inv_pti 0.10221f
C1014 5v0_nter2oter_code_sc_1/pti 5v0_addh_sc_tile_2/inv_nti 0
C1015 VDD_1V65_3 res_01 0.01451f
C1016 5v0_add_q_sc_0/5v0_half_adder_selector_sc_0/5v0_tgate_sel_2_sc_1/input_A 5v0_add_q_sc_0/upstepper_test 0
C1017 5v0_addh_sc_tile_1/upstepper_test c01 0
C1018 5v0_addh_sc_tile_2/upstepper_test 5v0_addh_sc_tile_2/a_n1205_n937# 0.00334f
C1019 5v0_add_q_sc_0/inv_pti 5v0_add_q_sc_0/ctrl_over 0
C1020 5v0_addh_sc_tile_0/upstepper_test VDD_1V65_0 0.16859f
C1021 int_012 5v0_addh_sc_tile_0/inv_nti 0.00631f
C1022 5v0_addh_sc_tile_0/m1_843_n857# in_1 0
C1023 5v0_addh_sc_tile_1/a_382_n1095# 5v0_add_q_sc_1/nti 0
C1024 5v0_add_q_sc_1/upstepper_test VDD_3V3_1 0.46215f
C1025 int_c01 c01 0.05455f
C1026 VDD_1V65_3 5v0_addh_sc_tile_2/ctrl_sign 0
C1027 5v0_addh_sc_tile_1/downstepper_test 5v0_addh_sc_tile_1/a_n1373_n454# 0.00442f
C1028 5v0_add_q_sc_0/5v0_half_adder_selector_sc_0/5v0_tgate_sel_2_sc_1/input_A 5v0_add_q_sc_0/ctrl_over 0.04656f
C1029 5v0_addh_sc_tile_1/5v0_half_adder_selector_sc_0/res_stage0 res_01 0.26626f
C1030 in_3 res_0 0.16326f
C1031 5v0_addh_sc_tile_1/inv_pti 5v0_addh_sc_tile_2/m1_843_n857# 0
C1032 5v0_add_q_sc_0/a_n1373_n454# VDD_1V65_5 0.00232f
C1033 in_3 5v0_addh_sc_tile_2/ctrl_sign 0.0062f
C1034 5v0_add_q_sc_0/inv_pti 5v0_addh_sc_tile_1/ctrl_over 0.00152f
C1035 5v0_addh_sc_tile_1/ctrl_sign 5v0_addh_sc_tile_0/5v0_half_adder_selector_sc_0/res_stage0 0.00758f
C1036 5v0_addh_sc_tile_2/downstepper_test 5v0_addh_sc_tile_2/inv_pti 0.13388f
C1037 5v0_addh_sc_tile_1/5v0_half_adder_selector_sc_0/5v0_tgate_sel_2_sc_1/input_A 5v0_addh_sc_tile_1/upstepper_test 0
C1038 5v0_addh_sc_tile_0/inv_pti 5v0_addh_sc_tile_0/m1_843_n857# 0
C1039 VDD_3V3_1 in_1 1.00116f
C1040 5v0_addh_sc_tile_2/upstepper_test 5v0_addh_sc_tile_2/a_n1373_n454# 0
C1041 5v0_add_q_sc_0/5v0_half_adder_selector_sc_0/m1_n244_n517# 5v0_add_q_sc_0/ctrl_over 0.34138f
C1042 5v0_addh_sc_tile_1/upstepper_test 5v0_addh_sc_tile_1/m1_103_293# 0.07773f
C1043 5v0_addh_sc_tile_1/pti 5v0_addh_sc_tile_1/a_n1373_n454# 0
C1044 5v0_addh_sc_tile_0/nti 5v0_addh_sc_tile_1/ctrl_sign 0
C1045 5v0_addh_sc_tile_1/ctrl_over int_012 0.27048f
C1046 int_c01 5v0_addh_sc_tile_1/m1_103_293# 0
C1047 5v0_addh_sc_tile_1/downstepper_test 5v0_addh_sc_tile_1/a_n1778_n454# 0.0031f
C1048 5v0_addh_sc_tile_1/inv_nti VDD_1V65_3 0.08611f
C1049 5v0_add_q_sc_0/5v0_half_adder_selector_sc_0/m1_n239_179# 5v0_addh_sc_tile_1/m1_103_293# 0
C1050 5v0_addh_sc_tile_0/5v0_half_adder_selector_sc_0/res_stage0 res_01 0.0902f
C1051 5v0_addh_sc_tile_1/upstepper_test m1_n2844_n810# 0.00447f
C1052 5v0_nter2oter_code_sc_0/gf180mcu_fd_sc_mcu7t5v0__nor2_1_0/a_224_472# 5v0_addh_sc_tile_2/ctrl_sign 0
C1053 5v0_addh_sc_tile_0/inv_pti VDD_3V3_1 1.05126f
C1054 5v0_addh_sc_tile_2/upstepper_test 5v0_addh_sc_tile_2/pti 0.02426f
C1055 5v0_addh_sc_tile_1/nti 5v0_addh_sc_tile_2/ctrl_over 0.00207f
C1056 5v0_addh_sc_tile_1/ctrl_sign 5v0_addh_sc_tile_0/downstepper_test 0.02017f
C1057 5v0_add_q_sc_0/a_n1373_n454# 5v0_add_q_sc_0/upstepper_test 0
C1058 5v0_nter2oter_code_sc_1/nti int_012 0.00204f
C1059 int_012 5v0_addh_sc_tile_1/inv_pti 0.00119f
C1060 int_c01 m1_n2844_n810# 0.11648f
C1061 5v0_addh_sc_tile_1/ctrl_sign 5v0_nter2oter_code_sc_0/pti 0.00632f
C1062 5v0_addh_sc_tile_0/carry_0_probe 5v0_addh_sc_tile_1/upstepper_test 0.02787f
C1063 5v0_addh_sc_tile_2/5v0_half_adder_selector_sc_0/res_stage0 5v0_addh_sc_tile_2/upstepper_test 0.27475f
C1064 5v0_addh_sc_tile_1/inv_nti 5v0_addh_sc_tile_1/5v0_half_adder_selector_sc_0/res_stage0 0.02399f
C1065 in_3 5v0_addh_sc_tile_2/nti 0.52138f
C1066 5v0_add_q_sc_1/upstepper_test 5v0_add_q_sc_1/inv_nti 0.0011f
C1067 5v0_addh_sc_tile_0/carry_0_probe int_c01 0.23005f
C1068 5v0_addh_sc_tile_2/upstepper_test 5v0_addh_sc_tile_2/a_n1778_n454# 0
C1069 5v0_addh_sc_tile_0/nti res_01 0
C1070 m1_n2844_n810# c01 0.12483f
C1071 5v0_addh_sc_tile_2/inv_nti 5v0_add_q_sc_0/ctrl_over 0.01761f
C1072 VDD_3V3_0 5v0_addh_sc_tile_2/a_n1205_n937# 0.00891f
C1073 5v0_addh_sc_tile_1/a_n1373_n454# res_01 0.00163f
C1074 5v0_addh_sc_tile_1/pti 5v0_addh_sc_tile_1/a_n1778_n454# 0.00135f
C1075 int_c01 5v0_addh_sc_tile_0/m1_103_293# 0
C1076 5v0_addh_sc_tile_0/carry_0_probe c01 0.0594f
C1077 5v0_addh_sc_tile_0/downstepper_test res_01 0.00308f
C1078 in_2 int_012 0.00863f
C1079 5v0_add_q_sc_0/ctrl_sign 5v0_addh_sc_tile_2/m1_103_293# 0.21173f
C1080 5v0_nter2oter_code_sc_0/pti res_01 0
C1081 5v0_addh_sc_tile_1/a_382_n1095# VDD_3V3_1 0.02507f
C1082 5v0_addh_sc_tile_1/a_n1205_n937# 5v0_addh_sc_tile_1/inv_nti 0
C1083 5v0_addh_sc_tile_0/m1_103_293# c01 0.21008f
C1084 5v0_addh_sc_tile_1/ctrl_over 5v0_addh_sc_tile_2/inv_nti 0
C1085 5v0_nter2oter_code_sc_0/gf180mcu_fd_sc_mcu7t5v0__nor2_1_0/a_224_472# 5v0_addh_sc_tile_2/nti 0
C1086 5v0_addh_sc_tile_1/nti 5v0_addh_sc_tile_1/upstepper_test 0.11981f
C1087 5v0_addh_sc_tile_0/a_n1205_n937# 5v0_addh_sc_tile_0/5v0_half_adder_selector_sc_0/res_stage0 0
C1088 5v0_add_q_sc_1/upstepper_test 5v0_add_q_sc_1/pti 0
C1089 in_1 5v0_addh_sc_tile_0/a_382_n1095# 0.09307f
C1090 5v0_nter2oter_code_sc_0/pti 5v0_addh_sc_tile_2/ctrl_sign 0.23385f
C1091 c_2_o int_c01 0.24448f
C1092 5v0_addh_sc_tile_1/m1_843_n857# VDD_3V3_1 0.00388f
C1093 5v0_addh_sc_tile_1/inv_pti 5v0_addh_sc_tile_2/inv_nti 0
C1094 m1_n2844_n810# 5v0_addh_sc_tile_1/m1_103_293# 0
C1095 5v0_addh_sc_tile_1/downstepper_test 5v0_addh_sc_tile_2/inv_pti 0.01675f
C1096 VDD_3V3_0 5v0_addh_sc_tile_2/a_n1373_n454# 0.00122f
C1097 5v0_addh_sc_tile_1/a_n1778_n454# res_01 0.00182f
C1098 5v0_addh_sc_tile_0/upstepper_test c01 0
C1099 5v0_addh_sc_tile_0/a_n1205_n937# 5v0_addh_sc_tile_0/nti 0
C1100 5v0_add_q_sc_0/pti 5v0_add_q_sc_0/nti 0.1782f
C1101 5v0_addh_sc_tile_0/carry_0_probe 5v0_addh_sc_tile_1/m1_103_293# 0.002f
C1102 5v0_addh_sc_tile_2/ctrl_over 5v0_addh_sc_tile_2/m1_843_n857# 0.10619f
C1103 5v0_addh_sc_tile_2/downstepper_test 5v0_addh_sc_tile_2/m1_103_293# 0.0934f
C1104 5v0_addh_sc_tile_0/inv_pti 5v0_addh_sc_tile_0/a_382_n1095# 0.00129f
C1105 5v0_addh_sc_tile_1/a_n1373_n454# 5v0_addh_sc_tile_1/inv_nti 0
C1106 c_2_o 5v0_add_q_sc_0/nti 0.01581f
C1107 VDD_3V3_0 5v0_addh_sc_tile_2/pti 0.713f
C1108 5v0_addh_sc_tile_0/a_n1205_n937# 5v0_addh_sc_tile_0/downstepper_test 0.00453f
C1109 5v0_add_q_sc_1/nti 5v0_add_q_sc_1/a_n1205_n937# 0
C1110 5v0_addh_sc_tile_0/carry_0_probe m1_n2844_n810# 0.40894f
C1111 5v0_addh_sc_tile_2/5v0_half_adder_selector_sc_0/res_stage0 VDD_3V3_0 0.16541f
C1112 5v0_addh_sc_tile_1/5v0_half_adder_selector_sc_0/5v0_tgate_sel_2_sc_1/input_A c_2_o 0
C1113 5v0_add_q_sc_0/inv_pti 5v0_addh_sc_tile_2/ctrl_over 0
C1114 m1_n2844_n810# 5v0_addh_sc_tile_0/m1_103_293# 0
C1115 5v0_addh_sc_tile_2/pti 5v0_addh_sc_tile_2/a_382_n1095# 0.12254f
C1116 5v0_addh_sc_tile_1/pti 5v0_addh_sc_tile_2/inv_pti 0
C1117 5v0_addh_sc_tile_2/nti 5v0_nter2oter_code_sc_0/pti 0
C1118 5v0_add_q_sc_0/a_n1205_n937# 5v0_add_q_sc_0/nti 0
C1119 5v0_addh_sc_tile_1/ctrl_sign 5v0_addh_sc_tile_2/inv_pti 0.00447f
C1120 5v0_addh_sc_tile_0/pti VDD_1V65_2 0
C1121 c_2_o 5v0_addh_sc_tile_1/m1_103_293# 0.01922f
C1122 5v0_addh_sc_tile_2/5v0_half_adder_selector_sc_0/res_stage0 5v0_addh_sc_tile_2/a_382_n1095# 0.08951f
C1123 5v0_addh_sc_tile_0/carry_0_probe 5v0_addh_sc_tile_0/m1_103_293# 0.01488f
C1124 5v0_addh_sc_tile_2/pti int_carry 0.00318f
C1125 5v0_add_q_sc_1/upstepper_test int_carry 0
C1126 5v0_nter2oter_code_sc_0/nti VDD_3V3_1 0.09208f
C1127 5v0_addh_sc_tile_2/upstepper_test VDD_1V65_4 0.16859f
C1128 5v0_addh_sc_tile_1/a_n1778_n454# 5v0_addh_sc_tile_1/inv_nti 0.00226f
C1129 int_012 5v0_addh_sc_tile_2/ctrl_over 1.76395f
C1130 5v0_add_q_sc_1/upstepper_test VDD_1V65_1 0.16859f
C1131 VDD_3V3_0 5v0_add_q_sc_0/5v0_half_adder_selector_sc_0/res_stage0 0.16909f
C1132 5v0_addh_sc_tile_0/carry_0_probe c_2_o 0
C1133 5v0_add_q_sc_1/nti c_2_s 0.2845f
C1134 5v0_add_q_sc_0/5v0_half_adder_selector_sc_0/m1_n244_n517# 5v0_addh_sc_tile_2/ctrl_over 0.00443f
C1135 5v0_addh_sc_tile_2/inv_pti res_01 0
C1136 5v0_addh_sc_tile_1/nti 5v0_addh_sc_tile_0/carry_0_probe 0.013f
C1137 5v0_addh_sc_tile_0/upstepper_test 5v0_addh_sc_tile_0/carry_0_probe 0
C1138 5v0_nter2oter_code_sc_1/pti 5v0_addh_sc_tile_2/pti 0.00125f
C1139 5v0_addh_sc_tile_0/a_n1373_n454# 5v0_addh_sc_tile_0/inv_nti 0
C1140 5v0_addh_sc_tile_0/a_n1373_n454# 5v0_addh_sc_tile_0/pti 0
C1141 5v0_add_q_sc_0/downstepper_test 5v0_add_q_sc_0/inv_nti 0.1819f
C1142 in_0_sign in_1 0
C1143 5v0_add_q_sc_0/5v0_half_adder_selector_sc_0/res_stage0 5v0_addh_sc_tile_2/a_382_n1095# 0.0013f
C1144 5v0_addh_sc_tile_1/nti 5v0_addh_sc_tile_0/m1_103_293# 0
C1145 5v0_addh_sc_tile_0/upstepper_test 5v0_addh_sc_tile_0/m1_103_293# 0.07773f
C1146 5v0_addh_sc_tile_2/pti res_c 0
C1147 5v0_add_q_sc_0/inv_pti 5v0_add_q_sc_0/5v0_half_adder_selector_sc_0/m1_n239_179# 0
C1148 5v0_addh_sc_tile_2/ctrl_sign 5v0_addh_sc_tile_2/inv_pti 0.28426f
C1149 5v0_addh_sc_tile_1/pti 5v0_add_q_sc_1/nti 0
C1150 5v0_addh_sc_tile_1/a_n1205_n937# VDD_1V65_3 0.00354f
C1151 5v0_add_q_sc_0/pti c_2_o 0.00513f
C1152 5v0_add_q_sc_0/5v0_half_adder_selector_sc_0/res_stage0 int_carry 0.27792f
C1153 5v0_add_q_sc_1/nti 5v0_add_q_sc_1/inv_pti 0.21255f
C1154 5v0_addh_sc_tile_1/ctrl_sign 5v0_add_q_sc_1/nti 0.00138f
C1155 5v0_addh_sc_tile_1/upstepper_test int_012 0.00268f
C1156 5v0_addh_sc_tile_2/upstepper_test 5v0_addh_sc_tile_2/downstepper_test 0.38555f
C1157 5v0_addh_sc_tile_0/inv_pti in_0_sign 0.23041f
C1158 5v0_addh_sc_tile_1/downstepper_test 5v0_addh_sc_tile_2/m1_103_293# 0.00921f
C1159 VDD_3V3_0 5v0_add_q_sc_0/downstepper_test 0.55841f
C1160 5v0_addh_sc_tile_1/a_382_n1095# VDD_3V3_0 0.61115f
C1161 5v0_add_q_sc_1/a_n1205_n937# VDD_3V3_1 0.00891f
C1162 5v0_addh_sc_tile_1/nti c_2_o 0
C1163 5v0_addh_sc_tile_2/ctrl_over 5v0_addh_sc_tile_2/inv_nti 0.26006f
C1164 5v0_addh_sc_tile_1/a_n1205_n937# 5v0_addh_sc_tile_1/5v0_half_adder_selector_sc_0/res_stage0 0
C1165 5v0_addh_sc_tile_0/a_n1778_n454# 5v0_addh_sc_tile_0/pti 0.00135f
C1166 5v0_addh_sc_tile_0/a_n1778_n454# 5v0_addh_sc_tile_0/inv_nti 0.00226f
C1167 5v0_addh_sc_tile_1/downstepper_test 5v0_addh_sc_tile_0/m1_843_n857# 0
C1168 5v0_add_q_sc_0/inv_pti 5v0_add_q_sc_0/nti 0.21873f
C1169 5v0_add_q_sc_0/downstepper_test 5v0_addh_sc_tile_2/a_382_n1095# 0.00139f
C1170 5v0_addh_sc_tile_0/inv_pti 5v0_nter2oter_code_sc_1/pti 0
C1171 5v0_add_q_sc_0/5v0_half_adder_selector_sc_0/m1_n244_n517# 5v0_add_q_sc_0/5v0_half_adder_selector_sc_0/m1_n239_179# 0.00585f
C1172 5v0_addh_sc_tile_1/inv_nti 5v0_addh_sc_tile_2/inv_pti 0
C1173 VDD_3V3_0 5v0_addh_sc_tile_1/m1_843_n857# 0.20528f
C1174 5v0_addh_sc_tile_0/m1_843_n857# c_2_s 0
C1175 5v0_addh_sc_tile_1/a_n1373_n454# VDD_1V65_3 0.00232f
C1176 5v0_add_q_sc_0/downstepper_test int_carry 0.17146f
C1177 5v0_add_q_sc_0/5v0_half_adder_selector_sc_0/res_stage0 res_c 0.08533f
C1178 5v0_addh_sc_tile_1/a_382_n1095# int_carry 0.00603f
C1179 VDD_3V3_0 VDD_1V65_4 0.0468f
C1180 5v0_add_q_sc_1/nti 5v0_add_q_sc_1/5v0_half_adder_selector_sc_0/m1_n244_n517# 0
C1181 5v0_addh_sc_tile_2/nti 5v0_addh_sc_tile_2/inv_pti 0.24025f
C1182 5v0_addh_sc_tile_1/downstepper_test VDD_3V3_1 0.09186f
C1183 5v0_addh_sc_tile_1/pti 5v0_addh_sc_tile_2/m1_103_293# 0
C1184 VDD_3V3_0 5v0_add_q_sc_0/ctrl_sign 0.80665f
C1185 VDD_1V65_2 VSS_3 0.07318f
C1186 5v0_addh_sc_tile_2/pti VSS_3 1.17571f
C1187 VDD_1V65_4 VSS_3 0.09068f
C1188 5v0_addh_sc_tile_2/inv_nti VSS_3 1.3751f
C1189 5v0_addh_sc_tile_2/m1_843_n857# VSS_3 0.16265f ; **FLOATING
C1190 5v0_addh_sc_tile_2/ctrl_sign VSS_3 1.27243f
C1191 5v0_addh_sc_tile_2/a_n1205_n937# VSS_3 0 ; **FLOATING
C1192 5v0_addh_sc_tile_2/a_n1373_n454# VSS_3 0.00335f ; **FLOATING
C1193 5v0_addh_sc_tile_2/a_n1778_n454# VSS_3 0.00573f ; **FLOATING
C1194 5v0_addh_sc_tile_2/inv_pti VSS_3 0.92511f
C1195 5v0_addh_sc_tile_2/5v0_half_adder_selector_sc_0/5v0_tgate_sel_2_sc_1/input_A VSS_3 0
C1196 5v0_addh_sc_tile_2/a_382_n1095# VSS_3 0.83941f ; **FLOATING
C1197 in_3 VSS_3 1.64882f
C1198 res_0 VSS_3 0.02768f
C1199 5v0_addh_sc_tile_2/ctrl_over VSS_3 0.80165f
C1200 5v0_addh_sc_tile_2/m1_103_293# VSS_3 0.74864f ; **FLOATING
C1201 5v0_addh_sc_tile_2/5v0_half_adder_selector_sc_0/res_stage0 VSS_3 0.50069f
C1202 5v0_addh_sc_tile_2/downstepper_test VSS_3 0.58281f
C1203 5v0_addh_sc_tile_2/upstepper_test VSS_3 0.53687f
C1204 5v0_addh_sc_tile_2/nti VSS_3 1.2554f
C1205 5v0_addh_sc_tile_1/pti VSS_3 1.17421f
C1206 VDD_1V65_3 VSS_3 0.09068f
C1207 5v0_addh_sc_tile_1/inv_nti VSS_3 1.35629f
C1208 5v0_addh_sc_tile_1/m1_843_n857# VSS_3 0.15965f ; **FLOATING
C1209 5v0_addh_sc_tile_1/ctrl_sign VSS_3 1.3078f
C1210 5v0_addh_sc_tile_1/a_n1205_n937# VSS_3 0 ; **FLOATING
C1211 5v0_addh_sc_tile_1/a_n1373_n454# VSS_3 0.00335f ; **FLOATING
C1212 5v0_addh_sc_tile_1/a_n1778_n454# VSS_3 0.00573f ; **FLOATING
C1213 5v0_addh_sc_tile_1/inv_pti VSS_3 0.92626f
C1214 VDD_3V3_1 VSS_3 38.76431f
C1215 5v0_addh_sc_tile_1/5v0_half_adder_selector_sc_0/5v0_tgate_sel_2_sc_1/input_A VSS_3 0
C1216 5v0_addh_sc_tile_1/a_382_n1095# VSS_3 0.81445f ; **FLOATING
C1217 res_01 VSS_3 1.54805f
C1218 int_012 VSS_3 1.10181f
C1219 5v0_addh_sc_tile_1/ctrl_over VSS_3 0.79116f
C1220 5v0_addh_sc_tile_1/m1_103_293# VSS_3 0.74864f ; **FLOATING
C1221 5v0_addh_sc_tile_1/5v0_half_adder_selector_sc_0/res_stage0 VSS_3 0.50069f
C1222 5v0_addh_sc_tile_1/downstepper_test VSS_3 0.58281f
C1223 5v0_addh_sc_tile_1/upstepper_test VSS_3 0.53687f
C1224 5v0_addh_sc_tile_1/nti VSS_3 1.26884f
C1225 5v0_addh_sc_tile_0/pti VSS_3 1.17947f
C1226 VDD_1V65_0 VSS_3 0.09068f
C1227 5v0_addh_sc_tile_0/inv_nti VSS_3 1.36063f
C1228 5v0_addh_sc_tile_0/m1_843_n857# VSS_3 0.15969f ; **FLOATING
C1229 in_0_sign VSS_3 0.87016f
C1230 5v0_addh_sc_tile_0/a_n1205_n937# VSS_3 0 ; **FLOATING
C1231 5v0_addh_sc_tile_0/a_n1373_n454# VSS_3 0.00335f ; **FLOATING
C1232 5v0_addh_sc_tile_0/a_n1778_n454# VSS_3 0.00573f ; **FLOATING
C1233 5v0_addh_sc_tile_0/inv_pti VSS_3 0.92409f
C1234 c01 VSS_3 0.24862f
C1235 5v0_addh_sc_tile_0/carry_0_probe VSS_3 0.62839f
C1236 5v0_addh_sc_tile_0/5v0_half_adder_selector_sc_0/5v0_tgate_sel_2_sc_1/input_A VSS_3 0
C1237 5v0_addh_sc_tile_0/a_382_n1095# VSS_3 0.81488f ; **FLOATING
C1238 in_1 VSS_3 1.70172f
C1239 in_0_over VSS_3 0.49348f
C1240 5v0_addh_sc_tile_0/m1_103_293# VSS_3 0.74828f ; **FLOATING
C1241 5v0_addh_sc_tile_0/5v0_half_adder_selector_sc_0/res_stage0 VSS_3 0.50069f
C1242 5v0_addh_sc_tile_0/downstepper_test VSS_3 0.58464f
C1243 5v0_addh_sc_tile_0/upstepper_test VSS_3 0.53687f
C1244 5v0_addh_sc_tile_0/nti VSS_3 1.25562f
C1245 in_2 VSS_3 0.95085f
C1246 5v0_nter2oter_code_sc_1/pti VSS_3 0.62525f
C1247 5v0_nter2oter_code_sc_1/nti VSS_3 0.65963f
C1248 5v0_nter2oter_code_sc_1/gf180mcu_fd_sc_mcu7t5v0__nor2_1_0/a_224_472# VSS_3 0 ; **FLOATING
C1249 5v0_nter2oter_code_sc_0/pti VSS_3 0.61125f
C1250 5v0_nter2oter_code_sc_0/nti VSS_3 0.66288f
C1251 5v0_nter2oter_code_sc_0/gf180mcu_fd_sc_mcu7t5v0__nor2_1_0/a_224_472# VSS_3 0 ; **FLOATING
C1252 5v0_add_q_sc_1/pti VSS_3 0.59838f
C1253 VDD_1V65_1 VSS_3 0.09068f
C1254 5v0_add_q_sc_1/inv_nti VSS_3 0.53562f
C1255 5v0_add_q_sc_1/inv_pti VSS_3 0.59603f
C1256 5v0_add_q_sc_1/a_n1205_n937# VSS_3 0 ; **FLOATING
C1257 5v0_add_q_sc_1/a_n1373_n454# VSS_3 0.00335f ; **FLOATING
C1258 5v0_add_q_sc_1/a_n1778_n454# VSS_3 0.00573f ; **FLOATING
C1259 5v0_add_q_sc_1/5v0_half_adder_selector_sc_0/5v0_tgate_sel_2_sc_1/input_A VSS_3 0
C1260 5v0_add_q_sc_1/5v0_half_adder_selector_sc_0/m1_n244_n517# VSS_3 0.29628f ; **FLOATING
C1261 int_c01 VSS_3 1.92885f
C1262 c_2_o VSS_3 0.97319f
C1263 5v0_add_q_sc_1/5v0_half_adder_selector_sc_0/m1_n239_179# VSS_3 0.29901f ; **FLOATING
C1264 5v0_add_q_sc_1/5v0_half_adder_selector_sc_0/res_stage0 VSS_3 0.50836f
C1265 5v0_add_q_sc_1/downstepper_test VSS_3 0.63842f
C1266 c_2_s VSS_3 1.02067f
C1267 5v0_add_q_sc_1/upstepper_test VSS_3 0.5468f
C1268 5v0_add_q_sc_1/nti VSS_3 1.26615f
C1269 5v0_add_q_sc_0/pti VSS_3 0.59945f
C1270 VDD_1V65_5 VSS_3 0.09068f
C1271 5v0_add_q_sc_0/inv_nti VSS_3 0.53562f
C1272 5v0_add_q_sc_0/inv_pti VSS_3 0.59603f
C1273 5v0_add_q_sc_0/a_n1205_n937# VSS_3 0 ; **FLOATING
C1274 5v0_add_q_sc_0/a_n1373_n454# VSS_3 0.00335f ; **FLOATING
C1275 5v0_add_q_sc_0/a_n1778_n454# VSS_3 0.00573f ; **FLOATING
C1276 5v0_add_q_sc_0/5v0_half_adder_selector_sc_0/5v0_tgate_sel_2_sc_1/input_A VSS_3 0
C1277 5v0_add_q_sc_0/5v0_half_adder_selector_sc_0/m1_n244_n517# VSS_3 0.29628f ; **FLOATING
C1278 int_carry VSS_3 2.49654f
C1279 res_c VSS_3 0.0293f
C1280 5v0_add_q_sc_0/ctrl_over VSS_3 0.73852f
C1281 5v0_add_q_sc_0/5v0_half_adder_selector_sc_0/m1_n239_179# VSS_3 0.29907f ; **FLOATING
C1282 5v0_add_q_sc_0/5v0_half_adder_selector_sc_0/res_stage0 VSS_3 0.50905f
C1283 5v0_add_q_sc_0/downstepper_test VSS_3 0.64239f
C1284 5v0_add_q_sc_0/ctrl_sign VSS_3 0.49276f
C1285 VDD_3V3_0 VSS_3 47.31763f
C1286 5v0_add_q_sc_0/upstepper_test VSS_3 0.54953f
C1287 5v0_add_q_sc_0/nti VSS_3 1.27003f
C1288 m1_n2844_n810# VSS_3 0.48934f ; **FLOATING
