* NGSPICE file created from 5v0_add3_sc.ext - technology: gf180mcuD

.option scale=5n

X0 5v0_add_q_sc_1/ternary_input m1_n2844_n810# 5v0_addh_sc_tile_0/carry_sign_probe VSS_3 nfet_06v0 ad=14.432n pd=0.504m as=14.432n ps=0.504m w=164 l=120
X1 VDD_1V65_2 5v0_addh_sc_tile_0/carry_0_probe 5v0_add_q_sc_1/ternary_input VSS_3 nfet_06v0 ad=14.432n pd=0.504m as=14.432n ps=0.504m w=164 l=120
X2 5v0_add_q_sc_0/pti 5v0_add_q_sc_0/ternary_input VSS_3 VSS_3 nfet_06v0 ad=6.336n pd=0.32m as=6.478n ps=0.255m w=72 l=578
X3 VDD_3V3_0 5v0_add_q_sc_0/ternary_input 5v0_add_q_sc_0/pti VDD_3V3_0 pfet_06v0 ad=12.81n pd=0.349m as=12.688n ps=0.348m w=244 l=100
X4 VDD_3V3_0 5v0_add_q_sc_0/ternary_input 5v0_add_q_sc_0/nti VDD_3V3_0 pfet_06v0 ad=13.616n pd=0.392m as=9.696n ps=0.394m w=96 l=150
X5 VSS_3 5v0_add_q_sc_0/ternary_input 5v0_add_q_sc_0/nti VSS_3 nfet_06v0 ad=6.478n pd=0.255m as=12.7n ps=0.454m w=127 l=120
X6 5v0_add_q_sc_0/pti 5v0_add_q_sc_0/ternary_input VDD_3V3_0 VDD_3V3_0 pfet_06v0 ad=12.688n pd=0.348m as=13.616n ps=0.392m w=244 l=100
X7 5v0_add_q_sc_0/pti 5v0_add_q_sc_0/ternary_input VDD_3V3_0 VDD_3V3_0 pfet_06v0 ad=27.328n pd=0.712m as=12.81n ps=0.349m w=244 l=100
X8 5v0_add_q_sc_0/5v0_half_adder_selector_sc_0/res_stage0 5v0_add_q_sc_0/5v0_half_adder_selector_sc_0/m1_n239_179# 5v0_add_q_sc_0/downstepper_test VSS_3 nfet_06v0 ad=14.432n pd=0.504m as=14.432n ps=0.504m w=164 l=120
X9 5v0_add_q_sc_0/5v0_half_adder_selector_sc_0/res_stage0 5v0_add_q_sc_0/5v0_half_adder_selector_sc_0/m1_n239_179# 5v0_add_q_sc_0/upstepper_test VDD_3V3_0 pfet_06v0 ad=21.472n pd=0.664m as=21.472n ps=0.664m w=244 l=100
X10 5v0_add_q_sc_0/5v0_half_adder_selector_sc_0/m1_n239_179# 5v0_add_q_sc_0/ctrl_sign VSS_3 VSS_3 nfet_06v0 ad=14.432n pd=0.504m as=14.432n ps=0.504m w=164 l=120
X11 5v0_add_q_sc_0/5v0_half_adder_selector_sc_0/m1_n239_179# 5v0_add_q_sc_0/ctrl_sign VDD_3V3_0 VDD_3V3_0 pfet_06v0 ad=21.472n pd=0.664m as=21.472n ps=0.664m w=244 l=100
X12 5v0_add_q_sc_0/5v0_half_adder_selector_sc_0/res_stage0 5v0_add_q_sc_0/ctrl_sign 5v0_add_q_sc_0/upstepper_test VSS_3 nfet_06v0 ad=31.489n pd=1.041m as=43.711n ps=1.504m w=164 l=120
X13 5v0_add_q_sc_0/5v0_half_adder_selector_sc_0/res_stage0 5v0_add_q_sc_0/ctrl_sign 5v0_add_q_sc_0/downstepper_test VDD_3V3_0 pfet_06v0 ad=46.849n pd=1.361m as=42.856n ps=1.326m w=244 l=100
X14 res_c 5v0_add_q_sc_0/5v0_half_adder_selector_sc_0/m1_n244_n517# 5v0_add_q_sc_0/5v0_half_adder_selector_sc_0/res_stage0 VSS_3 nfet_06v0 ad=17.057n pd=0.537m as=0 ps=0 w=164 l=120
X15 res_c 5v0_add_q_sc_0/5v0_half_adder_selector_sc_0/m1_n244_n517# 5v0_add_q_sc_0/ternary_input VDD_3V3_0 pfet_06v0 ad=25.377n pd=0.697m as=46.849n ps=1.361m w=244 l=100
X16 5v0_add_q_sc_0/5v0_half_adder_selector_sc_0/m1_n244_n517# 5v0_add_q_sc_0/ctrl_over VSS_3 VSS_3 nfet_06v0 ad=14.432n pd=0.504m as=0.63612u ps=0.02242 w=164 l=120
X17 5v0_add_q_sc_0/5v0_half_adder_selector_sc_0/m1_n244_n517# 5v0_add_q_sc_0/ctrl_over VDD_3V3_0 VDD_3V3_0 pfet_06v0 ad=21.472n pd=0.664m as=0.50045u ps=0.0145 w=244 l=100
X18 res_c 5v0_add_q_sc_0/ctrl_over 5v0_add_q_sc_0/ternary_input VSS_3 nfet_06v0 ad=0 pd=0 as=31.489n ps=1.041m w=164 l=120
X19 res_c 5v0_add_q_sc_0/ctrl_over 5v0_add_q_sc_0/5v0_half_adder_selector_sc_0/res_stage0 VDD_3V3_0 pfet_06v0 ad=0 pd=0 as=0 ps=0 w=244 l=100
X20 5v0_add_q_sc_0/inv_pti 5v0_add_q_sc_0/pti VSS_3 VSS_3 nfet_06v0 ad=14.432n pd=0.504m as=14.432n ps=0.504m w=164 l=120
X21 5v0_add_q_sc_0/inv_pti 5v0_add_q_sc_0/pti VDD_3V3_0 VDD_3V3_0 pfet_06v0 ad=21.472n pd=0.664m as=21.472n ps=0.664m w=244 l=100
X22 5v0_add_q_sc_0/a_n1373_n454# 5v0_add_q_sc_0/inv_nti 5v0_add_q_sc_0/downstepper_test VSS_3 nfet_06v0 ad=3.528n pd=0.195m as=8.599n ps=0.264m w=147 l=120
X23 5v0_add_q_sc_0/upstepper_test 5v0_add_q_sc_0/nti 5v0_add_q_sc_0/a_n1205_n937# VDD_3V3_0 pfet_06v0 ad=21.384n pd=0.662m as=5.832n ps=0.291m w=243 l=100
X24 5v0_add_q_sc_0/inv_nti 5v0_add_q_sc_0/nti VDD_3V3_0 VDD_3V3_0 pfet_06v0 ad=21.472n pd=0.664m as=21.472n ps=0.664m w=244 l=100
X25 5v0_add_q_sc_0/upstepper_test 5v0_add_q_sc_0/nti VDD_1V65_5 VSS_3 nfet_06v0 ad=14.847n pd=0.496m as=10.51n ps=0.29m w=147 l=120
X26 5v0_add_q_sc_0/a_n1205_n937# 5v0_add_q_sc_0/inv_pti VDD_3V3_0 VDD_3V3_0 pfet_06v0 ad=5.832n pd=0.291m as=21.384n ps=0.662m w=243 l=100
X27 5v0_add_q_sc_0/downstepper_test 5v0_add_q_sc_0/pti 5v0_add_q_sc_0/a_n1778_n454# VSS_3 nfet_06v0 ad=8.599n pd=0.264m as=3.528n ps=0.195m w=147 l=120
X28 5v0_add_q_sc_0/inv_nti 5v0_add_q_sc_0/nti VSS_3 VSS_3 nfet_06v0 ad=14.432n pd=0.504m as=14.432n ps=0.504m w=164 l=120
X29 5v0_add_q_sc_0/a_n1778_n454# 5v0_add_q_sc_0/inv_nti VSS_3 VSS_3 nfet_06v0 ad=3.528n pd=0.195m as=14.847n ps=0.496m w=147 l=120
X30 5v0_add_q_sc_0/upstepper_test 5v0_add_q_sc_0/inv_pti VSS_3 VSS_3 nfet_06v0 ad=14.432n pd=0.504m as=14.432n ps=0.504m w=164 l=120
X31 VDD_1V65_5 5v0_add_q_sc_0/inv_pti 5v0_add_q_sc_0/a_n1373_n454# VSS_3 nfet_06v0 ad=10.51n pd=0.29m as=3.528n ps=0.195m w=147 l=120
X32 5v0_add_q_sc_0/downstepper_test 5v0_add_q_sc_0/inv_nti VDD_3V3_0 VDD_3V3_0 pfet_06v0 ad=21.384n pd=0.662m as=21.384n ps=0.662m w=243 l=100
X33 5v0_addh_sc_tile_2/ctrl_over 5v0_addh_sc_tile_2/ctrl_sign 5v0_nter2oter_code_sc_0/gf180mcu_fd_sc_mcu7t5v0__nor2_1_0/a_224_472# VDD_3V3_0 pfet_06v0 ad=21.472n pd=0.664m as=16.348n ps=0.378m w=244 l=100
X34 VSS_3 5v0_addh_sc_tile_2/ctrl_sign 5v0_addh_sc_tile_2/ctrl_over VSS_3 nfet_06v0 ad=9.944n pd=0.402m as=5.876n ps=0.217m w=113 l=120
X35 5v0_nter2oter_code_sc_0/gf180mcu_fd_sc_mcu7t5v0__nor2_1_0/a_224_472# 5v0_nter2oter_code_sc_0/nti VDD_3V3_0 VDD_3V3_0 pfet_06v0 ad=16.348n pd=0.378m as=20.932n ps=0.664m w=244 l=100
X36 5v0_addh_sc_tile_2/ctrl_over 5v0_nter2oter_code_sc_0/nti VSS_3 VSS_3 nfet_06v0 ad=5.876n pd=0.217m as=9.944n ps=0.402m w=113 l=120
X37 5v0_addh_sc_tile_2/ctrl_sign 5v0_nter2oter_code_sc_0/pti VSS_3 VSS_3 nfet_06v0 ad=14.432n pd=0.504m as=0 ps=0 w=164 l=120
X38 5v0_addh_sc_tile_2/ctrl_sign 5v0_nter2oter_code_sc_0/pti VDD_3V3_0 VDD_3V3_0 pfet_06v0 ad=21.472n pd=0.664m as=0 ps=0 w=244 l=100
X39 5v0_nter2oter_code_sc_0/pti 5v0_nter2oter_code_sc_0/in VSS_3 VSS_3 nfet_06v0 ad=6.336n pd=0.32m as=6.478n ps=0.255m w=72 l=578
X40 VDD_3V3_1 5v0_nter2oter_code_sc_0/in 5v0_nter2oter_code_sc_0/pti VDD_3V3_1 pfet_06v0 ad=12.81n pd=0.349m as=12.688n ps=0.348m w=244 l=100
X41 VDD_3V3_1 5v0_nter2oter_code_sc_0/in 5v0_nter2oter_code_sc_0/nti VDD_3V3_1 pfet_06v0 ad=13.616n pd=0.392m as=9.696n ps=0.394m w=96 l=150
X42 VSS_3 5v0_nter2oter_code_sc_0/in 5v0_nter2oter_code_sc_0/nti VSS_3 nfet_06v0 ad=6.478n pd=0.255m as=12.7n ps=0.454m w=127 l=120
X43 5v0_nter2oter_code_sc_0/pti 5v0_nter2oter_code_sc_0/in VDD_3V3_1 VDD_3V3_1 pfet_06v0 ad=12.688n pd=0.348m as=13.616n ps=0.392m w=244 l=100
X44 5v0_nter2oter_code_sc_0/pti 5v0_nter2oter_code_sc_0/in VDD_3V3_1 VDD_3V3_1 pfet_06v0 ad=27.328n pd=0.712m as=12.81n ps=0.349m w=244 l=100
X45 5v0_add_q_sc_1/pti 5v0_add_q_sc_1/ternary_input VSS_3 VSS_3 nfet_06v0 ad=6.336n pd=0.32m as=0 ps=0 w=72 l=578
X46 VDD_3V3_1 5v0_add_q_sc_1/ternary_input 5v0_add_q_sc_1/pti VDD_3V3_1 pfet_06v0 ad=0.54021u pd=0.01553 as=52.704n ps=1.408m w=244 l=100
X47 VDD_3V3_1 5v0_add_q_sc_1/ternary_input 5v0_add_q_sc_1/nti VDD_3V3_1 pfet_06v0 ad=0 pd=0 as=9.696n ps=0.394m w=96 l=150
X48 VSS_3 5v0_add_q_sc_1/ternary_input 5v0_add_q_sc_1/nti VSS_3 nfet_06v0 ad=0 pd=0 as=12.7n ps=0.454m w=127 l=120
X49 5v0_add_q_sc_1/pti 5v0_add_q_sc_1/ternary_input VDD_3V3_1 VDD_3V3_1 pfet_06v0 ad=0 pd=0 as=0 ps=0 w=244 l=100
X50 5v0_add_q_sc_1/pti 5v0_add_q_sc_1/ternary_input VDD_3V3_1 VDD_3V3_1 pfet_06v0 ad=0 pd=0 as=0 ps=0 w=244 l=100
X51 5v0_add_q_sc_1/5v0_half_adder_selector_sc_0/res_stage0 5v0_add_q_sc_1/5v0_half_adder_selector_sc_0/m1_n239_179# 5v0_add_q_sc_1/downstepper_test VSS_3 nfet_06v0 ad=31.489n pd=1.041m as=31.631n ps=1.032m w=164 l=120
X52 5v0_add_q_sc_1/5v0_half_adder_selector_sc_0/res_stage0 5v0_add_q_sc_1/5v0_half_adder_selector_sc_0/m1_n239_179# VSS_3 VDD_3V3_1 pfet_06v0 ad=46.849n pd=1.361m as=0.15934u ps=5.646m w=244 l=100
X53 5v0_add_q_sc_1/5v0_half_adder_selector_sc_0/m1_n239_179# 5v0_add_q_sc_1/ctrl_sign VSS_3 VSS_3 nfet_06v0 ad=14.432n pd=0.504m as=0 ps=0 w=164 l=120
X54 5v0_add_q_sc_1/5v0_half_adder_selector_sc_0/m1_n239_179# 5v0_add_q_sc_1/ctrl_sign VDD_3V3_1 VDD_3V3_1 pfet_06v0 ad=21.472n pd=0.664m as=0 ps=0 w=244 l=100
X55 5v0_add_q_sc_1/5v0_half_adder_selector_sc_0/res_stage0 5v0_add_q_sc_1/ctrl_sign VSS_3 VSS_3 nfet_06v0 ad=0 pd=0 as=0 ps=0 w=164 l=120
X56 5v0_add_q_sc_1/5v0_half_adder_selector_sc_0/res_stage0 5v0_add_q_sc_1/ctrl_sign 5v0_add_q_sc_1/downstepper_test VDD_3V3_1 pfet_06v0 ad=0 pd=0 as=42.856n ps=1.326m w=244 l=100
X57 5v0_add_q_sc_0/ternary_input 5v0_add_q_sc_1/5v0_half_adder_selector_sc_0/m1_n244_n517# 5v0_add_q_sc_1/5v0_half_adder_selector_sc_0/res_stage0 VSS_3 nfet_06v0 ad=0 pd=0 as=0 ps=0 w=164 l=120
X58 5v0_add_q_sc_0/ternary_input 5v0_add_q_sc_1/5v0_half_adder_selector_sc_0/m1_n244_n517# 5v0_add_q_sc_1/ternary_input VDD_3V3_1 pfet_06v0 ad=0 pd=0 as=42.945n ps=1.329m w=244 l=100
X59 5v0_add_q_sc_1/5v0_half_adder_selector_sc_0/m1_n244_n517# 5v0_add_q_sc_1/ctrl_over VSS_3 VSS_3 nfet_06v0 ad=14.432n pd=0.504m as=0 ps=0 w=164 l=120
X60 5v0_add_q_sc_1/5v0_half_adder_selector_sc_0/m1_n244_n517# 5v0_add_q_sc_1/ctrl_over VDD_3V3_1 VDD_3V3_1 pfet_06v0 ad=21.472n pd=0.664m as=0 ps=0 w=244 l=100
X61 5v0_add_q_sc_0/ternary_input 5v0_add_q_sc_1/ctrl_over 5v0_add_q_sc_1/ternary_input VSS_3 nfet_06v0 ad=0 pd=0 as=31.489n ps=1.041m w=164 l=120
X62 5v0_add_q_sc_0/ternary_input 5v0_add_q_sc_1/ctrl_over 5v0_add_q_sc_1/5v0_half_adder_selector_sc_0/res_stage0 VDD_3V3_1 pfet_06v0 ad=0 pd=0 as=0 ps=0 w=244 l=100
X63 5v0_add_q_sc_1/inv_pti 5v0_add_q_sc_1/pti VSS_3 VSS_3 nfet_06v0 ad=14.432n pd=0.504m as=0 ps=0 w=164 l=120
X64 5v0_add_q_sc_1/inv_pti 5v0_add_q_sc_1/pti VDD_3V3_1 VDD_3V3_1 pfet_06v0 ad=21.472n pd=0.664m as=0 ps=0 w=244 l=100
X65 5v0_add_q_sc_1/a_n1373_n454# 5v0_add_q_sc_1/inv_nti 5v0_add_q_sc_1/downstepper_test VSS_3 nfet_06v0 ad=7.056n pd=0.39m as=0 ps=0 w=147 l=120
X66 VSS_3 5v0_add_q_sc_1/nti 5v0_add_q_sc_1/a_n1205_n937# VDD_3V3_1 pfet_06v0 ad=0 pd=0 as=11.664n ps=0.582m w=243 l=100
X67 5v0_add_q_sc_1/inv_nti 5v0_add_q_sc_1/nti VDD_3V3_1 VDD_3V3_1 pfet_06v0 ad=21.472n pd=0.664m as=0 ps=0 w=244 l=100
X68 VSS_3 5v0_add_q_sc_1/nti 5v0_add_q_sc_1/VDD_1V65 VSS_3 nfet_06v0 ad=0 pd=0 as=21.021n ps=0.58m w=147 l=120
X69 5v0_add_q_sc_1/a_n1205_n937# 5v0_add_q_sc_1/inv_pti VDD_3V3_1 VDD_3V3_1 pfet_06v0 ad=0 pd=0 as=0 ps=0 w=243 l=100
X70 5v0_add_q_sc_1/downstepper_test 5v0_add_q_sc_1/pti 5v0_add_q_sc_1/a_n1778_n454# VSS_3 nfet_06v0 ad=0 pd=0 as=7.056n ps=0.39m w=147 l=120
X71 5v0_add_q_sc_1/inv_nti 5v0_add_q_sc_1/nti VSS_3 VSS_3 nfet_06v0 ad=14.432n pd=0.504m as=0 ps=0 w=164 l=120
X72 5v0_add_q_sc_1/a_n1778_n454# 5v0_add_q_sc_1/inv_nti VSS_3 VSS_3 nfet_06v0 ad=0 pd=0 as=0 ps=0 w=147 l=120
X73 VSS_3 5v0_add_q_sc_1/inv_pti VSS_3 VSS_3 nfet_06v0 ad=0 pd=0 as=0 ps=0 w=164 l=120
X74 5v0_add_q_sc_1/VDD_1V65 5v0_add_q_sc_1/inv_pti 5v0_add_q_sc_1/a_n1373_n454# VSS_3 nfet_06v0 ad=0 pd=0 as=0 ps=0 w=147 l=120
X75 5v0_add_q_sc_1/downstepper_test 5v0_add_q_sc_1/inv_nti VDD_3V3_1 VDD_3V3_1 pfet_06v0 ad=0 pd=0 as=0 ps=0 w=243 l=100
X76 5v0_addh_sc_tile_1/ctrl_sign 5v0_addh_sc_tile_1/ctrl_over 5v0_nter2oter_code_sc_1/gf180mcu_fd_sc_mcu7t5v0__nor2_1_0/a_224_472# VDD_3V3_0 pfet_06v0 ad=21.472n pd=0.664m as=32.696n ps=0.756m w=244 l=100
X77 VSS_3 5v0_addh_sc_tile_1/ctrl_over 5v0_addh_sc_tile_1/ctrl_sign VSS_3 nfet_06v0 ad=0 pd=0 as=11.752n ps=0.434m w=113 l=120
X78 5v0_nter2oter_code_sc_1/gf180mcu_fd_sc_mcu7t5v0__nor2_1_0/a_224_472# 5v0_nter2oter_code_sc_1/nti VDD_3V3_0 VDD_3V3_0 pfet_06v0 ad=0 pd=0 as=0 ps=0 w=244 l=100
X79 5v0_addh_sc_tile_1/ctrl_sign 5v0_nter2oter_code_sc_1/nti VSS_3 VSS_3 nfet_06v0 ad=0 pd=0 as=0 ps=0 w=113 l=120
X80 5v0_addh_sc_tile_1/ctrl_over 5v0_nter2oter_code_sc_1/pti VSS_3 VSS_3 nfet_06v0 ad=14.432n pd=0.504m as=0 ps=0 w=164 l=120
X81 5v0_addh_sc_tile_1/ctrl_over 5v0_nter2oter_code_sc_1/pti VDD_3V3_0 VDD_3V3_0 pfet_06v0 ad=21.472n pd=0.664m as=0 ps=0 w=244 l=100
X82 5v0_nter2oter_code_sc_1/pti in_2 VSS_3 VSS_3 nfet_06v0 ad=6.336n pd=0.32m as=0 ps=0 w=72 l=578
X83 VDD_3V3_1 in_2 5v0_nter2oter_code_sc_1/pti VDD_3V3_1 pfet_06v0 ad=0 pd=0 as=52.704n ps=1.408m w=244 l=100
X84 VDD_3V3_1 in_2 5v0_nter2oter_code_sc_1/nti VDD_3V3_1 pfet_06v0 ad=0 pd=0 as=9.696n ps=0.394m w=96 l=150
X85 VSS_3 in_2 5v0_nter2oter_code_sc_1/nti VSS_3 nfet_06v0 ad=0 pd=0 as=12.7n ps=0.454m w=127 l=120
X86 5v0_nter2oter_code_sc_1/pti in_2 VDD_3V3_1 VDD_3V3_1 pfet_06v0 ad=0 pd=0 as=0 ps=0 w=244 l=100
X87 5v0_nter2oter_code_sc_1/pti in_2 VDD_3V3_1 VDD_3V3_1 pfet_06v0 ad=0 pd=0 as=0 ps=0 w=244 l=100
X88 m1_n2844_n810# 5v0_addh_sc_tile_0/carry_0_probe VSS_3 VSS_3 nfet_06v0 ad=14.432n pd=0.504m as=0 ps=0 w=164 l=120
X89 m1_n2844_n810# 5v0_addh_sc_tile_0/carry_0_probe VDD_3V3_1 VDD_3V3_1 pfet_06v0 ad=21.472n pd=0.664m as=0 ps=0 w=244 l=100
X90 5v0_addh_sc_tile_0/pti in_1 VSS_3 VSS_3 nfet_06v0 ad=20.768n pd=0.824m as=0 ps=0 w=72 l=578
X91 VDD_3V3_1 in_1 5v0_addh_sc_tile_0/pti VDD_3V3_1 pfet_06v0 ad=0 pd=0 as=74.176n ps=2.072m w=244 l=100
X92 VDD_3V3_1 in_1 5v0_addh_sc_tile_0/nti VDD_3V3_1 pfet_06v0 ad=0 pd=0 as=9.696n ps=0.394m w=96 l=150
X93 VSS_3 in_1 5v0_addh_sc_tile_0/nti VSS_3 nfet_06v0 ad=0 pd=0 as=12.7n ps=0.454m w=127 l=120
X94 5v0_addh_sc_tile_0/pti in_1 VDD_3V3_1 VDD_3V3_1 pfet_06v0 ad=0 pd=0 as=0 ps=0 w=244 l=100
X95 5v0_addh_sc_tile_0/pti in_1 VDD_3V3_1 VDD_3V3_1 pfet_06v0 ad=0 pd=0 as=0 ps=0 w=244 l=100
X96 5v0_addh_sc_tile_0/5v0_half_adder_selector_sc_0/res_stage0 5v0_addh_sc_tile_0/m1_103_293# 5v0_addh_sc_tile_0/downstepper_test VSS_3 nfet_06v0 ad=31.489n pd=1.041m as=31.631n ps=1.032m w=164 l=120
X97 5v0_addh_sc_tile_0/5v0_half_adder_selector_sc_0/res_stage0 5v0_addh_sc_tile_0/m1_103_293# 5v0_addh_sc_tile_0/upstepper_test VDD_3V3_1 pfet_06v0 ad=46.849n pd=1.361m as=42.856n ps=1.326m w=244 l=100
X98 5v0_addh_sc_tile_0/m1_103_293# in_0_sign VSS_3 VSS_3 nfet_06v0 ad=14.432n pd=0.504m as=0 ps=0 w=164 l=120
X99 5v0_addh_sc_tile_0/m1_103_293# in_0_sign VDD_3V3_1 VDD_3V3_1 pfet_06v0 ad=21.472n pd=0.664m as=0 ps=0 w=244 l=100
X100 5v0_addh_sc_tile_0/5v0_half_adder_selector_sc_0/res_stage0 in_0_sign 5v0_addh_sc_tile_0/upstepper_test VSS_3 nfet_06v0 ad=0 pd=0 as=43.711n ps=1.504m w=164 l=120
X101 5v0_addh_sc_tile_0/5v0_half_adder_selector_sc_0/res_stage0 in_0_sign 5v0_addh_sc_tile_0/downstepper_test VDD_3V3_1 pfet_06v0 ad=0 pd=0 as=42.856n ps=1.326m w=244 l=100
X102 5v0_addh_sc_tile_1/ternary_input 5v0_addh_sc_tile_0/a_382_n1095# 5v0_addh_sc_tile_0/5v0_half_adder_selector_sc_0/res_stage0 VSS_3 nfet_06v0 ad=31.489n pd=1.041m as=0 ps=0 w=164 l=120
X103 5v0_addh_sc_tile_1/ternary_input 5v0_addh_sc_tile_0/a_382_n1095# in_1 VDD_3V3_1 pfet_06v0 ad=46.849n pd=1.361m as=21.472n ps=0.664m w=244 l=100
X104 5v0_addh_sc_tile_0/a_382_n1095# in_0_over VSS_3 VSS_3 nfet_06v0 ad=14.432n pd=0.504m as=0 ps=0 w=164 l=120
X105 5v0_addh_sc_tile_0/a_382_n1095# in_0_over VDD_3V3_1 VDD_3V3_1 pfet_06v0 ad=21.472n pd=0.664m as=0 ps=0 w=244 l=100
X106 5v0_addh_sc_tile_1/ternary_input in_0_over in_1 VSS_3 nfet_06v0 ad=0 pd=0 as=14.432n ps=0.504m w=164 l=120
X107 5v0_addh_sc_tile_1/ternary_input in_0_over 5v0_addh_sc_tile_0/5v0_half_adder_selector_sc_0/res_stage0 VDD_3V3_1 pfet_06v0 ad=0 pd=0 as=0 ps=0 w=244 l=100
X108 5v0_addh_sc_tile_0/inv_pti 5v0_addh_sc_tile_0/pti VSS_3 VSS_3 nfet_06v0 ad=28.864n pd=1.008m as=0 ps=0 w=164 l=120
X109 5v0_addh_sc_tile_0/inv_pti 5v0_addh_sc_tile_0/pti VDD_3V3_1 VDD_3V3_1 pfet_06v0 ad=42.944n pd=1.328m as=0 ps=0 w=244 l=100
X110 5v0_addh_sc_tile_0/carry_0_probe 5v0_addh_sc_tile_0/a_382_n1095# 5v0_addh_sc_tile_0/m1_843_n857# VSS_3 nfet_06v0 ad=14.432n pd=0.504m as=14.432n ps=0.504m w=164 l=120
X111 5v0_addh_sc_tile_0/carry_0_probe in_0_over 5v0_addh_sc_tile_0/m1_843_n857# VDD_3V3_1 pfet_06v0 ad=21.472n pd=0.664m as=21.472n ps=0.664m w=244 l=100
X112 5v0_addh_sc_tile_0/inv_nti in_0_sign 5v0_addh_sc_tile_0/carry_sign_probe VDD_3V3_1 pfet_06v0 ad=21.472n pd=0.664m as=12.688n ps=0.348m w=244 l=100
X113 5v0_addh_sc_tile_0/carry_sign_probe 5v0_addh_sc_tile_0/m1_103_293# 5v0_addh_sc_tile_0/inv_nti VSS_3 nfet_06v0 ad=8.528n pd=0.268m as=14.432n ps=0.504m w=164 l=120
X114 5v0_addh_sc_tile_0/carry_sign_probe 5v0_addh_sc_tile_0/m1_103_293# 5v0_addh_sc_tile_0/inv_pti VDD_3V3_1 pfet_06v0 ad=12.688n pd=0.348m as=21.472n ps=0.664m w=244 l=100
X115 5v0_addh_sc_tile_0/inv_pti in_0_sign 5v0_addh_sc_tile_0/carry_sign_probe VSS_3 nfet_06v0 ad=14.432n pd=0.504m as=8.528n ps=0.268m w=164 l=120
X116 5v0_addh_sc_tile_0/inv_nti in_0_sign 5v0_addh_sc_tile_0/m1_843_n857# VDD_3V3_1 pfet_06v0 ad=64.416n pd=1.992m as=46.848n ps=1.36m w=244 l=100
X117 5v0_addh_sc_tile_0/m1_843_n857# 5v0_addh_sc_tile_0/m1_103_293# 5v0_addh_sc_tile_0/inv_nti VSS_3 nfet_06v0 ad=31.488n pd=1.04m as=43.296n ps=1.512m w=164 l=120
X118 5v0_addh_sc_tile_0/m1_843_n857# 5v0_addh_sc_tile_0/m1_103_293# 5v0_addh_sc_tile_0/pti VDD_3V3_1 pfet_06v0 ad=0 pd=0 as=0 ps=0 w=244 l=100
X119 5v0_addh_sc_tile_0/pti in_0_sign 5v0_addh_sc_tile_0/m1_843_n857# VSS_3 nfet_06v0 ad=0 pd=0 as=0 ps=0 w=164 l=120
X120 5v0_addh_sc_tile_0/a_n1373_n454# 5v0_addh_sc_tile_0/inv_nti 5v0_addh_sc_tile_0/downstepper_test VSS_3 nfet_06v0 ad=3.528n pd=0.195m as=8.599n ps=0.264m w=147 l=120
X121 5v0_addh_sc_tile_0/upstepper_test 5v0_addh_sc_tile_0/nti 5v0_addh_sc_tile_0/a_n1205_n937# VDD_3V3_1 pfet_06v0 ad=21.384n pd=0.662m as=5.832n ps=0.291m w=243 l=100
X122 5v0_addh_sc_tile_0/inv_nti 5v0_addh_sc_tile_0/nti VDD_3V3_1 VDD_3V3_1 pfet_06v0 ad=21.472n pd=0.664m as=21.472n ps=0.664m w=244 l=100
X123 5v0_addh_sc_tile_0/upstepper_test 5v0_addh_sc_tile_0/nti VDD_1V65_0 VSS_3 nfet_06v0 ad=14.847n pd=0.496m as=10.51n ps=0.29m w=147 l=120
X124 5v0_addh_sc_tile_0/carry_0_probe 5v0_addh_sc_tile_0/a_382_n1095# VDD_3V3_1 VDD_3V3_1 pfet_06v0 ad=21.472n pd=0.664m as=21.472n ps=0.664m w=244 l=100
X125 5v0_addh_sc_tile_0/a_n1205_n937# 5v0_addh_sc_tile_0/inv_pti VDD_3V3_1 VDD_3V3_1 pfet_06v0 ad=5.832n pd=0.291m as=21.384n ps=0.662m w=243 l=100
X126 5v0_addh_sc_tile_0/downstepper_test 5v0_addh_sc_tile_0/pti 5v0_addh_sc_tile_0/a_n1778_n454# VSS_3 nfet_06v0 ad=8.599n pd=0.264m as=3.528n ps=0.195m w=147 l=120
X127 5v0_addh_sc_tile_0/inv_nti 5v0_addh_sc_tile_0/nti VSS_3 VSS_3 nfet_06v0 ad=14.432n pd=0.504m as=14.432n ps=0.504m w=164 l=120
X128 5v0_addh_sc_tile_0/a_n1778_n454# 5v0_addh_sc_tile_0/inv_nti VSS_3 VSS_3 nfet_06v0 ad=3.528n pd=0.195m as=14.847n ps=0.496m w=147 l=120
X129 5v0_addh_sc_tile_0/upstepper_test 5v0_addh_sc_tile_0/inv_pti VSS_3 VSS_3 nfet_06v0 ad=14.432n pd=0.504m as=14.432n ps=0.504m w=164 l=120
X130 VDD_1V65_0 5v0_addh_sc_tile_0/inv_pti 5v0_addh_sc_tile_0/a_n1373_n454# VSS_3 nfet_06v0 ad=10.51n pd=0.29m as=3.528n ps=0.195m w=147 l=120
X131 5v0_addh_sc_tile_0/downstepper_test 5v0_addh_sc_tile_0/inv_nti VDD_3V3_1 VDD_3V3_1 pfet_06v0 ad=21.384n pd=0.662m as=21.384n ps=0.662m w=243 l=100
X132 5v0_addh_sc_tile_1/pti 5v0_addh_sc_tile_1/ternary_input VSS_3 VSS_3 nfet_06v0 ad=20.768n pd=0.824m as=0 ps=0 w=72 l=578
X133 VDD_3V3_1 5v0_addh_sc_tile_1/ternary_input 5v0_addh_sc_tile_1/pti VDD_3V3_1 pfet_06v0 ad=0 pd=0 as=74.176n ps=2.072m w=244 l=100
X134 VDD_3V3_1 5v0_addh_sc_tile_1/ternary_input 5v0_addh_sc_tile_1/nti VDD_3V3_1 pfet_06v0 ad=0 pd=0 as=9.696n ps=0.394m w=96 l=150
X135 VSS_3 5v0_addh_sc_tile_1/ternary_input 5v0_addh_sc_tile_1/nti VSS_3 nfet_06v0 ad=0 pd=0 as=12.7n ps=0.454m w=127 l=120
X136 5v0_addh_sc_tile_1/pti 5v0_addh_sc_tile_1/ternary_input VDD_3V3_1 VDD_3V3_1 pfet_06v0 ad=0 pd=0 as=0 ps=0 w=244 l=100
X137 5v0_addh_sc_tile_1/pti 5v0_addh_sc_tile_1/ternary_input VDD_3V3_1 VDD_3V3_1 pfet_06v0 ad=0 pd=0 as=0 ps=0 w=244 l=100
X138 5v0_addh_sc_tile_1/5v0_half_adder_selector_sc_0/res_stage0 5v0_addh_sc_tile_1/m1_103_293# 5v0_addh_sc_tile_1/downstepper_test VSS_3 nfet_06v0 ad=31.489n pd=1.041m as=31.631n ps=1.032m w=164 l=120
X139 5v0_addh_sc_tile_1/5v0_half_adder_selector_sc_0/res_stage0 5v0_addh_sc_tile_1/m1_103_293# 5v0_addh_sc_tile_1/upstepper_test VDD_3V3_1 pfet_06v0 ad=46.849n pd=1.361m as=42.856n ps=1.326m w=244 l=100
X140 5v0_addh_sc_tile_1/m1_103_293# 5v0_addh_sc_tile_1/ctrl_sign VSS_3 VSS_3 nfet_06v0 ad=14.432n pd=0.504m as=0 ps=0 w=164 l=120
X141 5v0_addh_sc_tile_1/m1_103_293# 5v0_addh_sc_tile_1/ctrl_sign VDD_3V3_1 VDD_3V3_1 pfet_06v0 ad=21.472n pd=0.664m as=0 ps=0 w=244 l=100
X142 5v0_addh_sc_tile_1/5v0_half_adder_selector_sc_0/res_stage0 5v0_addh_sc_tile_1/ctrl_sign 5v0_addh_sc_tile_1/upstepper_test VSS_3 nfet_06v0 ad=0 pd=0 as=43.711n ps=1.504m w=164 l=120
X143 5v0_addh_sc_tile_1/5v0_half_adder_selector_sc_0/res_stage0 5v0_addh_sc_tile_1/ctrl_sign 5v0_addh_sc_tile_1/downstepper_test VDD_3V3_1 pfet_06v0 ad=0 pd=0 as=42.856n ps=1.326m w=244 l=100
X144 5v0_nter2oter_code_sc_0/in 5v0_addh_sc_tile_1/a_382_n1095# 5v0_addh_sc_tile_1/5v0_half_adder_selector_sc_0/res_stage0 VSS_3 nfet_06v0 ad=17.057n pd=0.537m as=0 ps=0 w=164 l=120
X145 5v0_nter2oter_code_sc_0/in 5v0_addh_sc_tile_1/a_382_n1095# 5v0_addh_sc_tile_1/ternary_input VDD_3V3_0 pfet_06v0 ad=25.377n pd=0.697m as=0 ps=0 w=244 l=100
X146 5v0_addh_sc_tile_1/a_382_n1095# 5v0_addh_sc_tile_1/ctrl_over VSS_3 VSS_3 nfet_06v0 ad=14.432n pd=0.504m as=0 ps=0 w=164 l=120
X147 5v0_addh_sc_tile_1/a_382_n1095# 5v0_addh_sc_tile_1/ctrl_over VDD_3V3_0 VDD_3V3_0 pfet_06v0 ad=21.472n pd=0.664m as=0 ps=0 w=244 l=100
X148 5v0_nter2oter_code_sc_0/in 5v0_addh_sc_tile_1/ctrl_over 5v0_addh_sc_tile_1/ternary_input VSS_3 nfet_06v0 ad=0 pd=0 as=0 ps=0 w=164 l=120
X149 5v0_nter2oter_code_sc_0/in 5v0_addh_sc_tile_1/ctrl_over 5v0_addh_sc_tile_1/5v0_half_adder_selector_sc_0/res_stage0 VDD_3V3_0 pfet_06v0 ad=0 pd=0 as=0 ps=0 w=244 l=100
X150 5v0_addh_sc_tile_1/inv_pti 5v0_addh_sc_tile_1/pti VSS_3 VSS_3 nfet_06v0 ad=28.864n pd=1.008m as=0 ps=0 w=164 l=120
X151 5v0_addh_sc_tile_1/inv_pti 5v0_addh_sc_tile_1/pti VDD_3V3_1 VDD_3V3_1 pfet_06v0 ad=42.944n pd=1.328m as=0 ps=0 w=244 l=100
X152 5v0_add_q_sc_1/ctrl_over 5v0_addh_sc_tile_1/a_382_n1095# 5v0_addh_sc_tile_1/m1_843_n857# VSS_3 nfet_06v0 ad=14.432n pd=0.504m as=31.488n ps=1.04m w=164 l=120
X153 5v0_add_q_sc_1/ctrl_over 5v0_addh_sc_tile_1/ctrl_over 5v0_addh_sc_tile_1/m1_843_n857# VDD_3V3_0 pfet_06v0 ad=42.944n pd=1.328m as=46.848n ps=1.36m w=244 l=100
X154 5v0_addh_sc_tile_1/inv_nti 5v0_addh_sc_tile_1/ctrl_sign 5v0_add_q_sc_1/ctrl_sign VDD_3V3_1 pfet_06v0 ad=64.416n pd=1.992m as=25.376n ps=0.696m w=244 l=100
X155 5v0_add_q_sc_1/ctrl_sign 5v0_addh_sc_tile_1/m1_103_293# 5v0_addh_sc_tile_1/inv_nti VSS_3 nfet_06v0 ad=17.056n pd=0.536m as=43.296n ps=1.512m w=164 l=120
X156 5v0_add_q_sc_1/ctrl_sign 5v0_addh_sc_tile_1/m1_103_293# 5v0_addh_sc_tile_1/inv_pti VDD_3V3_1 pfet_06v0 ad=0 pd=0 as=0 ps=0 w=244 l=100
X157 5v0_addh_sc_tile_1/inv_pti 5v0_addh_sc_tile_1/ctrl_sign 5v0_add_q_sc_1/ctrl_sign VSS_3 nfet_06v0 ad=0 pd=0 as=0 ps=0 w=164 l=120
X158 5v0_addh_sc_tile_1/inv_nti 5v0_addh_sc_tile_1/ctrl_sign 5v0_addh_sc_tile_1/m1_843_n857# VDD_3V3_0 pfet_06v0 ad=0 pd=0 as=0 ps=0 w=244 l=100
X159 5v0_addh_sc_tile_1/m1_843_n857# 5v0_addh_sc_tile_1/m1_103_293# 5v0_addh_sc_tile_1/inv_nti VSS_3 nfet_06v0 ad=0 pd=0 as=0 ps=0 w=164 l=120
X160 5v0_addh_sc_tile_1/m1_843_n857# 5v0_addh_sc_tile_1/m1_103_293# 5v0_addh_sc_tile_1/pti VDD_3V3_0 pfet_06v0 ad=0 pd=0 as=0 ps=0 w=244 l=100
X161 5v0_addh_sc_tile_1/pti 5v0_addh_sc_tile_1/ctrl_sign 5v0_addh_sc_tile_1/m1_843_n857# VSS_3 nfet_06v0 ad=0 pd=0 as=0 ps=0 w=164 l=120
X162 5v0_addh_sc_tile_1/a_n1373_n454# 5v0_addh_sc_tile_1/inv_nti 5v0_addh_sc_tile_1/downstepper_test VSS_3 nfet_06v0 ad=7.056n pd=0.39m as=0 ps=0 w=147 l=120
X163 5v0_addh_sc_tile_1/upstepper_test 5v0_addh_sc_tile_1/nti 5v0_addh_sc_tile_1/a_n1205_n937# VDD_3V3_0 pfet_06v0 ad=0 pd=0 as=11.664n ps=0.582m w=243 l=100
X164 5v0_addh_sc_tile_1/inv_nti 5v0_addh_sc_tile_1/nti VDD_3V3_0 VDD_3V3_0 pfet_06v0 ad=0 pd=0 as=0 ps=0 w=244 l=100
X165 5v0_addh_sc_tile_1/upstepper_test 5v0_addh_sc_tile_1/nti VDD_1V65_3 VSS_3 nfet_06v0 ad=0 pd=0 as=21.021n ps=0.58m w=147 l=120
X166 5v0_add_q_sc_1/ctrl_over 5v0_addh_sc_tile_1/a_382_n1095# VDD_3V3_0 VDD_3V3_0 pfet_06v0 ad=0 pd=0 as=0 ps=0 w=244 l=100
X167 5v0_addh_sc_tile_1/a_n1205_n937# 5v0_addh_sc_tile_1/inv_pti VDD_3V3_0 VDD_3V3_0 pfet_06v0 ad=0 pd=0 as=0 ps=0 w=243 l=100
X168 5v0_addh_sc_tile_1/downstepper_test 5v0_addh_sc_tile_1/pti 5v0_addh_sc_tile_1/a_n1778_n454# VSS_3 nfet_06v0 ad=0 pd=0 as=7.056n ps=0.39m w=147 l=120
X169 5v0_addh_sc_tile_1/inv_nti 5v0_addh_sc_tile_1/nti VSS_3 VSS_3 nfet_06v0 ad=0 pd=0 as=0 ps=0 w=164 l=120
X170 5v0_addh_sc_tile_1/a_n1778_n454# 5v0_addh_sc_tile_1/inv_nti VSS_3 VSS_3 nfet_06v0 ad=0 pd=0 as=0 ps=0 w=147 l=120
X171 5v0_addh_sc_tile_1/upstepper_test 5v0_addh_sc_tile_1/inv_pti VSS_3 VSS_3 nfet_06v0 ad=0 pd=0 as=0 ps=0 w=164 l=120
X172 VDD_1V65_3 5v0_addh_sc_tile_1/inv_pti 5v0_addh_sc_tile_1/a_n1373_n454# VSS_3 nfet_06v0 ad=0 pd=0 as=0 ps=0 w=147 l=120
X173 5v0_addh_sc_tile_1/downstepper_test 5v0_addh_sc_tile_1/inv_nti VDD_3V3_0 VDD_3V3_0 pfet_06v0 ad=0 pd=0 as=0 ps=0 w=243 l=100
X174 5v0_addh_sc_tile_2/pti in_3 VSS_3 VSS_3 nfet_06v0 ad=20.768n pd=0.824m as=0 ps=0 w=72 l=578
X175 VDD_3V3_0 in_3 5v0_addh_sc_tile_2/pti VDD_3V3_0 pfet_06v0 ad=0 pd=0 as=74.176n ps=2.072m w=244 l=100
X176 VDD_3V3_0 in_3 5v0_addh_sc_tile_2/nti VDD_3V3_0 pfet_06v0 ad=0 pd=0 as=9.696n ps=0.394m w=96 l=150
X177 VSS_3 in_3 5v0_addh_sc_tile_2/nti VSS_3 nfet_06v0 ad=0 pd=0 as=12.7n ps=0.454m w=127 l=120
X178 5v0_addh_sc_tile_2/pti in_3 VDD_3V3_0 VDD_3V3_0 pfet_06v0 ad=0 pd=0 as=0 ps=0 w=244 l=100
X179 5v0_addh_sc_tile_2/pti in_3 VDD_3V3_0 VDD_3V3_0 pfet_06v0 ad=0 pd=0 as=0 ps=0 w=244 l=100
X180 5v0_addh_sc_tile_2/5v0_half_adder_selector_sc_0/res_stage0 5v0_addh_sc_tile_2/m1_103_293# 5v0_addh_sc_tile_2/downstepper_test VSS_3 nfet_06v0 ad=31.489n pd=1.041m as=31.631n ps=1.032m w=164 l=120
X181 5v0_addh_sc_tile_2/5v0_half_adder_selector_sc_0/res_stage0 5v0_addh_sc_tile_2/m1_103_293# 5v0_addh_sc_tile_2/upstepper_test VDD_3V3_0 pfet_06v0 ad=46.849n pd=1.361m as=42.856n ps=1.326m w=244 l=100
X182 5v0_addh_sc_tile_2/m1_103_293# 5v0_addh_sc_tile_2/ctrl_sign VSS_3 VSS_3 nfet_06v0 ad=14.432n pd=0.504m as=0 ps=0 w=164 l=120
X183 5v0_addh_sc_tile_2/m1_103_293# 5v0_addh_sc_tile_2/ctrl_sign VDD_3V3_0 VDD_3V3_0 pfet_06v0 ad=21.472n pd=0.664m as=0 ps=0 w=244 l=100
X184 5v0_addh_sc_tile_2/5v0_half_adder_selector_sc_0/res_stage0 5v0_addh_sc_tile_2/ctrl_sign 5v0_addh_sc_tile_2/upstepper_test VSS_3 nfet_06v0 ad=0 pd=0 as=43.711n ps=1.504m w=164 l=120
X185 5v0_addh_sc_tile_2/5v0_half_adder_selector_sc_0/res_stage0 5v0_addh_sc_tile_2/ctrl_sign 5v0_addh_sc_tile_2/downstepper_test VDD_3V3_0 pfet_06v0 ad=0 pd=0 as=42.856n ps=1.326m w=244 l=100
X186 res_0 5v0_addh_sc_tile_2/a_382_n1095# 5v0_addh_sc_tile_2/5v0_half_adder_selector_sc_0/res_stage0 VSS_3 nfet_06v0 ad=17.057n pd=0.537m as=0 ps=0 w=164 l=120
X187 res_0 5v0_addh_sc_tile_2/a_382_n1095# in_3 VDD_3V3_0 pfet_06v0 ad=25.377n pd=0.697m as=21.472n ps=0.664m w=244 l=100
X188 5v0_addh_sc_tile_2/a_382_n1095# 5v0_addh_sc_tile_2/ctrl_over VSS_3 VSS_3 nfet_06v0 ad=14.432n pd=0.504m as=0 ps=0 w=164 l=120
X189 5v0_addh_sc_tile_2/a_382_n1095# 5v0_addh_sc_tile_2/ctrl_over VDD_3V3_0 VDD_3V3_0 pfet_06v0 ad=21.472n pd=0.664m as=0 ps=0 w=244 l=100
X190 res_0 5v0_addh_sc_tile_2/ctrl_over in_3 VSS_3 nfet_06v0 ad=0 pd=0 as=14.432n ps=0.504m w=164 l=120
X191 res_0 5v0_addh_sc_tile_2/ctrl_over 5v0_addh_sc_tile_2/5v0_half_adder_selector_sc_0/res_stage0 VDD_3V3_0 pfet_06v0 ad=0 pd=0 as=0 ps=0 w=244 l=100
X192 5v0_addh_sc_tile_2/inv_pti 5v0_addh_sc_tile_2/pti VSS_3 VSS_3 nfet_06v0 ad=28.864n pd=1.008m as=0 ps=0 w=164 l=120
X193 5v0_addh_sc_tile_2/inv_pti 5v0_addh_sc_tile_2/pti VDD_3V3_0 VDD_3V3_0 pfet_06v0 ad=42.944n pd=1.328m as=0 ps=0 w=244 l=100
X194 5v0_add_q_sc_0/ctrl_over 5v0_addh_sc_tile_2/a_382_n1095# 5v0_addh_sc_tile_2/m1_843_n857# VSS_3 nfet_06v0 ad=14.432n pd=0.504m as=31.488n ps=1.04m w=164 l=120
X195 5v0_add_q_sc_0/ctrl_over 5v0_addh_sc_tile_2/ctrl_over 5v0_addh_sc_tile_2/m1_843_n857# VDD_3V3_0 pfet_06v0 ad=42.944n pd=1.328m as=46.848n ps=1.36m w=244 l=100
X196 5v0_addh_sc_tile_2/inv_nti 5v0_addh_sc_tile_2/ctrl_sign 5v0_add_q_sc_0/ctrl_sign VDD_3V3_0 pfet_06v0 ad=64.416n pd=1.992m as=25.376n ps=0.696m w=244 l=100
X197 5v0_add_q_sc_0/ctrl_sign 5v0_addh_sc_tile_2/m1_103_293# 5v0_addh_sc_tile_2/inv_nti VSS_3 nfet_06v0 ad=17.056n pd=0.536m as=43.296n ps=1.512m w=164 l=120
X198 5v0_add_q_sc_0/ctrl_sign 5v0_addh_sc_tile_2/m1_103_293# 5v0_addh_sc_tile_2/inv_pti VDD_3V3_0 pfet_06v0 ad=0 pd=0 as=0 ps=0 w=244 l=100
X199 5v0_addh_sc_tile_2/inv_pti 5v0_addh_sc_tile_2/ctrl_sign 5v0_add_q_sc_0/ctrl_sign VSS_3 nfet_06v0 ad=0 pd=0 as=0 ps=0 w=164 l=120
X200 5v0_addh_sc_tile_2/inv_nti 5v0_addh_sc_tile_2/ctrl_sign 5v0_addh_sc_tile_2/m1_843_n857# VDD_3V3_0 pfet_06v0 ad=0 pd=0 as=0 ps=0 w=244 l=100
X201 5v0_addh_sc_tile_2/m1_843_n857# 5v0_addh_sc_tile_2/m1_103_293# 5v0_addh_sc_tile_2/inv_nti VSS_3 nfet_06v0 ad=0 pd=0 as=0 ps=0 w=164 l=120
X202 5v0_addh_sc_tile_2/m1_843_n857# 5v0_addh_sc_tile_2/m1_103_293# 5v0_addh_sc_tile_2/pti VDD_3V3_0 pfet_06v0 ad=0 pd=0 as=0 ps=0 w=244 l=100
X203 5v0_addh_sc_tile_2/pti 5v0_addh_sc_tile_2/ctrl_sign 5v0_addh_sc_tile_2/m1_843_n857# VSS_3 nfet_06v0 ad=0 pd=0 as=0 ps=0 w=164 l=120
X204 5v0_addh_sc_tile_2/a_n1373_n454# 5v0_addh_sc_tile_2/inv_nti 5v0_addh_sc_tile_2/downstepper_test VSS_3 nfet_06v0 ad=7.056n pd=0.39m as=0 ps=0 w=147 l=120
X205 5v0_addh_sc_tile_2/upstepper_test 5v0_addh_sc_tile_2/nti 5v0_addh_sc_tile_2/a_n1205_n937# VDD_3V3_0 pfet_06v0 ad=0 pd=0 as=11.664n ps=0.582m w=243 l=100
X206 5v0_addh_sc_tile_2/inv_nti 5v0_addh_sc_tile_2/nti VDD_3V3_0 VDD_3V3_0 pfet_06v0 ad=0 pd=0 as=0 ps=0 w=244 l=100
X207 5v0_addh_sc_tile_2/upstepper_test 5v0_addh_sc_tile_2/nti VDD_1V65_4 VSS_3 nfet_06v0 ad=0 pd=0 as=21.021n ps=0.58m w=147 l=120
X208 5v0_add_q_sc_0/ctrl_over 5v0_addh_sc_tile_2/a_382_n1095# VDD_3V3_0 VDD_3V3_0 pfet_06v0 ad=0 pd=0 as=0 ps=0 w=244 l=100
X209 5v0_addh_sc_tile_2/a_n1205_n937# 5v0_addh_sc_tile_2/inv_pti VDD_3V3_0 VDD_3V3_0 pfet_06v0 ad=0 pd=0 as=0 ps=0 w=243 l=100
X210 5v0_addh_sc_tile_2/downstepper_test 5v0_addh_sc_tile_2/pti 5v0_addh_sc_tile_2/a_n1778_n454# VSS_3 nfet_06v0 ad=0 pd=0 as=7.056n ps=0.39m w=147 l=120
X211 5v0_addh_sc_tile_2/inv_nti 5v0_addh_sc_tile_2/nti VSS_3 VSS_3 nfet_06v0 ad=0 pd=0 as=0 ps=0 w=164 l=120
X212 5v0_addh_sc_tile_2/a_n1778_n454# 5v0_addh_sc_tile_2/inv_nti VSS_3 VSS_3 nfet_06v0 ad=0 pd=0 as=0 ps=0 w=147 l=120
X213 5v0_addh_sc_tile_2/upstepper_test 5v0_addh_sc_tile_2/inv_pti VSS_3 VSS_3 nfet_06v0 ad=0 pd=0 as=0 ps=0 w=164 l=120
X214 VDD_1V65_4 5v0_addh_sc_tile_2/inv_pti 5v0_addh_sc_tile_2/a_n1373_n454# VSS_3 nfet_06v0 ad=0 pd=0 as=0 ps=0 w=147 l=120
X215 5v0_addh_sc_tile_2/downstepper_test 5v0_addh_sc_tile_2/inv_nti VDD_3V3_0 VDD_3V3_0 pfet_06v0 ad=0 pd=0 as=0 ps=0 w=243 l=100
C0 5v0_add_q_sc_0/5v0_half_adder_selector_sc_0/m1_n244_n517# 5v0_add_q_sc_0/ctrl_sign 0
C1 5v0_addh_sc_tile_2/a_n1778_n454# 5v0_addh_sc_tile_2/downstepper_test 0.0031f
C2 5v0_addh_sc_tile_0/inv_pti 5v0_addh_sc_tile_0/m1_103_293# 0.17653f
C3 5v0_nter2oter_code_sc_0/in 5v0_add_q_sc_0/ctrl_sign 0.01026f
C4 5v0_addh_sc_tile_2/pti 5v0_addh_sc_tile_2/m1_103_293# 0.10002f
C5 5v0_addh_sc_tile_1/5v0_half_adder_selector_sc_0/res_stage0 5v0_add_q_sc_1/ctrl_over 0
C6 5v0_add_q_sc_1/downstepper_test VDD_3V3_1 0.52531f
C7 5v0_addh_sc_tile_1/a_n1373_n454# VDD_3V3_0 0.00122f
C8 5v0_nter2oter_code_sc_1/nti 5v0_addh_sc_tile_2/inv_pti 0
C9 5v0_add_q_sc_0/ctrl_over 5v0_addh_sc_tile_2/m1_103_293# 0.01398f
C10 5v0_add_q_sc_0/ctrl_sign 5v0_add_q_sc_0/downstepper_test 0.14564f
C11 5v0_addh_sc_tile_0/nti VDD_3V3_0 0
C12 5v0_add_q_sc_0/a_n1373_n454# 5v0_add_q_sc_0/downstepper_test 0.00442f
C13 5v0_nter2oter_code_sc_1/nti 5v0_addh_sc_tile_2/upstepper_test 0
C14 5v0_addh_sc_tile_2/inv_nti 5v0_addh_sc_tile_1/downstepper_test 0.00392f
C15 5v0_add_q_sc_1/ctrl_over 5v0_addh_sc_tile_1/downstepper_test 0
C16 5v0_addh_sc_tile_1/5v0_half_adder_selector_sc_0/5v0_tgate_sel_2_sc_1/input_A 5v0_addh_sc_tile_1/upstepper_test 0
C17 5v0_add_q_sc_1/inv_nti 5v0_add_q_sc_1/ctrl_over 0.00311f
C18 res_0 in_3 0.16326f
C19 res_0 5v0_addh_sc_tile_2/nti 0
C20 5v0_addh_sc_tile_1/5v0_half_adder_selector_sc_0/res_stage0 5v0_addh_sc_tile_1/inv_pti 0.01365f
C21 in_0_over 5v0_addh_sc_tile_0/m1_103_293# 0.02633f
C22 5v0_add_q_sc_0/inv_nti 5v0_add_q_sc_0/pti 0.11055f
C23 5v0_addh_sc_tile_2/ctrl_sign 5v0_addh_sc_tile_1/upstepper_test 0
C24 5v0_nter2oter_code_sc_0/in 5v0_addh_sc_tile_2/inv_pti 0.00498f
C25 5v0_addh_sc_tile_1/5v0_half_adder_selector_sc_0/res_stage0 5v0_addh_sc_tile_1/ctrl_over 0.11033f
C26 5v0_add_q_sc_1/a_n1205_n937# 5v0_add_q_sc_1/VDD_1V65 0.00354f
C27 5v0_nter2oter_code_sc_1/nti 5v0_addh_sc_tile_0/inv_nti 0.00216f
C28 5v0_add_q_sc_1/ctrl_sign VDD_3V3_1 1.0828f
C29 5v0_addh_sc_tile_2/inv_nti 5v0_addh_sc_tile_1/inv_nti 0
C30 VDD_3V3_1 5v0_addh_sc_tile_1/m1_843_n857# 0.00388f
C31 5v0_addh_sc_tile_1/inv_nti 5v0_add_q_sc_1/ctrl_over 0.03482f
C32 5v0_nter2oter_code_sc_1/pti 5v0_addh_sc_tile_2/downstepper_test 0
C33 5v0_addh_sc_tile_1/ternary_input 5v0_addh_sc_tile_2/ctrl_sign 0
C34 VDD_1V65_4 VDD_3V3_0 0.0468f
C35 5v0_addh_sc_tile_2/m1_843_n857# VDD_3V3_0 0.17677f
C36 5v0_addh_sc_tile_1/downstepper_test 5v0_addh_sc_tile_1/inv_pti 0.1369f
C37 5v0_addh_sc_tile_0/nti 5v0_addh_sc_tile_0/a_n1205_n937# 0
C38 5v0_addh_sc_tile_2/inv_nti 5v0_add_q_sc_0/5v0_half_adder_selector_sc_0/m1_n239_179# 0
C39 5v0_add_q_sc_1/inv_nti 5v0_addh_sc_tile_1/inv_pti 0.00455f
C40 5v0_addh_sc_tile_1/ctrl_over 5v0_addh_sc_tile_1/downstepper_test 0.16011f
C41 in_1 5v0_addh_sc_tile_0/m1_103_293# 0
C42 5v0_add_q_sc_1/inv_pti 5v0_add_q_sc_1/ctrl_over 0.0024f
C43 5v0_nter2oter_code_sc_0/in 5v0_addh_sc_tile_0/inv_nti 0.00631f
C44 5v0_addh_sc_tile_1/m1_103_293# 5v0_add_q_sc_0/downstepper_test 0
C45 5v0_addh_sc_tile_2/m1_103_293# VDD_3V3_0 0.75958f
C46 5v0_add_q_sc_0/inv_pti 5v0_add_q_sc_0/pti 0.19726f
C47 5v0_add_q_sc_0/ternary_input 5v0_addh_sc_tile_2/m1_843_n857# 0
C48 5v0_add_q_sc_0/inv_pti 5v0_addh_sc_tile_1/m1_843_n857# 0
C49 5v0_addh_sc_tile_2/ctrl_sign 5v0_addh_sc_tile_2/5v0_half_adder_selector_sc_0/res_stage0 0.25152f
C50 5v0_addh_sc_tile_1/inv_nti 5v0_addh_sc_tile_1/inv_pti 0.26136f
C51 5v0_add_q_sc_0/a_n1205_n937# 5v0_add_q_sc_0/downstepper_test 0.00453f
C52 5v0_addh_sc_tile_1/ctrl_over 5v0_addh_sc_tile_1/inv_nti 0.46832f
C53 5v0_addh_sc_tile_2/ctrl_over 5v0_addh_sc_tile_2/downstepper_test 0.02378f
C54 5v0_add_q_sc_0/5v0_half_adder_selector_sc_0/m1_n239_179# 5v0_add_q_sc_0/5v0_half_adder_selector_sc_0/res_stage0 0.18379f
C55 5v0_addh_sc_tile_1/ternary_input 5v0_addh_sc_tile_0/m1_103_293# 0
C56 5v0_add_q_sc_0/5v0_half_adder_selector_sc_0/m1_n239_179# 5v0_addh_sc_tile_1/ctrl_over 0.00107f
C57 5v0_addh_sc_tile_0/nti 5v0_addh_sc_tile_0/a_n1373_n454# 0
C58 5v0_addh_sc_tile_0/downstepper_test 5v0_addh_sc_tile_0/pti 0.20149f
C59 5v0_nter2oter_code_sc_0/pti 5v0_addh_sc_tile_0/inv_nti 0.00589f
C60 5v0_addh_sc_tile_0/carry_sign_probe 5v0_addh_sc_tile_0/a_382_n1095# 0.02324f
C61 VDD_1V65_0 5v0_addh_sc_tile_0/pti 0.00234f
C62 5v0_addh_sc_tile_0/5v0_half_adder_selector_sc_0/res_stage0 5v0_addh_sc_tile_0/a_n1205_n937# 0
C63 5v0_add_q_sc_1/inv_nti 5v0_add_q_sc_1/ternary_input 0.02537f
C64 5v0_addh_sc_tile_1/ctrl_sign 5v0_nter2oter_code_sc_1/pti 0.05404f
C65 5v0_addh_sc_tile_0/pti 5v0_addh_sc_tile_1/inv_pti 0.00107f
C66 5v0_addh_sc_tile_1/ctrl_sign 5v0_addh_sc_tile_1/a_382_n1095# 0.07412f
C67 5v0_addh_sc_tile_1/inv_nti 5v0_add_q_sc_1/ternary_input 0
C68 5v0_nter2oter_code_sc_1/pti 5v0_addh_sc_tile_0/inv_pti 0
C69 5v0_nter2oter_code_sc_1/pti 5v0_addh_sc_tile_2/ctrl_over 0
C70 5v0_nter2oter_code_sc_0/nti VDD_3V3_1 0.09208f
C71 5v0_addh_sc_tile_1/5v0_half_adder_selector_sc_0/res_stage0 5v0_addh_sc_tile_1/nti 0.00372f
C72 5v0_add_q_sc_1/inv_pti 5v0_add_q_sc_1/ternary_input 0.08427f
C73 5v0_addh_sc_tile_1/5v0_half_adder_selector_sc_0/res_stage0 5v0_addh_sc_tile_0/carry_0_probe 0.00121f
C74 5v0_add_q_sc_1/ternary_input 5v0_addh_sc_tile_0/pti 0.00103f
C75 5v0_add_q_sc_1/ctrl_sign 5v0_addh_sc_tile_0/a_382_n1095# 0
C76 5v0_addh_sc_tile_1/ctrl_sign in_0_over 0.03467f
C77 5v0_addh_sc_tile_1/nti 5v0_addh_sc_tile_1/downstepper_test 0.06935f
C78 5v0_add_q_sc_0/pti 5v0_add_q_sc_0/ctrl_over 0
C79 5v0_addh_sc_tile_2/ctrl_sign VDD_1V65_4 0
C80 5v0_addh_sc_tile_1/downstepper_test 5v0_addh_sc_tile_0/carry_0_probe 0.01317f
C81 5v0_addh_sc_tile_2/ctrl_sign 5v0_addh_sc_tile_2/m1_843_n857# 0.24363f
C82 5v0_add_q_sc_1/inv_nti 5v0_add_q_sc_1/VDD_1V65 0.01114f
C83 5v0_add_q_sc_0/pti 5v0_add_q_sc_0/nti 0.1782f
C84 5v0_add_q_sc_1/inv_nti 5v0_addh_sc_tile_0/carry_0_probe 0.00204f
C85 5v0_addh_sc_tile_0/inv_pti in_0_over 0
C86 5v0_addh_sc_tile_1/m1_843_n857# 5v0_add_q_sc_0/nti 0
C87 5v0_addh_sc_tile_2/pti in_3 0.66373f
C88 5v0_nter2oter_code_sc_1/nti VDD_3V3_1 0.0701f
C89 5v0_addh_sc_tile_1/5v0_half_adder_selector_sc_0/res_stage0 5v0_addh_sc_tile_2/a_382_n1095# 0
C90 5v0_addh_sc_tile_1/a_n1205_n937# VDD_3V3_0 0.00891f
C91 5v0_addh_sc_tile_2/inv_nti 5v0_add_q_sc_0/5v0_half_adder_selector_sc_0/res_stage0 0
C92 5v0_addh_sc_tile_2/pti 5v0_addh_sc_tile_2/nti 0.24563f
C93 5v0_add_q_sc_0/ctrl_over in_3 0.00136f
C94 5v0_addh_sc_tile_1/nti 5v0_addh_sc_tile_1/inv_nti 0.22702f
C95 5v0_addh_sc_tile_2/ctrl_sign 5v0_addh_sc_tile_2/m1_103_293# 0.61512f
C96 5v0_addh_sc_tile_2/5v0_half_adder_selector_sc_0/res_stage0 5v0_addh_sc_tile_2/downstepper_test 0.24494f
C97 5v0_addh_sc_tile_2/inv_nti 5v0_addh_sc_tile_1/inv_pti 0
C98 5v0_addh_sc_tile_0/a_n1205_n937# 5v0_addh_sc_tile_0/upstepper_test 0.00334f
C99 5v0_add_q_sc_1/ctrl_over 5v0_addh_sc_tile_1/inv_pti 0.01474f
C100 5v0_addh_sc_tile_1/ctrl_sign in_1 0.01394f
C101 5v0_add_q_sc_0/ctrl_over 5v0_addh_sc_tile_2/nti 0
C102 5v0_addh_sc_tile_2/inv_nti 5v0_addh_sc_tile_1/ctrl_over 0
C103 5v0_addh_sc_tile_1/inv_nti 5v0_addh_sc_tile_0/carry_0_probe 0
C104 5v0_addh_sc_tile_1/ctrl_over 5v0_add_q_sc_1/ctrl_over 0.12383f
C105 5v0_add_q_sc_1/5v0_half_adder_selector_sc_0/m1_n239_179# 5v0_add_q_sc_1/5v0_half_adder_selector_sc_0/res_stage0 0.18379f
C106 5v0_addh_sc_tile_1/ctrl_sign 5v0_addh_sc_tile_1/upstepper_test 0.10431f
C107 5v0_addh_sc_tile_2/a_382_n1095# 5v0_addh_sc_tile_1/downstepper_test 0.0018f
C108 VDD_1V65_0 5v0_addh_sc_tile_0/downstepper_test 0.13024f
C109 in_1 5v0_addh_sc_tile_0/inv_pti 0.05631f
C110 5v0_add_q_sc_1/a_n1373_n454# 5v0_add_q_sc_1/nti 0
C111 5v0_add_q_sc_1/downstepper_test 5v0_add_q_sc_0/ternary_input 0.00477f
C112 VDD_3V3_1 5v0_nter2oter_code_sc_0/in 0.92139f
C113 5v0_add_q_sc_1/inv_pti 5v0_add_q_sc_1/VDD_1V65 0.14775f
C114 5v0_addh_sc_tile_1/ctrl_over 5v0_addh_sc_tile_0/downstepper_test 0.00265f
C115 5v0_add_q_sc_0/inv_nti 5v0_add_q_sc_0/downstepper_test 0.1819f
C116 5v0_addh_sc_tile_1/downstepper_test m1_n2844_n810# 0
C117 5v0_addh_sc_tile_0/5v0_half_adder_selector_sc_0/res_stage0 5v0_addh_sc_tile_0/m1_103_293# 0.18549f
C118 5v0_addh_sc_tile_1/nti 5v0_addh_sc_tile_0/pti 0
C119 5v0_addh_sc_tile_1/ternary_input 5v0_nter2oter_code_sc_1/pti 0
C120 5v0_addh_sc_tile_1/ctrl_over VDD_1V65_0 0
C121 5v0_add_q_sc_1/inv_nti m1_n2844_n810# 0.00427f
C122 5v0_addh_sc_tile_1/ctrl_over 5v0_add_q_sc_0/5v0_half_adder_selector_sc_0/res_stage0 0
C123 5v0_addh_sc_tile_1/ctrl_sign 5v0_addh_sc_tile_1/ternary_input 0.17571f
C124 5v0_addh_sc_tile_1/5v0_half_adder_selector_sc_0/res_stage0 5v0_addh_sc_tile_1/pti 0.01078f
C125 5v0_add_q_sc_1/pti 5v0_add_q_sc_1/a_n1778_n454# 0.00135f
C126 5v0_addh_sc_tile_1/ctrl_over 5v0_addh_sc_tile_1/inv_pti 0.0052f
C127 5v0_add_q_sc_0/pti VDD_3V3_0 0.57843f
C128 5v0_addh_sc_tile_0/pti 5v0_addh_sc_tile_0/carry_0_probe 0.14486f
C129 5v0_addh_sc_tile_1/ternary_input 5v0_addh_sc_tile_1/a_382_n1095# 0.09307f
C130 5v0_addh_sc_tile_0/a_n1373_n454# 5v0_addh_sc_tile_0/upstepper_test 0
C131 5v0_add_q_sc_0/5v0_half_adder_selector_sc_0/m1_n244_n517# res_c 0.16119f
C132 5v0_addh_sc_tile_2/ctrl_over 5v0_addh_sc_tile_1/upstepper_test 0
C133 5v0_addh_sc_tile_1/m1_843_n857# VDD_3V3_0 0.20528f
C134 5v0_add_q_sc_1/ternary_input 5v0_add_q_sc_1/ctrl_over 0.24448f
C135 in_1 in_0_over 0.13684f
C136 VDD_3V3_1 5v0_nter2oter_code_sc_0/pti 0.29053f
C137 5v0_addh_sc_tile_2/a_n1373_n454# VDD_1V65_4 0.00232f
C138 5v0_addh_sc_tile_1/pti 5v0_addh_sc_tile_1/downstepper_test 0.19626f
C139 5v0_add_q_sc_0/ternary_input 5v0_add_q_sc_0/pti 0.6113f
C140 res_c 5v0_add_q_sc_0/downstepper_test 0.00302f
C141 5v0_add_q_sc_1/inv_nti 5v0_addh_sc_tile_1/pti 0.00257f
C142 in_3 VDD_3V3_0 1.10285f
C143 5v0_add_q_sc_1/ctrl_sign 5v0_add_q_sc_0/ternary_input 0.00413f
C144 5v0_addh_sc_tile_1/m1_843_n857# 5v0_add_q_sc_0/ternary_input 0.00836f
C145 5v0_addh_sc_tile_1/ternary_input 5v0_addh_sc_tile_2/ctrl_over 0.00181f
C146 5v0_nter2oter_code_sc_1/nti 5v0_nter2oter_code_sc_1/gf180mcu_fd_sc_mcu7t5v0__nor2_1_0/a_224_472# 0.00898f
C147 5v0_add_q_sc_0/inv_pti 5v0_add_q_sc_0/downstepper_test 0.07797f
C148 5v0_addh_sc_tile_1/upstepper_test in_0_over 0.01202f
C149 5v0_add_q_sc_1/pti 5v0_addh_sc_tile_0/carry_sign_probe 0
C150 5v0_addh_sc_tile_2/nti VDD_3V3_0 0.7527f
C151 5v0_addh_sc_tile_1/inv_nti 5v0_addh_sc_tile_1/pti 0.42143f
C152 5v0_addh_sc_tile_1/5v0_half_adder_selector_sc_0/res_stage0 5v0_add_q_sc_0/ctrl_sign 0
C153 5v0_add_q_sc_1/downstepper_test 5v0_add_q_sc_1/pti 0.08084f
C154 5v0_add_q_sc_1/downstepper_test 5v0_add_q_sc_1/5v0_half_adder_selector_sc_0/res_stage0 0.25483f
C155 5v0_add_q_sc_1/ternary_input 5v0_addh_sc_tile_1/inv_pti 0.00686f
C156 5v0_addh_sc_tile_1/ternary_input in_0_over 0.21152f
C157 5v0_add_q_sc_1/nti 5v0_add_q_sc_1/a_n1205_n937# 0
C158 5v0_addh_sc_tile_0/pti m1_n2844_n810# 0.00645f
C159 5v0_addh_sc_tile_2/ctrl_over 5v0_addh_sc_tile_2/5v0_half_adder_selector_sc_0/res_stage0 0.09179f
C160 5v0_nter2oter_code_sc_1/gf180mcu_fd_sc_mcu7t5v0__nor2_1_0/a_224_472# 5v0_nter2oter_code_sc_0/in 0
C161 VDD_1V65_4 5v0_addh_sc_tile_2/downstepper_test 0.13024f
C162 5v0_add_q_sc_0/5v0_half_adder_selector_sc_0/m1_n239_179# 5v0_addh_sc_tile_1/pti 0
C163 5v0_addh_sc_tile_2/a_n1778_n454# VDD_1V65_4 0
C164 5v0_addh_sc_tile_1/inv_nti 5v0_add_q_sc_0/upstepper_test 0.00109f
C165 5v0_addh_sc_tile_1/downstepper_test 5v0_add_q_sc_0/ctrl_sign 0.00426f
C166 5v0_nter2oter_code_sc_1/pti 5v0_addh_sc_tile_0/nti 0
C167 5v0_addh_sc_tile_2/downstepper_test 5v0_addh_sc_tile_2/m1_103_293# 0.0934f
C168 5v0_addh_sc_tile_2/inv_nti 5v0_addh_sc_tile_1/nti 0
C169 5v0_nter2oter_code_sc_1/nti 5v0_addh_sc_tile_2/pti 0
C170 5v0_addh_sc_tile_1/ctrl_sign 5v0_addh_sc_tile_0/nti 0
C171 5v0_addh_sc_tile_1/nti 5v0_add_q_sc_1/ctrl_over 0
C172 5v0_addh_sc_tile_1/ternary_input in_1 0.18462f
C173 5v0_add_q_sc_0/5v0_half_adder_selector_sc_0/m1_n239_179# 5v0_add_q_sc_0/upstepper_test 0.07502f
C174 5v0_addh_sc_tile_1/pti 5v0_addh_sc_tile_0/pti 0
C175 5v0_addh_sc_tile_0/m1_103_293# 5v0_addh_sc_tile_0/upstepper_test 0.07773f
C176 in_2 5v0_addh_sc_tile_0/pti 0
C177 VDD_3V3_1 5v0_add_q_sc_1/a_n1373_n454# 0.00122f
C178 5v0_add_q_sc_1/ctrl_over 5v0_add_q_sc_1/VDD_1V65 0.04751f
C179 5v0_add_q_sc_1/ctrl_over 5v0_addh_sc_tile_0/carry_0_probe 0
C180 5v0_add_q_sc_1/ctrl_sign 5v0_add_q_sc_1/5v0_half_adder_selector_sc_0/res_stage0 0.22434f
C181 5v0_addh_sc_tile_1/ternary_input 5v0_addh_sc_tile_1/upstepper_test 0.01604f
C182 5v0_add_q_sc_1/ctrl_sign 5v0_add_q_sc_1/pti 0.15254f
C183 5v0_addh_sc_tile_0/inv_pti 5v0_addh_sc_tile_0/nti 0.24025f
C184 5v0_add_q_sc_0/pti VDD_1V65_5 0.00115f
C185 5v0_addh_sc_tile_1/inv_nti 5v0_add_q_sc_0/ctrl_sign 0
C186 5v0_addh_sc_tile_2/pti 5v0_add_q_sc_0/5v0_half_adder_selector_sc_0/m1_n244_n517# 0
C187 5v0_add_q_sc_0/a_n1778_n454# 5v0_add_q_sc_0/upstepper_test 0
C188 5v0_addh_sc_tile_2/pti 5v0_nter2oter_code_sc_0/in 0.00286f
C189 5v0_nter2oter_code_sc_0/nti VDD_3V3_0 0.31492f
C190 5v0_add_q_sc_0/5v0_half_adder_selector_sc_0/m1_n239_179# 5v0_add_q_sc_0/ctrl_sign 0.307f
C191 5v0_addh_sc_tile_1/downstepper_test 5v0_addh_sc_tile_2/inv_pti 0.01675f
C192 5v0_addh_sc_tile_1/5v0_half_adder_selector_sc_0/res_stage0 5v0_addh_sc_tile_1/m1_103_293# 0.18549f
C193 5v0_addh_sc_tile_0/carry_sign_probe 5v0_addh_sc_tile_0/m1_103_293# 0.21008f
C194 5v0_add_q_sc_0/5v0_half_adder_selector_sc_0/m1_n244_n517# 5v0_add_q_sc_0/ctrl_over 0.35346f
C195 5v0_addh_sc_tile_1/nti 5v0_addh_sc_tile_1/inv_pti 0.23171f
C196 5v0_addh_sc_tile_0/5v0_half_adder_selector_sc_0/5v0_tgate_sel_2_sc_1/input_A in_0_over 0.04656f
C197 5v0_addh_sc_tile_1/ctrl_over 5v0_addh_sc_tile_1/nti 0.07635f
C198 5v0_addh_sc_tile_2/pti 5v0_add_q_sc_0/downstepper_test 0
C199 5v0_addh_sc_tile_2/inv_nti 5v0_addh_sc_tile_2/a_382_n1095# 0.28654f
C200 5v0_add_q_sc_0/5v0_half_adder_selector_sc_0/m1_n244_n517# 5v0_add_q_sc_0/nti 0
C201 5v0_addh_sc_tile_1/inv_pti 5v0_addh_sc_tile_0/carry_0_probe 0.01474f
C202 5v0_addh_sc_tile_1/ctrl_over 5v0_addh_sc_tile_0/carry_0_probe 0
C203 5v0_add_q_sc_0/ctrl_over 5v0_add_q_sc_0/downstepper_test 0.02328f
C204 5v0_addh_sc_tile_1/ctrl_sign 5v0_addh_sc_tile_0/5v0_half_adder_selector_sc_0/res_stage0 0.00758f
C205 5v0_addh_sc_tile_0/nti in_0_over 0.00162f
C206 5v0_addh_sc_tile_1/inv_nti 5v0_addh_sc_tile_2/inv_pti 0
C207 5v0_addh_sc_tile_1/downstepper_test 5v0_addh_sc_tile_1/m1_103_293# 0.10533f
C208 5v0_addh_sc_tile_1/ternary_input 5v0_addh_sc_tile_2/5v0_half_adder_selector_sc_0/res_stage0 0
C209 in_0_sign 5v0_addh_sc_tile_0/pti 0.27027f
C210 5v0_add_q_sc_0/downstepper_test 5v0_add_q_sc_0/nti 0.07205f
C211 5v0_add_q_sc_1/inv_nti 5v0_addh_sc_tile_1/m1_103_293# 0.00334f
C212 5v0_addh_sc_tile_2/pti 5v0_nter2oter_code_sc_0/pti 0
C213 5v0_addh_sc_tile_0/5v0_half_adder_selector_sc_0/res_stage0 5v0_addh_sc_tile_0/inv_pti 0.01365f
C214 5v0_add_q_sc_1/inv_nti 5v0_addh_sc_tile_0/inv_nti 0
C215 5v0_addh_sc_tile_2/ctrl_sign in_3 0.0062f
C216 5v0_add_q_sc_0/5v0_half_adder_selector_sc_0/m1_n239_179# 5v0_addh_sc_tile_2/inv_pti 0.00128f
C217 VDD_1V65_3 5v0_addh_sc_tile_1/downstepper_test 0.13024f
C218 5v0_add_q_sc_1/5v0_half_adder_selector_sc_0/m1_n244_n517# 5v0_add_q_sc_1/5v0_half_adder_selector_sc_0/m1_n239_179# 0.00585f
C219 5v0_addh_sc_tile_2/a_382_n1095# 5v0_add_q_sc_0/5v0_half_adder_selector_sc_0/res_stage0 0.0013f
C220 VDD_3V3_1 5v0_add_q_sc_1/a_n1205_n937# 0.00891f
C221 5v0_addh_sc_tile_2/ctrl_over VDD_1V65_4 0.00145f
C222 5v0_addh_sc_tile_2/ctrl_sign 5v0_addh_sc_tile_2/nti 0.01914f
C223 5v0_addh_sc_tile_2/ctrl_over 5v0_addh_sc_tile_2/m1_843_n857# 0.10619f
C224 5v0_nter2oter_code_sc_1/nti VDD_3V3_0 0.31259f
C225 5v0_addh_sc_tile_0/downstepper_test m1_n2844_n810# 0
C226 5v0_addh_sc_tile_2/a_382_n1095# 5v0_addh_sc_tile_1/inv_pti 0
C227 5v0_addh_sc_tile_1/inv_nti 5v0_addh_sc_tile_1/m1_103_293# 0.35313f
C228 5v0_addh_sc_tile_1/ctrl_over 5v0_addh_sc_tile_2/a_382_n1095# 0
C229 in_1 5v0_addh_sc_tile_0/nti 0.52138f
C230 5v0_addh_sc_tile_1/a_n1373_n454# 5v0_addh_sc_tile_1/upstepper_test 0
C231 5v0_addh_sc_tile_1/pti 5v0_add_q_sc_1/ctrl_over 0.16959f
C232 5v0_addh_sc_tile_1/inv_pti m1_n2844_n810# 0
C233 5v0_add_q_sc_1/ctrl_sign 5v0_addh_sc_tile_0/m1_103_293# 0
C234 5v0_addh_sc_tile_2/ctrl_over 5v0_addh_sc_tile_2/m1_103_293# 0.05856f
C235 5v0_add_q_sc_1/ternary_input 5v0_add_q_sc_1/VDD_1V65 0.03394f
C236 5v0_add_q_sc_0/5v0_half_adder_selector_sc_0/m1_n239_179# 5v0_addh_sc_tile_1/m1_103_293# 0
C237 VDD_1V65_3 5v0_addh_sc_tile_1/inv_nti 0.08611f
C238 5v0_add_q_sc_1/ternary_input 5v0_addh_sc_tile_0/carry_0_probe 0.23005f
C239 5v0_add_q_sc_0/5v0_half_adder_selector_sc_0/m1_n244_n517# VDD_3V3_0 0.29978f
C240 5v0_addh_sc_tile_1/ternary_input 5v0_addh_sc_tile_1/a_n1373_n454# 0.00163f
C241 5v0_nter2oter_code_sc_0/in VDD_3V3_0 2.39776f
C242 5v0_add_q_sc_1/ctrl_over 5v0_add_q_sc_0/upstepper_test 0.01814f
C243 5v0_addh_sc_tile_2/inv_nti 5v0_addh_sc_tile_2/a_n1205_n937# 0
C244 5v0_addh_sc_tile_0/5v0_half_adder_selector_sc_0/res_stage0 in_0_over 0.09179f
C245 5v0_add_q_sc_1/5v0_half_adder_selector_sc_0/5v0_tgate_sel_2_sc_1/input_A 5v0_add_q_sc_1/ctrl_over 0.04656f
C246 5v0_addh_sc_tile_0/downstepper_test in_2 0.01514f
C247 5v0_add_q_sc_1/inv_nti 5v0_add_q_sc_1/nti 0.20056f
C248 5v0_addh_sc_tile_1/ternary_input 5v0_addh_sc_tile_0/nti 0
C249 5v0_add_q_sc_0/downstepper_test VDD_3V3_0 0.55841f
C250 VDD_1V65_0 in_2 0
C251 5v0_add_q_sc_0/5v0_half_adder_selector_sc_0/m1_n244_n517# 5v0_add_q_sc_0/ternary_input 0.07888f
C252 5v0_addh_sc_tile_1/pti 5v0_addh_sc_tile_1/inv_pti 0.37325f
C253 5v0_addh_sc_tile_2/a_382_n1095# 5v0_addh_sc_tile_2/5v0_half_adder_selector_sc_0/5v0_tgate_sel_2_sc_1/input_A 0.02928f
C254 in_2 5v0_addh_sc_tile_1/inv_pti 0
C255 5v0_addh_sc_tile_1/ctrl_over 5v0_addh_sc_tile_1/pti 0.11567f
C256 5v0_addh_sc_tile_0/inv_nti 5v0_addh_sc_tile_0/pti 0.4209f
C257 5v0_addh_sc_tile_1/downstepper_test 5v0_addh_sc_tile_0/m1_843_n857# 0
C258 5v0_addh_sc_tile_1/ctrl_over in_2 0.02277f
C259 5v0_addh_sc_tile_1/inv_nti 5v0_add_q_sc_1/nti 0
C260 5v0_addh_sc_tile_2/inv_nti 5v0_add_q_sc_0/ctrl_sign 0.12058f
C261 5v0_addh_sc_tile_0/5v0_half_adder_selector_sc_0/res_stage0 in_1 0.2646f
C262 5v0_add_q_sc_0/ternary_input 5v0_add_q_sc_0/downstepper_test 0.17146f
C263 5v0_add_q_sc_0/5v0_half_adder_selector_sc_0/res_stage0 5v0_add_q_sc_0/upstepper_test 0.27475f
C264 5v0_addh_sc_tile_1/ctrl_sign 5v0_addh_sc_tile_0/upstepper_test 0
C265 5v0_nter2oter_code_sc_0/pti VDD_3V3_0 0.17187f
C266 5v0_add_q_sc_1/ternary_input m1_n2844_n810# 0.11751f
C267 5v0_add_q_sc_1/downstepper_test 5v0_add_q_sc_1/5v0_half_adder_selector_sc_0/m1_n244_n517# 0.00507f
C268 5v0_addh_sc_tile_1/ctrl_over 5v0_add_q_sc_0/upstepper_test 0.00229f
C269 5v0_addh_sc_tile_2/a_n1373_n454# in_3 0.00163f
C270 5v0_addh_sc_tile_2/a_n1373_n454# 5v0_addh_sc_tile_2/nti 0
C271 5v0_addh_sc_tile_0/inv_pti 5v0_addh_sc_tile_0/upstepper_test 0.07282f
C272 5v0_add_q_sc_1/inv_pti 5v0_add_q_sc_1/nti 0.21255f
C273 5v0_nter2oter_code_sc_0/nti 5v0_addh_sc_tile_2/ctrl_sign 0.03693f
C274 5v0_addh_sc_tile_1/nti 5v0_addh_sc_tile_0/carry_0_probe 0.013f
C275 in_0_sign 5v0_addh_sc_tile_0/downstepper_test 0.14463f
C276 5v0_add_q_sc_0/5v0_half_adder_selector_sc_0/res_stage0 5v0_add_q_sc_0/ctrl_sign 0.22359f
C277 5v0_addh_sc_tile_1/ternary_input 5v0_addh_sc_tile_0/5v0_half_adder_selector_sc_0/res_stage0 0.0902f
C278 5v0_add_q_sc_1/nti 5v0_addh_sc_tile_0/pti 0.00264f
C279 5v0_addh_sc_tile_1/inv_pti 5v0_add_q_sc_0/ctrl_sign 0
C280 5v0_addh_sc_tile_1/ternary_input 5v0_addh_sc_tile_2/m1_103_293# 0
C281 5v0_addh_sc_tile_2/inv_nti 5v0_addh_sc_tile_2/inv_pti 0.2615f
C282 5v0_addh_sc_tile_1/ctrl_over 5v0_add_q_sc_0/ctrl_sign 0.00366f
C283 in_0_sign 5v0_addh_sc_tile_1/inv_pti 0.00171f
C284 5v0_addh_sc_tile_2/inv_nti 5v0_addh_sc_tile_2/upstepper_test 0.00736f
C285 5v0_addh_sc_tile_0/inv_pti 5v0_addh_sc_tile_0/carry_sign_probe 0.17523f
C286 5v0_add_q_sc_1/downstepper_test 5v0_addh_sc_tile_1/ctrl_sign 0.00227f
C287 5v0_addh_sc_tile_2/downstepper_test in_3 0.18203f
C288 5v0_add_q_sc_1/ctrl_sign 5v0_add_q_sc_1/5v0_half_adder_selector_sc_0/m1_n244_n517# 0
C289 5v0_addh_sc_tile_2/a_n1778_n454# in_3 0.00182f
C290 5v0_addh_sc_tile_0/pti 5v0_addh_sc_tile_0/m1_843_n857# 0.11666f
C291 VDD_3V3_1 5v0_addh_sc_tile_1/5v0_half_adder_selector_sc_0/res_stage0 0.01812f
C292 5v0_addh_sc_tile_2/nti 5v0_addh_sc_tile_2/downstepper_test 0.06935f
C293 5v0_addh_sc_tile_2/a_382_n1095# 5v0_addh_sc_tile_1/nti 0
C294 5v0_add_q_sc_1/downstepper_test 5v0_addh_sc_tile_1/a_382_n1095# 0.00433f
C295 5v0_addh_sc_tile_2/a_n1778_n454# 5v0_addh_sc_tile_2/nti 0.00142f
C296 in_0_over 5v0_addh_sc_tile_0/upstepper_test 0.00168f
C297 5v0_nter2oter_code_sc_1/nti 5v0_addh_sc_tile_2/ctrl_sign 0.01527f
C298 5v0_add_q_sc_1/ctrl_over 5v0_addh_sc_tile_1/m1_103_293# 0.01922f
C299 5v0_addh_sc_tile_2/5v0_half_adder_selector_sc_0/res_stage0 5v0_addh_sc_tile_2/m1_103_293# 0.18487f
C300 VDD_1V65_5 5v0_add_q_sc_0/downstepper_test 0.13024f
C301 5v0_addh_sc_tile_1/inv_pti 5v0_addh_sc_tile_2/inv_pti 0
C302 VDD_1V65_2 5v0_addh_sc_tile_0/pti 0
C303 VDD_3V3_1 5v0_addh_sc_tile_1/downstepper_test 0.09186f
C304 5v0_addh_sc_tile_1/ctrl_over 5v0_addh_sc_tile_2/inv_pti 0.00723f
C305 5v0_add_q_sc_1/inv_nti VDD_3V3_1 0.56275f
C306 5v0_addh_sc_tile_0/carry_0_probe m1_n2844_n810# 0.42968f
C307 5v0_addh_sc_tile_1/ctrl_over 5v0_addh_sc_tile_2/upstepper_test 0
C308 in_0_over 5v0_addh_sc_tile_0/carry_sign_probe 0.00413f
C309 in_1 5v0_addh_sc_tile_0/upstepper_test 0.01604f
C310 5v0_addh_sc_tile_1/a_n1778_n454# 5v0_addh_sc_tile_1/downstepper_test 0.0031f
C311 5v0_nter2oter_code_sc_0/in 5v0_addh_sc_tile_2/ctrl_sign 0.30294f
C312 5v0_add_q_sc_1/ternary_input in_0_sign 0
C313 5v0_addh_sc_tile_0/a_n1778_n454# 5v0_addh_sc_tile_0/pti 0.00135f
C314 5v0_addh_sc_tile_1/ctrl_sign 5v0_addh_sc_tile_1/m1_843_n857# 0.24363f
C315 5v0_add_q_sc_1/ctrl_sign 5v0_addh_sc_tile_1/ctrl_sign 0.24986f
C316 5v0_addh_sc_tile_0/downstepper_test 5v0_addh_sc_tile_0/inv_nti 0.29989f
C317 5v0_addh_sc_tile_0/5v0_half_adder_selector_sc_0/res_stage0 5v0_addh_sc_tile_0/5v0_half_adder_selector_sc_0/5v0_tgate_sel_2_sc_1/input_A 0.00253f
C318 5v0_add_q_sc_0/pti 5v0_addh_sc_tile_1/a_382_n1095# 0
C319 5v0_addh_sc_tile_1/m1_103_293# 5v0_addh_sc_tile_1/inv_pti 0.17653f
C320 VDD_3V3_1 5v0_addh_sc_tile_1/inv_nti 0.11496f
C321 5v0_addh_sc_tile_1/nti 5v0_addh_sc_tile_1/pti 0.24193f
C322 VDD_1V65_0 5v0_addh_sc_tile_0/inv_nti 0.08611f
C323 5v0_add_q_sc_0/a_n1205_n937# 5v0_add_q_sc_0/5v0_half_adder_selector_sc_0/res_stage0 0
C324 5v0_addh_sc_tile_1/nti in_2 0.00583f
C325 5v0_add_q_sc_1/downstepper_test in_0_over 0
C326 5v0_add_q_sc_1/ctrl_sign 5v0_addh_sc_tile_1/a_382_n1095# 0.00155f
C327 5v0_addh_sc_tile_1/ctrl_over 5v0_addh_sc_tile_1/m1_103_293# 0.02786f
C328 5v0_addh_sc_tile_1/m1_843_n857# 5v0_addh_sc_tile_1/a_382_n1095# 0.05013f
C329 5v0_add_q_sc_1/ctrl_sign 5v0_addh_sc_tile_0/inv_pti 0
C330 5v0_addh_sc_tile_0/inv_nti 5v0_addh_sc_tile_1/inv_pti 0
C331 5v0_addh_sc_tile_1/pti 5v0_addh_sc_tile_0/carry_0_probe 0.0051f
C332 5v0_addh_sc_tile_1/ctrl_over 5v0_addh_sc_tile_0/inv_nti 0
C333 5v0_addh_sc_tile_0/5v0_half_adder_selector_sc_0/res_stage0 5v0_addh_sc_tile_0/nti 0.00372f
C334 5v0_addh_sc_tile_1/inv_nti 5v0_addh_sc_tile_1/a_n1778_n454# 0.00226f
C335 VDD_1V65_3 5v0_addh_sc_tile_1/inv_pti 0.14775f
C336 5v0_nter2oter_code_sc_1/pti 5v0_addh_sc_tile_2/nti 0
C337 5v0_add_q_sc_1/ctrl_over 5v0_add_q_sc_1/nti 0.00725f
C338 5v0_addh_sc_tile_1/ctrl_sign 5v0_addh_sc_tile_2/nti 0
C339 VDD_1V65_3 5v0_addh_sc_tile_1/ctrl_over 0.02438f
C340 VDD_3V3_1 5v0_add_q_sc_1/inv_pti 0.40305f
C341 5v0_nter2oter_code_sc_0/pti 5v0_addh_sc_tile_2/ctrl_sign 0.23385f
C342 5v0_addh_sc_tile_1/upstepper_test 5v0_addh_sc_tile_0/carry_sign_probe 0
C343 5v0_addh_sc_tile_2/upstepper_test 5v0_addh_sc_tile_2/5v0_half_adder_selector_sc_0/5v0_tgate_sel_2_sc_1/input_A 0
C344 5v0_add_q_sc_0/inv_nti 5v0_add_q_sc_0/a_n1778_n454# 0.00214f
C345 5v0_add_q_sc_0/inv_pti 5v0_addh_sc_tile_1/inv_nti 0
C346 5v0_addh_sc_tile_1/a_n1205_n937# 5v0_addh_sc_tile_1/upstepper_test 0.00334f
C347 VDD_3V3_1 5v0_addh_sc_tile_0/pti 0.68621f
C348 5v0_addh_sc_tile_2/ctrl_over in_3 0.1551f
C349 5v0_add_q_sc_1/ctrl_sign in_0_over 0.00327f
C350 5v0_addh_sc_tile_1/nti 5v0_add_q_sc_0/ctrl_sign 0
C351 5v0_add_q_sc_1/ternary_input 5v0_addh_sc_tile_1/m1_103_293# 0
C352 5v0_addh_sc_tile_2/ctrl_over 5v0_addh_sc_tile_2/nti 0.007f
C353 5v0_add_q_sc_1/nti 5v0_addh_sc_tile_1/inv_pti 0.00413f
C354 5v0_add_q_sc_0/5v0_half_adder_selector_sc_0/m1_n239_179# 5v0_add_q_sc_0/inv_pti 0
C355 5v0_nter2oter_code_sc_1/gf180mcu_fd_sc_mcu7t5v0__nor2_1_0/a_224_472# 5v0_addh_sc_tile_1/downstepper_test 0
C356 5v0_add_q_sc_0/5v0_half_adder_selector_sc_0/m1_n244_n517# 5v0_add_q_sc_0/5v0_half_adder_selector_sc_0/5v0_tgate_sel_2_sc_1/input_A 0.02928f
C357 5v0_addh_sc_tile_1/ctrl_over 5v0_add_q_sc_1/nti 0
C358 5v0_addh_sc_tile_1/nti in_0_sign 0
C359 5v0_add_q_sc_1/ternary_input 5v0_addh_sc_tile_0/inv_nti 0.001f
C360 5v0_add_q_sc_1/a_n1373_n454# 5v0_add_q_sc_1/pti 0
C361 5v0_addh_sc_tile_2/a_382_n1095# 5v0_add_q_sc_0/upstepper_test 0
C362 5v0_addh_sc_tile_2/m1_103_293# 5v0_addh_sc_tile_2/m1_843_n857# 0.20659f
C363 in_0_sign 5v0_addh_sc_tile_0/carry_0_probe 0.01013f
C364 5v0_add_q_sc_0/5v0_half_adder_selector_sc_0/5v0_tgate_sel_2_sc_1/input_A 5v0_add_q_sc_0/downstepper_test 0
C365 5v0_addh_sc_tile_1/inv_pti 5v0_addh_sc_tile_0/m1_843_n857# 0.00739f
C366 5v0_addh_sc_tile_1/5v0_half_adder_selector_sc_0/res_stage0 5v0_addh_sc_tile_0/a_382_n1095# 0
C367 5v0_addh_sc_tile_2/inv_nti res_0 0.01449f
C368 5v0_addh_sc_tile_0/5v0_half_adder_selector_sc_0/5v0_tgate_sel_2_sc_1/input_A 5v0_addh_sc_tile_0/upstepper_test 0
C369 5v0_add_q_sc_1/ctrl_sign 5v0_addh_sc_tile_1/upstepper_test 0
C370 5v0_addh_sc_tile_1/nti 5v0_addh_sc_tile_2/inv_pti 0
C371 5v0_addh_sc_tile_2/a_382_n1095# 5v0_add_q_sc_0/ctrl_sign 0.00651f
C372 5v0_addh_sc_tile_1/nti 5v0_addh_sc_tile_2/upstepper_test 0.00102f
C373 5v0_nter2oter_code_sc_0/nti 5v0_addh_sc_tile_1/ctrl_sign 0
C374 5v0_addh_sc_tile_0/a_n1778_n454# 5v0_addh_sc_tile_0/downstepper_test 0.0031f
C375 5v0_addh_sc_tile_0/nti 5v0_addh_sc_tile_0/upstepper_test 0.11981f
C376 5v0_add_q_sc_1/ternary_input 5v0_add_q_sc_1/nti 0.68929f
C377 5v0_addh_sc_tile_1/pti 5v0_add_q_sc_0/upstepper_test 0.0029f
C378 5v0_addh_sc_tile_0/a_n1778_n454# VDD_1V65_0 0
C379 5v0_add_q_sc_1/inv_nti 5v0_addh_sc_tile_0/a_382_n1095# 0
C380 5v0_addh_sc_tile_1/ternary_input 5v0_addh_sc_tile_1/m1_843_n857# 0
C381 in_0_sign m1_n2844_n810# 0.0018f
C382 5v0_add_q_sc_0/inv_nti 5v0_add_q_sc_1/ctrl_over 0
C383 5v0_addh_sc_tile_1/nti 5v0_addh_sc_tile_0/inv_nti 0
C384 VDD_3V3_1 5v0_add_q_sc_1/ctrl_over 0.6465f
C385 5v0_addh_sc_tile_1/m1_103_293# 5v0_addh_sc_tile_0/carry_0_probe 0.002f
C386 5v0_add_q_sc_1/5v0_half_adder_selector_sc_0/res_stage0 5v0_add_q_sc_1/a_n1205_n937# 0
C387 5v0_addh_sc_tile_2/pti 5v0_addh_sc_tile_1/inv_nti 0
C388 5v0_addh_sc_tile_1/inv_nti 5v0_addh_sc_tile_0/a_382_n1095# 0
C389 5v0_nter2oter_code_sc_0/nti 5v0_addh_sc_tile_2/ctrl_over 0.22761f
C390 VDD_1V65_3 5v0_addh_sc_tile_1/nti 0.21326f
C391 5v0_addh_sc_tile_0/inv_nti 5v0_addh_sc_tile_0/carry_0_probe 0.03001f
C392 5v0_addh_sc_tile_2/a_382_n1095# 5v0_addh_sc_tile_2/inv_pti 0.00129f
C393 5v0_addh_sc_tile_1/pti 5v0_add_q_sc_0/ctrl_sign 0
C394 5v0_nter2oter_code_sc_1/nti 5v0_nter2oter_code_sc_1/pti 0.0056f
C395 5v0_addh_sc_tile_2/pti 5v0_add_q_sc_0/5v0_half_adder_selector_sc_0/m1_n239_179# 0
C396 VDD_3V3_1 5v0_addh_sc_tile_0/downstepper_test 0.513f
C397 5v0_nter2oter_code_sc_1/nti 5v0_addh_sc_tile_1/ctrl_sign 0.34366f
C398 5v0_addh_sc_tile_1/inv_nti 5v0_add_q_sc_0/nti 0
C399 in_0_sign 5v0_addh_sc_tile_1/pti 0
C400 5v0_add_q_sc_1/ternary_input VDD_1V65_2 0.02356f
C401 VDD_3V3_1 VDD_1V65_0 0.04264f
C402 5v0_add_q_sc_0/5v0_half_adder_selector_sc_0/m1_n239_179# 5v0_add_q_sc_0/ctrl_over 0.00258f
C403 5v0_addh_sc_tile_0/5v0_half_adder_selector_sc_0/res_stage0 5v0_addh_sc_tile_0/upstepper_test 0.27475f
C404 5v0_add_q_sc_0/inv_nti 5v0_addh_sc_tile_1/ctrl_over 0
C405 5v0_addh_sc_tile_2/5v0_half_adder_selector_sc_0/res_stage0 in_3 0.26626f
C406 5v0_addh_sc_tile_1/5v0_half_adder_selector_sc_0/res_stage0 VDD_3V3_0 0.11354f
C407 5v0_add_q_sc_0/inv_pti 5v0_add_q_sc_1/ctrl_over 0.00278f
C408 VDD_3V3_1 5v0_addh_sc_tile_1/inv_pti 0.81122f
C409 5v0_add_q_sc_0/ctrl_sign 5v0_add_q_sc_0/upstepper_test 0.08746f
C410 5v0_addh_sc_tile_2/5v0_half_adder_selector_sc_0/res_stage0 5v0_addh_sc_tile_2/nti 0.00372f
C411 VDD_3V3_1 5v0_addh_sc_tile_1/ctrl_over 0.02757f
C412 5v0_add_q_sc_0/a_n1373_n454# 5v0_add_q_sc_0/upstepper_test 0
C413 5v0_addh_sc_tile_0/a_382_n1095# 5v0_addh_sc_tile_0/pti 0.12627f
C414 5v0_nter2oter_code_sc_1/pti 5v0_nter2oter_code_sc_0/in 0.00485f
C415 5v0_addh_sc_tile_1/m1_103_293# m1_n2844_n810# 0
C416 5v0_addh_sc_tile_1/ctrl_sign 5v0_nter2oter_code_sc_0/in 0.00767f
C417 5v0_nter2oter_code_sc_1/nti 5v0_addh_sc_tile_2/ctrl_over 0
C418 5v0_add_q_sc_1/nti 5v0_add_q_sc_1/VDD_1V65 0.21326f
C419 5v0_add_q_sc_0/5v0_half_adder_selector_sc_0/m1_n244_n517# 5v0_addh_sc_tile_1/a_382_n1095# 0
C420 5v0_addh_sc_tile_1/pti 5v0_addh_sc_tile_2/inv_pti 0
C421 5v0_add_q_sc_1/nti 5v0_addh_sc_tile_0/carry_0_probe 0.11163f
C422 in_2 5v0_addh_sc_tile_2/inv_pti 0
C423 5v0_addh_sc_tile_0/inv_nti m1_n2844_n810# 0.02458f
C424 5v0_addh_sc_tile_1/downstepper_test VDD_3V3_0 0.41827f
C425 res_c 5v0_add_q_sc_0/5v0_half_adder_selector_sc_0/res_stage0 0.08533f
C426 5v0_nter2oter_code_sc_0/in 5v0_addh_sc_tile_1/a_382_n1095# 0.16245f
C427 5v0_addh_sc_tile_0/5v0_half_adder_selector_sc_0/res_stage0 5v0_addh_sc_tile_0/carry_sign_probe 0
C428 5v0_add_q_sc_0/a_n1778_n454# 5v0_add_q_sc_0/nti 0.00142f
C429 5v0_add_q_sc_0/inv_pti 5v0_add_q_sc_0/5v0_half_adder_selector_sc_0/res_stage0 0
C430 5v0_addh_sc_tile_1/nti 5v0_addh_sc_tile_0/m1_843_n857# 0
C431 5v0_addh_sc_tile_1/ctrl_over res_c 0
C432 5v0_addh_sc_tile_1/a_382_n1095# 5v0_add_q_sc_0/downstepper_test 0.00203f
C433 5v0_add_q_sc_0/inv_pti 5v0_addh_sc_tile_1/ctrl_over 0.00152f
C434 5v0_add_q_sc_0/upstepper_test 5v0_addh_sc_tile_2/inv_pti 0
C435 5v0_add_q_sc_0/5v0_half_adder_selector_sc_0/m1_n244_n517# 5v0_addh_sc_tile_2/ctrl_over 0.00443f
C436 5v0_addh_sc_tile_0/carry_0_probe 5v0_addh_sc_tile_0/m1_843_n857# 0.18376f
C437 5v0_addh_sc_tile_1/pti 5v0_addh_sc_tile_1/m1_103_293# 0.10002f
C438 5v0_nter2oter_code_sc_0/in 5v0_addh_sc_tile_2/ctrl_over 1.76395f
C439 5v0_nter2oter_code_sc_0/pti 5v0_nter2oter_code_sc_1/pti 0.20957f
C440 5v0_addh_sc_tile_1/inv_nti VDD_3V3_0 0.66951f
C441 VDD_3V3_1 5v0_add_q_sc_1/ternary_input 1.23209f
C442 5v0_addh_sc_tile_1/ctrl_sign 5v0_nter2oter_code_sc_0/pti 0.00357f
C443 5v0_addh_sc_tile_2/upstepper_test 5v0_addh_sc_tile_2/a_n1205_n937# 0.00334f
C444 5v0_addh_sc_tile_0/inv_nti 5v0_addh_sc_tile_1/pti 0
C445 5v0_addh_sc_tile_2/ctrl_over 5v0_add_q_sc_0/downstepper_test 0.01272f
C446 5v0_addh_sc_tile_0/inv_nti in_2 0.01479f
C447 VDD_1V65_3 5v0_addh_sc_tile_1/pti 0.00234f
C448 5v0_add_q_sc_0/5v0_half_adder_selector_sc_0/m1_n239_179# VDD_3V3_0 0.30519f
C449 5v0_addh_sc_tile_1/m1_103_293# 5v0_add_q_sc_0/upstepper_test 0.00268f
C450 5v0_addh_sc_tile_1/inv_nti 5v0_add_q_sc_0/ternary_input 0.0263f
C451 VDD_1V65_2 5v0_addh_sc_tile_0/carry_0_probe 0.03841f
C452 5v0_add_q_sc_1/nti m1_n2844_n810# 0.00573f
C453 5v0_nter2oter_code_sc_1/nti in_1 0
C454 5v0_add_q_sc_0/ctrl_sign 5v0_addh_sc_tile_2/inv_pti 0.10221f
C455 5v0_add_q_sc_0/a_n1205_n937# 5v0_add_q_sc_0/upstepper_test 0.00334f
C456 res_0 5v0_addh_sc_tile_1/nti 0
C457 5v0_nter2oter_code_sc_1/gf180mcu_fd_sc_mcu7t5v0__nor2_1_0/a_224_472# 5v0_addh_sc_tile_1/ctrl_over 0.00394f
C458 5v0_add_q_sc_0/5v0_half_adder_selector_sc_0/m1_n239_179# 5v0_add_q_sc_0/ternary_input 0.00189f
C459 5v0_nter2oter_code_sc_0/pti 5v0_addh_sc_tile_2/ctrl_over 0.00125f
C460 5v0_addh_sc_tile_0/m1_843_n857# m1_n2844_n810# 0.00191f
C461 5v0_addh_sc_tile_2/inv_nti 5v0_addh_sc_tile_2/pti 0.42143f
C462 5v0_addh_sc_tile_1/pti 5v0_add_q_sc_1/nti 0
C463 5v0_nter2oter_code_sc_0/in in_1 0.00145f
C464 VDD_1V65_4 in_3 0.01451f
C465 in_3 5v0_addh_sc_tile_2/m1_843_n857# 0
C466 5v0_addh_sc_tile_2/inv_nti 5v0_add_q_sc_0/ctrl_over 0.01791f
C467 5v0_nter2oter_code_sc_1/nti 5v0_addh_sc_tile_1/ternary_input 0.01204f
C468 VDD_1V65_4 5v0_addh_sc_tile_2/nti 0.21326f
C469 5v0_add_q_sc_0/ternary_input 5v0_add_q_sc_0/a_n1778_n454# 0.00116f
C470 5v0_add_q_sc_1/downstepper_test 5v0_add_q_sc_1/5v0_half_adder_selector_sc_0/m1_n239_179# 0.09961f
C471 5v0_add_q_sc_1/ctrl_over 5v0_add_q_sc_0/nti 0.01581f
C472 5v0_nter2oter_code_sc_0/in 5v0_addh_sc_tile_1/upstepper_test 0.00268f
C473 5v0_addh_sc_tile_1/5v0_half_adder_selector_sc_0/5v0_tgate_sel_2_sc_1/input_A 5v0_addh_sc_tile_1/5v0_half_adder_selector_sc_0/res_stage0 0.00253f
C474 VDD_1V65_2 m1_n2844_n810# 0.00448f
C475 in_0_sign 5v0_addh_sc_tile_0/inv_nti 0.24892f
C476 5v0_add_q_sc_1/inv_nti 5v0_add_q_sc_1/pti 0.10916f
C477 5v0_addh_sc_tile_2/m1_103_293# in_3 0
C478 5v0_addh_sc_tile_0/downstepper_test 5v0_addh_sc_tile_0/a_382_n1095# 0.00679f
C479 5v0_addh_sc_tile_1/pti 5v0_addh_sc_tile_0/m1_843_n857# 0
C480 5v0_addh_sc_tile_0/carry_sign_probe 5v0_addh_sc_tile_0/upstepper_test 0
C481 VDD_3V3_1 5v0_addh_sc_tile_1/nti 0.14047f
C482 VDD_1V65_3 in_0_sign 0
C483 5v0_addh_sc_tile_2/upstepper_test 5v0_addh_sc_tile_2/inv_pti 0.07254f
C484 5v0_addh_sc_tile_2/pti 5v0_add_q_sc_0/5v0_half_adder_selector_sc_0/res_stage0 0
C485 res_0 5v0_addh_sc_tile_2/a_382_n1095# 0.16245f
C486 VDD_3V3_1 5v0_add_q_sc_1/VDD_1V65 0.0427f
C487 5v0_addh_sc_tile_2/pti 5v0_addh_sc_tile_1/inv_pti 0
C488 VDD_3V3_1 5v0_addh_sc_tile_0/carry_0_probe 0.82136f
C489 5v0_addh_sc_tile_0/a_382_n1095# 5v0_addh_sc_tile_1/inv_pti 0
C490 5v0_addh_sc_tile_1/nti 5v0_addh_sc_tile_1/a_n1778_n454# 0.00142f
C491 5v0_add_q_sc_0/ctrl_over 5v0_add_q_sc_0/5v0_half_adder_selector_sc_0/res_stage0 0.09159f
C492 5v0_addh_sc_tile_2/pti 5v0_addh_sc_tile_1/ctrl_over 0.00148f
C493 5v0_addh_sc_tile_1/ctrl_over 5v0_addh_sc_tile_0/a_382_n1095# 0
C494 5v0_addh_sc_tile_1/ternary_input 5v0_nter2oter_code_sc_0/in 0.17192f
C495 5v0_add_q_sc_1/downstepper_test 5v0_add_q_sc_1/a_n1778_n454# 0.0031f
C496 5v0_addh_sc_tile_1/inv_nti 5v0_add_q_sc_1/pti 0
C497 5v0_nter2oter_code_sc_0/pti in_1 0
C498 5v0_addh_sc_tile_1/5v0_half_adder_selector_sc_0/5v0_tgate_sel_2_sc_1/input_A 5v0_addh_sc_tile_1/downstepper_test 0
C499 5v0_addh_sc_tile_1/ctrl_over 5v0_add_q_sc_0/ctrl_over 0
C500 5v0_nter2oter_code_sc_0/nti 5v0_addh_sc_tile_0/nti 0.00244f
C501 5v0_add_q_sc_0/5v0_half_adder_selector_sc_0/res_stage0 5v0_add_q_sc_0/nti 0.00372f
C502 5v0_addh_sc_tile_2/ctrl_sign 5v0_addh_sc_tile_1/downstepper_test 0.00468f
C503 5v0_addh_sc_tile_1/ctrl_over 5v0_add_q_sc_0/nti 0
C504 5v0_add_q_sc_1/ctrl_sign 5v0_add_q_sc_1/5v0_half_adder_selector_sc_0/m1_n239_179# 0.30422f
C505 5v0_add_q_sc_1/inv_pti 5v0_add_q_sc_1/5v0_half_adder_selector_sc_0/res_stage0 0
C506 5v0_add_q_sc_1/inv_pti 5v0_add_q_sc_1/pti 0.19726f
C507 in_0_sign 5v0_add_q_sc_1/nti 0
C508 5v0_addh_sc_tile_1/ternary_input 5v0_nter2oter_code_sc_0/pti 0
C509 5v0_addh_sc_tile_2/inv_nti VDD_3V3_0 0.88474f
C510 5v0_add_q_sc_1/ctrl_over VDD_3V3_0 0.33124f
C511 5v0_addh_sc_tile_1/inv_nti 5v0_addh_sc_tile_2/ctrl_sign 0.00386f
C512 VDD_3V3_1 m1_n2844_n810# 0.14975f
C513 5v0_add_q_sc_1/ctrl_sign 5v0_add_q_sc_1/a_n1778_n454# 0
C514 5v0_addh_sc_tile_0/a_n1373_n454# 5v0_addh_sc_tile_0/pti 0
C515 in_0_sign 5v0_addh_sc_tile_0/m1_843_n857# 0.24363f
C516 5v0_add_q_sc_0/a_n1778_n454# VDD_1V65_5 0
C517 5v0_add_q_sc_0/ctrl_over 5v0_addh_sc_tile_2/5v0_half_adder_selector_sc_0/5v0_tgate_sel_2_sc_1/input_A 0
C518 5v0_addh_sc_tile_2/inv_nti 5v0_add_q_sc_0/ternary_input 0
C519 5v0_nter2oter_code_sc_1/nti 5v0_addh_sc_tile_0/nti 0
C520 5v0_add_q_sc_0/ternary_input 5v0_add_q_sc_1/ctrl_over 0.30261f
C521 5v0_addh_sc_tile_0/downstepper_test VDD_3V3_0 0
C522 5v0_add_q_sc_0/5v0_half_adder_selector_sc_0/res_stage0 VDD_3V3_0 0.16909f
C523 5v0_addh_sc_tile_1/inv_pti VDD_3V3_0 0.1766f
C524 VDD_3V3_1 5v0_addh_sc_tile_1/pti 0.57114f
C525 5v0_add_q_sc_1/ctrl_sign 5v0_addh_sc_tile_0/carry_sign_probe 0.00205f
C526 VDD_3V3_1 in_2 0.90866f
C527 5v0_addh_sc_tile_1/ctrl_over VDD_3V3_0 1.37819f
C528 5v0_add_q_sc_1/nti 5v0_addh_sc_tile_1/m1_103_293# 0.00685f
C529 5v0_nter2oter_code_sc_0/in 5v0_addh_sc_tile_0/nti 0.0033f
C530 5v0_add_q_sc_0/ternary_input 5v0_add_q_sc_0/5v0_half_adder_selector_sc_0/res_stage0 0.27792f
C531 5v0_addh_sc_tile_1/a_n1778_n454# 5v0_addh_sc_tile_1/pti 0.00135f
C532 5v0_add_q_sc_0/inv_nti 5v0_add_q_sc_0/upstepper_test 0.0011f
C533 VDD_3V3_1 5v0_add_q_sc_0/upstepper_test 0
C534 5v0_add_q_sc_0/ternary_input 5v0_addh_sc_tile_1/inv_pti 0.00157f
C535 5v0_add_q_sc_1/ctrl_sign 5v0_add_q_sc_1/downstepper_test 0.25694f
C536 5v0_addh_sc_tile_1/ctrl_over 5v0_add_q_sc_0/ternary_input 0.01695f
C537 VDD_3V3_1 5v0_add_q_sc_1/5v0_half_adder_selector_sc_0/5v0_tgate_sel_2_sc_1/input_A 0.02871f
C538 5v0_addh_sc_tile_0/downstepper_test 5v0_addh_sc_tile_0/a_n1205_n937# 0.00453f
C539 5v0_add_q_sc_0/inv_pti 5v0_addh_sc_tile_1/pti 0
C540 VDD_1V65_0 5v0_addh_sc_tile_0/a_n1205_n937# 0.00354f
C541 5v0_addh_sc_tile_0/inv_nti 5v0_addh_sc_tile_0/m1_843_n857# 0.36668f
C542 5v0_addh_sc_tile_2/pti 5v0_addh_sc_tile_1/nti 0
C543 5v0_addh_sc_tile_1/nti 5v0_addh_sc_tile_0/a_382_n1095# 0.01157f
C544 5v0_nter2oter_code_sc_0/pti 5v0_addh_sc_tile_0/nti 0
C545 5v0_addh_sc_tile_2/5v0_half_adder_selector_sc_0/5v0_tgate_sel_2_sc_1/input_A VDD_3V3_0 0.02871f
C546 5v0_addh_sc_tile_0/m1_103_293# 5v0_addh_sc_tile_0/pti 0.10002f
C547 5v0_addh_sc_tile_1/ctrl_over 5v0_addh_sc_tile_0/a_n1205_n937# 0
C548 5v0_addh_sc_tile_0/a_382_n1095# 5v0_addh_sc_tile_0/carry_0_probe 0.08241f
C549 5v0_add_q_sc_1/pti 5v0_add_q_sc_1/ctrl_over 0
C550 5v0_add_q_sc_1/5v0_half_adder_selector_sc_0/res_stage0 5v0_add_q_sc_1/ctrl_over 0.11645f
C551 5v0_add_q_sc_0/inv_nti 5v0_add_q_sc_0/a_n1373_n454# 0
C552 VDD_1V65_2 5v0_addh_sc_tile_1/m1_103_293# 0
C553 5v0_add_q_sc_0/inv_pti 5v0_add_q_sc_0/upstepper_test 0.0467f
C554 VDD_3V3_1 in_0_sign 0.65887f
C555 5v0_addh_sc_tile_1/m1_843_n857# 5v0_add_q_sc_0/pti 0.00111f
C556 5v0_add_q_sc_1/ctrl_sign 5v0_addh_sc_tile_1/m1_843_n857# 0.0069f
C557 5v0_add_q_sc_0/ternary_input 5v0_add_q_sc_1/ternary_input 0.17661f
C558 5v0_nter2oter_code_sc_0/in 5v0_addh_sc_tile_2/m1_103_293# 0.00332f
C559 5v0_addh_sc_tile_1/5v0_half_adder_selector_sc_0/5v0_tgate_sel_2_sc_1/input_A 5v0_add_q_sc_1/ctrl_over 0
C560 5v0_addh_sc_tile_0/downstepper_test 5v0_addh_sc_tile_0/a_n1373_n454# 0.00442f
C561 5v0_addh_sc_tile_0/a_n1778_n454# 5v0_addh_sc_tile_0/inv_nti 0.00226f
C562 res_c 5v0_add_q_sc_0/ctrl_sign 0
C563 VDD_1V65_0 5v0_addh_sc_tile_0/a_n1373_n454# 0.00232f
C564 5v0_addh_sc_tile_2/pti 5v0_addh_sc_tile_2/a_382_n1095# 0.12254f
C565 5v0_add_q_sc_1/pti 5v0_addh_sc_tile_1/inv_pti 0
C566 5v0_addh_sc_tile_2/inv_nti 5v0_addh_sc_tile_2/ctrl_sign 0.24905f
C567 5v0_add_q_sc_0/inv_pti 5v0_add_q_sc_0/ctrl_sign 0.00263f
C568 5v0_addh_sc_tile_2/a_382_n1095# 5v0_add_q_sc_0/ctrl_over 0.06871f
C569 5v0_add_q_sc_0/a_n1373_n454# 5v0_add_q_sc_0/inv_pti 0.00135f
C570 5v0_addh_sc_tile_1/ctrl_over VDD_1V65_5 0
C571 5v0_addh_sc_tile_0/a_382_n1095# m1_n2844_n810# 0.04011f
C572 5v0_addh_sc_tile_1/ctrl_sign 5v0_addh_sc_tile_1/5v0_half_adder_selector_sc_0/res_stage0 0.22639f
C573 5v0_addh_sc_tile_2/a_382_n1095# 5v0_add_q_sc_0/nti 0
C574 VDD_1V65_2 5v0_add_q_sc_1/nti 0.02331f
C575 5v0_addh_sc_tile_2/nti in_3 0.52138f
C576 5v0_addh_sc_tile_1/5v0_half_adder_selector_sc_0/res_stage0 5v0_addh_sc_tile_1/a_382_n1095# 0.08951f
C577 5v0_addh_sc_tile_1/nti VDD_3V3_0 0.44357f
C578 5v0_addh_sc_tile_1/5v0_half_adder_selector_sc_0/5v0_tgate_sel_2_sc_1/input_A 5v0_addh_sc_tile_1/ctrl_over 0.04656f
C579 VDD_3V3_1 5v0_addh_sc_tile_1/m1_103_293# 0.62378f
C580 5v0_add_q_sc_0/inv_nti 5v0_add_q_sc_0/a_n1205_n937# 0
C581 5v0_nter2oter_code_sc_1/nti 5v0_addh_sc_tile_0/upstepper_test 0
C582 VDD_3V3_1 5v0_addh_sc_tile_0/inv_nti 0.85222f
C583 5v0_addh_sc_tile_2/ctrl_sign 5v0_addh_sc_tile_1/inv_pti 0
C584 5v0_addh_sc_tile_0/carry_0_probe VDD_3V3_0 0
C585 5v0_addh_sc_tile_1/ctrl_sign 5v0_addh_sc_tile_1/downstepper_test 0.20136f
C586 5v0_addh_sc_tile_2/pti 5v0_addh_sc_tile_1/pti 0
C587 5v0_addh_sc_tile_1/ctrl_over 5v0_addh_sc_tile_2/ctrl_sign 0.04127f
C588 5v0_addh_sc_tile_1/ctrl_sign 5v0_add_q_sc_1/inv_nti 0
C589 5v0_addh_sc_tile_1/pti 5v0_addh_sc_tile_0/a_382_n1095# 0.00485f
C590 5v0_addh_sc_tile_2/pti in_2 0
C591 5v0_addh_sc_tile_1/5v0_half_adder_selector_sc_0/res_stage0 5v0_addh_sc_tile_2/ctrl_over 0.00478f
C592 5v0_addh_sc_tile_1/a_382_n1095# 5v0_addh_sc_tile_1/downstepper_test 0.00679f
C593 5v0_add_q_sc_1/ternary_input 5v0_add_q_sc_1/5v0_half_adder_selector_sc_0/res_stage0 0.27251f
C594 5v0_add_q_sc_1/ternary_input 5v0_add_q_sc_1/pti 0.54174f
C595 VDD_1V65_3 5v0_addh_sc_tile_1/a_n1778_n454# 0
C596 5v0_addh_sc_tile_1/pti 5v0_add_q_sc_0/nti 0
C597 5v0_addh_sc_tile_2/pti 5v0_add_q_sc_0/upstepper_test 0
C598 5v0_nter2oter_code_sc_1/pti 5v0_addh_sc_tile_1/inv_nti 0
C599 5v0_addh_sc_tile_1/ctrl_sign 5v0_addh_sc_tile_1/inv_nti 0.25042f
C600 5v0_addh_sc_tile_0/downstepper_test 5v0_addh_sc_tile_0/m1_103_293# 0.10533f
C601 5v0_addh_sc_tile_1/5v0_half_adder_selector_sc_0/res_stage0 in_0_over 0
C602 5v0_add_q_sc_0/ctrl_over 5v0_add_q_sc_0/upstepper_test 0.00167f
C603 5v0_addh_sc_tile_2/ctrl_over 5v0_addh_sc_tile_1/downstepper_test 0.01399f
C604 5v0_addh_sc_tile_1/inv_nti 5v0_addh_sc_tile_1/a_382_n1095# 0.28394f
C605 5v0_addh_sc_tile_2/a_382_n1095# VDD_3V3_0 0.66129f
C606 5v0_addh_sc_tile_2/inv_nti 5v0_addh_sc_tile_2/a_n1373_n454# 0
C607 5v0_addh_sc_tile_1/ctrl_sign 5v0_add_q_sc_0/5v0_half_adder_selector_sc_0/m1_n239_179# 0
C608 5v0_add_q_sc_0/upstepper_test 5v0_add_q_sc_0/nti 0.11981f
C609 5v0_nter2oter_code_sc_1/gf180mcu_fd_sc_mcu7t5v0__nor2_1_0/a_224_472# 5v0_addh_sc_tile_2/inv_pti 0
C610 5v0_addh_sc_tile_0/m1_103_293# 5v0_addh_sc_tile_1/inv_pti 0.00205f
C611 VDD_3V3_1 5v0_add_q_sc_1/nti 0.5318f
C612 5v0_addh_sc_tile_2/ctrl_sign 5v0_addh_sc_tile_2/5v0_half_adder_selector_sc_0/5v0_tgate_sel_2_sc_1/input_A 0
C613 5v0_add_q_sc_0/5v0_half_adder_selector_sc_0/m1_n239_179# 5v0_addh_sc_tile_1/a_382_n1095# 0.0035f
C614 5v0_addh_sc_tile_2/pti 5v0_add_q_sc_0/ctrl_sign 0.011f
C615 5v0_addh_sc_tile_2/a_382_n1095# 5v0_add_q_sc_0/ternary_input 0.0013f
C616 5v0_add_q_sc_1/inv_pti 5v0_addh_sc_tile_1/a_382_n1095# 0
C617 in_0_over 5v0_addh_sc_tile_1/downstepper_test 0
C618 5v0_nter2oter_code_sc_0/gf180mcu_fd_sc_mcu7t5v0__nor2_1_0/a_224_472# VDD_3V3_0 0.01413f
C619 5v0_addh_sc_tile_2/ctrl_over 5v0_addh_sc_tile_1/inv_nti 0.00155f
C620 5v0_add_q_sc_1/inv_nti in_0_over 0.00113f
C621 5v0_nter2oter_code_sc_1/pti 5v0_addh_sc_tile_0/pti 0
C622 5v0_addh_sc_tile_1/ctrl_sign 5v0_addh_sc_tile_0/pti 0.00125f
C623 5v0_add_q_sc_0/5v0_half_adder_selector_sc_0/5v0_tgate_sel_2_sc_1/input_A 5v0_add_q_sc_0/5v0_half_adder_selector_sc_0/res_stage0 0.00253f
C624 in_0_sign 5v0_addh_sc_tile_0/a_382_n1095# 0.07412f
C625 5v0_add_q_sc_0/ctrl_over 5v0_add_q_sc_0/ctrl_sign 0.02568f
C626 5v0_nter2oter_code_sc_0/nti in_3 0.00248f
C627 VDD_3V3_1 5v0_addh_sc_tile_0/m1_843_n857# 0.22222f
C628 5v0_add_q_sc_0/5v0_half_adder_selector_sc_0/m1_n239_179# 5v0_addh_sc_tile_2/ctrl_over 0.00716f
C629 5v0_nter2oter_code_sc_0/nti 5v0_addh_sc_tile_2/nti 0.00237f
C630 5v0_addh_sc_tile_1/5v0_half_adder_selector_sc_0/res_stage0 5v0_addh_sc_tile_1/upstepper_test 0.27475f
C631 5v0_add_q_sc_0/ctrl_sign 5v0_add_q_sc_0/nti 0
C632 5v0_addh_sc_tile_0/inv_pti 5v0_addh_sc_tile_0/pti 0.44081f
C633 5v0_add_q_sc_0/a_n1373_n454# 5v0_add_q_sc_0/nti 0
C634 5v0_addh_sc_tile_1/inv_nti in_0_over 0
C635 5v0_addh_sc_tile_1/pti VDD_3V3_0 0.08682f
C636 5v0_addh_sc_tile_2/inv_nti 5v0_addh_sc_tile_2/downstepper_test 0.29987f
C637 5v0_addh_sc_tile_2/inv_nti 5v0_addh_sc_tile_2/a_n1778_n454# 0.00226f
C638 in_2 VDD_3V3_0 0.01316f
C639 5v0_add_q_sc_1/pti 5v0_add_q_sc_1/VDD_1V65 0.00115f
C640 5v0_add_q_sc_1/pti 5v0_addh_sc_tile_0/carry_0_probe 0
C641 VDD_3V3_1 VDD_1V65_2 0.01209f
C642 5v0_add_q_sc_1/ternary_input 5v0_addh_sc_tile_0/m1_103_293# 0
C643 5v0_addh_sc_tile_2/pti 5v0_addh_sc_tile_2/inv_pti 0.44081f
C644 5v0_addh_sc_tile_1/ternary_input 5v0_addh_sc_tile_1/5v0_half_adder_selector_sc_0/res_stage0 0.26626f
C645 5v0_add_q_sc_0/ternary_input 5v0_addh_sc_tile_1/pti 0
C646 5v0_addh_sc_tile_1/upstepper_test 5v0_addh_sc_tile_1/downstepper_test 0.38867f
C647 5v0_add_q_sc_0/upstepper_test VDD_3V3_0 0.55779f
C648 5v0_addh_sc_tile_2/a_n1205_n937# VDD_3V3_0 0.00891f
C649 5v0_addh_sc_tile_2/pti 5v0_addh_sc_tile_2/upstepper_test 0.02426f
C650 5v0_add_q_sc_1/5v0_half_adder_selector_sc_0/m1_n244_n517# 5v0_add_q_sc_1/ctrl_over 0.34508f
C651 5v0_nter2oter_code_sc_1/nti in_3 0
C652 5v0_addh_sc_tile_1/nti 5v0_addh_sc_tile_2/ctrl_sign 0.01236f
C653 5v0_addh_sc_tile_1/ternary_input 5v0_addh_sc_tile_1/downstepper_test 0.18203f
C654 in_0_over 5v0_addh_sc_tile_0/pti 0.10966f
C655 5v0_add_q_sc_0/ternary_input 5v0_add_q_sc_0/upstepper_test 0.02583f
C656 5v0_addh_sc_tile_1/inv_nti 5v0_addh_sc_tile_1/upstepper_test 0.00736f
C657 5v0_addh_sc_tile_0/inv_nti 5v0_addh_sc_tile_0/a_382_n1095# 0.28672f
C658 5v0_add_q_sc_0/pti 5v0_add_q_sc_0/downstepper_test 0.0825f
C659 5v0_add_q_sc_0/ctrl_sign VDD_3V3_0 0.8077f
C660 5v0_add_q_sc_0/a_n1373_n454# VDD_3V3_0 0.00122f
C661 5v0_nter2oter_code_sc_0/in in_3 0.01005f
C662 in_0_sign VDD_3V3_0 0
C663 5v0_addh_sc_tile_1/ternary_input 5v0_addh_sc_tile_1/inv_nti 0.28104f
C664 5v0_addh_sc_tile_2/inv_nti 5v0_nter2oter_code_sc_1/pti 0
C665 5v0_nter2oter_code_sc_0/in 5v0_addh_sc_tile_2/nti 0.00515f
C666 in_1 5v0_addh_sc_tile_0/pti 0.66373f
C667 5v0_add_q_sc_0/a_n1205_n937# 5v0_add_q_sc_0/nti 0
C668 5v0_addh_sc_tile_1/ctrl_sign 5v0_add_q_sc_1/ctrl_over 0.01552f
C669 5v0_add_q_sc_0/ternary_input 5v0_add_q_sc_0/ctrl_sign 0.00264f
C670 5v0_add_q_sc_0/a_n1373_n454# 5v0_add_q_sc_0/ternary_input 0.00136f
C671 5v0_addh_sc_tile_1/a_382_n1095# 5v0_add_q_sc_1/ctrl_over 0.08702f
C672 5v0_addh_sc_tile_1/ternary_input 5v0_add_q_sc_0/5v0_half_adder_selector_sc_0/m1_n239_179# 0
C673 5v0_addh_sc_tile_1/nti 5v0_addh_sc_tile_0/m1_103_293# 0
C674 5v0_addh_sc_tile_2/a_382_n1095# 5v0_addh_sc_tile_2/ctrl_sign 0.07412f
C675 5v0_addh_sc_tile_2/5v0_half_adder_selector_sc_0/5v0_tgate_sel_2_sc_1/input_A 5v0_addh_sc_tile_2/downstepper_test 0
C676 5v0_add_q_sc_1/pti 5v0_addh_sc_tile_1/pti 0
C677 5v0_nter2oter_code_sc_1/pti 5v0_addh_sc_tile_0/downstepper_test 0.00886f
C678 5v0_addh_sc_tile_1/ctrl_sign 5v0_addh_sc_tile_0/downstepper_test 0.01492f
C679 5v0_addh_sc_tile_2/inv_pti VDD_3V3_0 1.08712f
C680 5v0_addh_sc_tile_0/m1_103_293# 5v0_addh_sc_tile_0/carry_0_probe 0.01488f
C681 5v0_add_q_sc_1/nti 5v0_addh_sc_tile_0/a_382_n1095# 0
C682 5v0_nter2oter_code_sc_0/pti in_3 0.00219f
C683 5v0_addh_sc_tile_1/ctrl_sign VDD_1V65_0 0
C684 5v0_addh_sc_tile_2/inv_nti 5v0_addh_sc_tile_2/ctrl_over 0.26006f
C685 5v0_addh_sc_tile_1/ternary_input 5v0_addh_sc_tile_0/pti 0
C686 5v0_nter2oter_code_sc_0/pti 5v0_addh_sc_tile_2/nti 0
C687 5v0_addh_sc_tile_2/upstepper_test VDD_3V3_0 0.46517f
C688 5v0_add_q_sc_1/downstepper_test 5v0_add_q_sc_1/a_n1373_n454# 0.00442f
C689 5v0_addh_sc_tile_2/ctrl_sign 5v0_nter2oter_code_sc_0/gf180mcu_fd_sc_mcu7t5v0__nor2_1_0/a_224_472# 0
C690 5v0_addh_sc_tile_0/inv_pti 5v0_addh_sc_tile_0/downstepper_test 0.14186f
C691 5v0_add_q_sc_0/inv_nti 5v0_add_q_sc_0/inv_pti 0.08256f
C692 5v0_addh_sc_tile_1/ctrl_sign 5v0_addh_sc_tile_1/inv_pti 0.41772f
C693 5v0_nter2oter_code_sc_1/pti 5v0_addh_sc_tile_1/ctrl_over 0.20691f
C694 5v0_addh_sc_tile_1/a_382_n1095# 5v0_add_q_sc_0/5v0_half_adder_selector_sc_0/res_stage0 0.00175f
C695 5v0_addh_sc_tile_1/ctrl_sign 5v0_addh_sc_tile_1/ctrl_over 0.48056f
C696 5v0_add_q_sc_1/5v0_half_adder_selector_sc_0/5v0_tgate_sel_2_sc_1/input_A 5v0_add_q_sc_1/5v0_half_adder_selector_sc_0/res_stage0 0.00253f
C697 5v0_add_q_sc_1/5v0_half_adder_selector_sc_0/m1_n244_n517# 5v0_add_q_sc_1/ternary_input 0.07888f
C698 5v0_addh_sc_tile_1/a_n1373_n454# 5v0_addh_sc_tile_1/downstepper_test 0.00442f
C699 5v0_addh_sc_tile_0/inv_pti VDD_1V65_0 0.14775f
C700 VDD_1V65_5 5v0_add_q_sc_0/upstepper_test 0.16859f
C701 5v0_addh_sc_tile_1/a_382_n1095# 5v0_addh_sc_tile_1/inv_pti 0.00129f
C702 5v0_addh_sc_tile_0/a_382_n1095# 5v0_addh_sc_tile_0/m1_843_n857# 0.05013f
C703 5v0_addh_sc_tile_1/m1_103_293# VDD_3V3_0 0.14668f
C704 5v0_addh_sc_tile_1/ctrl_over 5v0_addh_sc_tile_1/a_382_n1095# 0.70472f
C705 5v0_addh_sc_tile_2/ctrl_sign 5v0_addh_sc_tile_1/pti 0
C706 5v0_add_q_sc_0/a_n1205_n937# VDD_3V3_0 0.00891f
C707 5v0_addh_sc_tile_2/ctrl_over 5v0_add_q_sc_0/5v0_half_adder_selector_sc_0/res_stage0 0.00474f
C708 5v0_addh_sc_tile_2/ctrl_sign in_2 0.0046f
C709 VDD_1V65_3 VDD_3V3_0 0.04264f
C710 5v0_add_q_sc_0/ternary_input 5v0_addh_sc_tile_1/m1_103_293# 0
C711 5v0_addh_sc_tile_2/ctrl_over 5v0_addh_sc_tile_1/inv_pti 0
C712 5v0_addh_sc_tile_0/m1_103_293# m1_n2844_n810# 0
C713 5v0_addh_sc_tile_1/a_n1373_n454# 5v0_addh_sc_tile_1/inv_nti 0
C714 5v0_addh_sc_tile_1/ctrl_over 5v0_addh_sc_tile_2/ctrl_over 0.02293f
C715 5v0_add_q_sc_0/ternary_input 5v0_add_q_sc_0/a_n1205_n937# 0
C716 5v0_addh_sc_tile_0/downstepper_test in_0_over 0.02344f
C717 5v0_nter2oter_code_sc_0/nti 5v0_nter2oter_code_sc_0/in 0.23186f
C718 5v0_add_q_sc_0/a_n1373_n454# VDD_1V65_5 0.00232f
C719 VDD_1V65_0 in_0_over 0.00145f
C720 5v0_addh_sc_tile_1/ctrl_sign 5v0_add_q_sc_1/ternary_input 0
C721 5v0_addh_sc_tile_1/nti 5v0_addh_sc_tile_2/downstepper_test 0
C722 in_0_over 5v0_addh_sc_tile_1/inv_pti 0.00926f
C723 5v0_addh_sc_tile_1/ctrl_over in_0_over 0
C724 5v0_addh_sc_tile_2/pti res_0 0
C725 5v0_addh_sc_tile_1/pti 5v0_addh_sc_tile_0/m1_103_293# 0.00135f
C726 5v0_addh_sc_tile_0/inv_pti 5v0_add_q_sc_1/ternary_input 0.00639f
C727 5v0_add_q_sc_1/downstepper_test 5v0_add_q_sc_1/a_n1205_n937# 0.00453f
C728 res_0 5v0_add_q_sc_0/ctrl_over 0
C729 5v0_addh_sc_tile_0/inv_nti 5v0_addh_sc_tile_0/a_n1205_n937# 0
C730 in_1 5v0_addh_sc_tile_0/downstepper_test 0.18203f
C731 5v0_addh_sc_tile_2/ctrl_sign 5v0_add_q_sc_0/ctrl_sign 0.27145f
C732 in_1 VDD_1V65_0 0.01451f
C733 5v0_addh_sc_tile_2/ctrl_over 5v0_addh_sc_tile_2/5v0_half_adder_selector_sc_0/5v0_tgate_sel_2_sc_1/input_A 0.04656f
C734 5v0_nter2oter_code_sc_0/nti 5v0_nter2oter_code_sc_0/pti 0.00234f
C735 5v0_addh_sc_tile_1/downstepper_test 5v0_addh_sc_tile_2/m1_103_293# 0.00921f
C736 5v0_addh_sc_tile_0/nti 5v0_addh_sc_tile_0/pti 0.24563f
C737 5v0_addh_sc_tile_1/ternary_input 5v0_add_q_sc_1/ctrl_over 0.00136f
C738 5v0_add_q_sc_0/ternary_input 5v0_add_q_sc_1/nti 0
C739 5v0_nter2oter_code_sc_1/nti 5v0_nter2oter_code_sc_0/in 0.00216f
C740 in_1 5v0_addh_sc_tile_1/ctrl_over 0
C741 5v0_addh_sc_tile_2/a_382_n1095# 5v0_addh_sc_tile_2/downstepper_test 0.00679f
C742 VDD_3V3_1 5v0_addh_sc_tile_0/a_382_n1095# 0.63349f
C743 5v0_addh_sc_tile_1/upstepper_test 5v0_addh_sc_tile_1/inv_pti 0.06901f
C744 5v0_addh_sc_tile_1/ctrl_over 5v0_addh_sc_tile_1/upstepper_test 0.0043f
C745 5v0_addh_sc_tile_1/ternary_input 5v0_addh_sc_tile_0/downstepper_test 0.00308f
C746 5v0_addh_sc_tile_1/inv_nti 5v0_addh_sc_tile_2/m1_103_293# 0.00513f
C747 5v0_addh_sc_tile_2/inv_nti 5v0_addh_sc_tile_2/5v0_half_adder_selector_sc_0/res_stage0 0.02878f
C748 5v0_add_q_sc_0/inv_nti 5v0_add_q_sc_0/nti 0.20874f
C749 5v0_add_q_sc_0/5v0_half_adder_selector_sc_0/5v0_tgate_sel_2_sc_1/input_A 5v0_add_q_sc_0/upstepper_test 0
C750 5v0_addh_sc_tile_2/ctrl_sign 5v0_addh_sc_tile_2/inv_pti 0.28426f
C751 5v0_addh_sc_tile_0/inv_nti 5v0_addh_sc_tile_0/a_n1373_n454# 0
C752 5v0_add_q_sc_0/a_n1205_n937# VDD_1V65_5 0.00354f
C753 5v0_nter2oter_code_sc_1/pti 5v0_addh_sc_tile_1/nti 0
C754 5v0_addh_sc_tile_1/ternary_input 5v0_addh_sc_tile_1/inv_pti 0.05503f
C755 5v0_addh_sc_tile_1/ctrl_sign 5v0_addh_sc_tile_1/nti 0.146f
C756 5v0_addh_sc_tile_1/ternary_input 5v0_addh_sc_tile_1/ctrl_over 0.25964f
C757 5v0_addh_sc_tile_2/ctrl_sign 5v0_addh_sc_tile_2/upstepper_test 0.15846f
C758 in_0_sign 5v0_addh_sc_tile_0/m1_103_293# 0.60072f
C759 5v0_add_q_sc_0/5v0_half_adder_selector_sc_0/m1_n244_n517# 5v0_add_q_sc_0/downstepper_test 0.00507f
C760 5v0_addh_sc_tile_2/pti res_c 0
C761 5v0_addh_sc_tile_1/ctrl_sign 5v0_addh_sc_tile_0/carry_0_probe 0.02298f
C762 5v0_addh_sc_tile_1/nti 5v0_addh_sc_tile_1/a_382_n1095# 0
C763 5v0_addh_sc_tile_0/5v0_half_adder_selector_sc_0/res_stage0 5v0_addh_sc_tile_0/pti 0.01078f
C764 5v0_addh_sc_tile_1/a_382_n1095# 5v0_add_q_sc_1/VDD_1V65 0
C765 res_0 VDD_3V3_0 0.09575f
C766 res_c 5v0_add_q_sc_0/ctrl_over 0.20178f
C767 5v0_addh_sc_tile_1/a_382_n1095# 5v0_addh_sc_tile_0/carry_0_probe 0
C768 5v0_addh_sc_tile_0/inv_pti 5v0_addh_sc_tile_0/carry_0_probe 0.01451f
C769 5v0_add_q_sc_0/inv_pti 5v0_add_q_sc_0/ctrl_over 0
C770 5v0_add_q_sc_0/5v0_half_adder_selector_sc_0/5v0_tgate_sel_2_sc_1/input_A 5v0_add_q_sc_0/ctrl_sign 0
C771 res_c 5v0_add_q_sc_0/nti 0
C772 5v0_addh_sc_tile_1/nti 5v0_addh_sc_tile_2/ctrl_over 0.00207f
C773 5v0_addh_sc_tile_2/ctrl_sign 5v0_addh_sc_tile_0/inv_nti 0
C774 5v0_add_q_sc_1/5v0_half_adder_selector_sc_0/res_stage0 5v0_add_q_sc_1/nti 0.00372f
C775 5v0_add_q_sc_1/pti 5v0_add_q_sc_1/nti 0.15563f
C776 5v0_nter2oter_code_sc_0/pti 5v0_nter2oter_code_sc_0/in 0.58802f
C777 5v0_add_q_sc_0/inv_pti 5v0_add_q_sc_0/nti 0.21873f
C778 VDD_1V65_3 5v0_addh_sc_tile_2/ctrl_sign 0
C779 5v0_addh_sc_tile_2/a_n1205_n937# 5v0_addh_sc_tile_2/downstepper_test 0.00453f
C780 5v0_add_q_sc_1/inv_nti 5v0_add_q_sc_1/a_n1778_n454# 0.00214f
C781 5v0_add_q_sc_0/inv_nti VDD_3V3_0 0.56502f
C782 5v0_addh_sc_tile_1/nti in_0_over 0.00205f
C783 5v0_addh_sc_tile_0/5v0_half_adder_selector_sc_0/5v0_tgate_sel_2_sc_1/input_A 5v0_addh_sc_tile_0/downstepper_test 0
C784 VDD_3V3_1 VDD_3V3_0 0.00212f
C785 5v0_addh_sc_tile_1/ctrl_sign m1_n2844_n810# 0.00105f
C786 5v0_addh_sc_tile_1/5v0_half_adder_selector_sc_0/res_stage0 5v0_addh_sc_tile_1/a_n1205_n937# 0
C787 in_0_over 5v0_addh_sc_tile_0/carry_0_probe 0.12282f
C788 5v0_add_q_sc_1/5v0_half_adder_selector_sc_0/m1_n239_179# 5v0_add_q_sc_1/inv_pti 0
C789 5v0_add_q_sc_1/5v0_half_adder_selector_sc_0/m1_n244_n517# 5v0_add_q_sc_1/5v0_half_adder_selector_sc_0/5v0_tgate_sel_2_sc_1/input_A 0.02928f
C790 5v0_add_q_sc_0/inv_nti 5v0_add_q_sc_0/ternary_input 0.02537f
C791 5v0_addh_sc_tile_0/nti 5v0_addh_sc_tile_0/downstepper_test 0.06935f
C792 5v0_addh_sc_tile_0/inv_pti m1_n2844_n810# 0.00753f
C793 5v0_addh_sc_tile_0/inv_nti 5v0_addh_sc_tile_0/m1_103_293# 0.35313f
C794 5v0_addh_sc_tile_2/a_n1373_n454# 5v0_addh_sc_tile_2/inv_pti 0.00135f
C795 5v0_addh_sc_tile_2/downstepper_test 5v0_add_q_sc_0/ctrl_sign 0
C796 5v0_addh_sc_tile_2/5v0_half_adder_selector_sc_0/res_stage0 5v0_addh_sc_tile_2/5v0_half_adder_selector_sc_0/5v0_tgate_sel_2_sc_1/input_A 0.00253f
C797 5v0_addh_sc_tile_1/a_n1373_n454# 5v0_addh_sc_tile_1/inv_pti 0.00135f
C798 VDD_3V3_1 5v0_add_q_sc_0/ternary_input 0.20806f
C799 5v0_addh_sc_tile_2/a_382_n1095# 5v0_addh_sc_tile_2/ctrl_over 0.69037f
C800 VDD_1V65_0 5v0_addh_sc_tile_0/nti 0.21326f
C801 5v0_addh_sc_tile_2/a_n1373_n454# 5v0_addh_sc_tile_2/upstepper_test 0
C802 5v0_addh_sc_tile_1/a_n1205_n937# 5v0_addh_sc_tile_1/downstepper_test 0.00453f
C803 in_1 5v0_addh_sc_tile_1/nti 0.00579f
C804 res_c VDD_3V3_0 0.09697f
C805 5v0_addh_sc_tile_1/ctrl_over 5v0_addh_sc_tile_0/nti 0
C806 5v0_addh_sc_tile_1/ctrl_sign 5v0_addh_sc_tile_1/pti 0.48393f
C807 5v0_nter2oter_code_sc_1/pti in_2 0.46547f
C808 5v0_addh_sc_tile_2/inv_nti VDD_1V65_4 0.08611f
C809 5v0_addh_sc_tile_2/inv_nti 5v0_addh_sc_tile_2/m1_843_n857# 0.36668f
C810 5v0_addh_sc_tile_1/ctrl_sign in_2 0.16477f
C811 5v0_add_q_sc_0/inv_pti VDD_3V3_0 0.40694f
C812 in_1 5v0_addh_sc_tile_0/carry_0_probe 0.00136f
C813 5v0_add_q_sc_1/downstepper_test 5v0_add_q_sc_1/inv_nti 0.17947f
C814 5v0_addh_sc_tile_2/ctrl_over 5v0_nter2oter_code_sc_0/gf180mcu_fd_sc_mcu7t5v0__nor2_1_0/a_224_472# 0.0326f
C815 5v0_addh_sc_tile_1/a_382_n1095# 5v0_addh_sc_tile_1/pti 0.12627f
C816 5v0_addh_sc_tile_1/nti 5v0_addh_sc_tile_1/upstepper_test 0.11981f
C817 VDD_3V3_1 5v0_addh_sc_tile_0/a_n1205_n937# 0.00891f
C818 5v0_addh_sc_tile_0/inv_pti in_2 0.00153f
C819 res_c 5v0_add_q_sc_0/ternary_input 0.167f
C820 5v0_addh_sc_tile_1/ctrl_sign 5v0_add_q_sc_0/upstepper_test 0
C821 5v0_addh_sc_tile_1/upstepper_test 5v0_addh_sc_tile_0/carry_0_probe 0.02787f
C822 5v0_addh_sc_tile_2/inv_nti 5v0_addh_sc_tile_2/m1_103_293# 0.35313f
C823 5v0_addh_sc_tile_1/a_n1205_n937# 5v0_addh_sc_tile_1/inv_nti 0
C824 5v0_addh_sc_tile_0/pti 5v0_addh_sc_tile_0/upstepper_test 0.02426f
C825 5v0_add_q_sc_1/ctrl_sign 5v0_addh_sc_tile_1/5v0_half_adder_selector_sc_0/res_stage0 0
C826 in_0_over m1_n2844_n810# 0.00329f
C827 5v0_add_q_sc_0/inv_pti 5v0_add_q_sc_0/ternary_input 0.08665f
C828 5v0_add_q_sc_1/downstepper_test 5v0_addh_sc_tile_1/inv_nti 0.00441f
C829 5v0_addh_sc_tile_2/pti 5v0_add_q_sc_0/ctrl_over 0.1334f
C830 5v0_addh_sc_tile_2/downstepper_test 5v0_addh_sc_tile_2/inv_pti 0.13388f
C831 5v0_addh_sc_tile_1/a_382_n1095# 5v0_add_q_sc_0/upstepper_test 0.0104f
C832 5v0_addh_sc_tile_1/ternary_input 5v0_addh_sc_tile_1/nti 0.54752f
C833 5v0_addh_sc_tile_2/ctrl_over 5v0_addh_sc_tile_1/pti 0
C834 5v0_addh_sc_tile_2/ctrl_over in_2 0
C835 5v0_addh_sc_tile_2/upstepper_test 5v0_addh_sc_tile_2/downstepper_test 0.38555f
C836 5v0_addh_sc_tile_0/5v0_half_adder_selector_sc_0/res_stage0 5v0_addh_sc_tile_0/downstepper_test 0.25483f
C837 5v0_addh_sc_tile_2/a_n1778_n454# 5v0_addh_sc_tile_2/upstepper_test 0
C838 5v0_addh_sc_tile_1/ternary_input 5v0_addh_sc_tile_0/carry_0_probe 0.00236f
C839 5v0_addh_sc_tile_1/inv_pti 5v0_addh_sc_tile_2/m1_843_n857# 0
C840 5v0_addh_sc_tile_1/ctrl_over VDD_1V65_4 0
C841 5v0_nter2oter_code_sc_1/gf180mcu_fd_sc_mcu7t5v0__nor2_1_0/a_224_472# VDD_3V3_0 0.0165f
C842 5v0_add_q_sc_0/ctrl_over 5v0_add_q_sc_0/nti 0.00167f
C843 5v0_add_q_sc_1/ctrl_sign 5v0_addh_sc_tile_1/downstepper_test 0
C844 5v0_addh_sc_tile_0/carry_sign_probe 5v0_addh_sc_tile_0/pti 0.01168f
C845 5v0_addh_sc_tile_0/m1_103_293# 5v0_addh_sc_tile_0/m1_843_n857# 0.20659f
C846 5v0_add_q_sc_1/downstepper_test 5v0_add_q_sc_1/inv_pti 0.07669f
C847 5v0_addh_sc_tile_2/ctrl_over 5v0_add_q_sc_0/upstepper_test 0.00252f
C848 5v0_addh_sc_tile_1/ctrl_sign 5v0_add_q_sc_0/ctrl_sign 0
C849 5v0_addh_sc_tile_0/5v0_half_adder_selector_sc_0/res_stage0 5v0_addh_sc_tile_1/ctrl_over 0
C850 5v0_add_q_sc_1/ctrl_sign 5v0_add_q_sc_1/inv_nti 0.10096f
C851 in_0_over 5v0_addh_sc_tile_1/pti 0.00417f
C852 5v0_addh_sc_tile_2/ctrl_over 5v0_addh_sc_tile_2/a_n1205_n937# 0
C853 VDD_3V3_1 5v0_add_q_sc_1/5v0_half_adder_selector_sc_0/res_stage0 0.14945f
C854 VDD_3V3_1 5v0_add_q_sc_1/pti 0.56896f
C855 5v0_add_q_sc_0/inv_nti VDD_1V65_5 0.01114f
C856 5v0_addh_sc_tile_1/nti 5v0_addh_sc_tile_2/5v0_half_adder_selector_sc_0/res_stage0 0
C857 5v0_addh_sc_tile_1/inv_pti 5v0_addh_sc_tile_2/m1_103_293# 0
C858 5v0_addh_sc_tile_1/ctrl_sign in_0_sign 0
C859 VDD_3V3_1 5v0_addh_sc_tile_0/a_n1373_n454# 0.00122f
C860 5v0_addh_sc_tile_1/a_382_n1095# 5v0_add_q_sc_0/ctrl_sign 0.0169f
C861 5v0_addh_sc_tile_1/ctrl_over 5v0_addh_sc_tile_2/m1_103_293# 0
C862 5v0_addh_sc_tile_1/upstepper_test m1_n2844_n810# 0.00447f
C863 5v0_add_q_sc_1/ctrl_sign 5v0_addh_sc_tile_1/inv_nti 0.05407f
C864 5v0_addh_sc_tile_0/inv_pti in_0_sign 0.23041f
C865 5v0_addh_sc_tile_1/ternary_input 5v0_addh_sc_tile_2/a_382_n1095# 0
C866 5v0_addh_sc_tile_1/m1_843_n857# 5v0_addh_sc_tile_1/inv_nti 0.36668f
C867 5v0_add_q_sc_1/5v0_half_adder_selector_sc_0/m1_n239_179# 5v0_add_q_sc_1/ctrl_over 0.00258f
C868 5v0_addh_sc_tile_2/ctrl_over 5v0_add_q_sc_0/ctrl_sign 0.2177f
C869 in_1 in_2 0
C870 5v0_addh_sc_tile_1/ctrl_sign 5v0_addh_sc_tile_2/inv_pti 0.00272f
C871 5v0_add_q_sc_1/ctrl_sign 5v0_add_q_sc_1/inv_pti 0.05919f
C872 VDD_3V3_1 5v0_addh_sc_tile_2/ctrl_sign 0.00526f
C873 5v0_add_q_sc_1/inv_pti 5v0_addh_sc_tile_1/m1_843_n857# 0
C874 5v0_addh_sc_tile_2/pti VDD_3V3_0 0.71212f
C875 5v0_add_q_sc_0/inv_pti VDD_1V65_5 0.14775f
C876 5v0_addh_sc_tile_0/a_382_n1095# VDD_3V3_0 0
C877 5v0_addh_sc_tile_1/upstepper_test 5v0_addh_sc_tile_1/pti 0.02161f
C878 5v0_addh_sc_tile_2/a_382_n1095# 5v0_addh_sc_tile_2/5v0_half_adder_selector_sc_0/res_stage0 0.08951f
C879 5v0_addh_sc_tile_1/nti 5v0_addh_sc_tile_1/a_n1373_n454# 0
C880 5v0_addh_sc_tile_0/5v0_half_adder_selector_sc_0/5v0_tgate_sel_2_sc_1/input_A 5v0_addh_sc_tile_0/carry_0_probe 0
C881 5v0_add_q_sc_0/ctrl_over VDD_3V3_0 0.96278f
C882 5v0_add_q_sc_1/ctrl_sign 5v0_addh_sc_tile_0/pti 0.00768f
C883 5v0_add_q_sc_0/pti 5v0_add_q_sc_0/a_n1778_n454# 0.00135f
C884 5v0_addh_sc_tile_2/pti 5v0_add_q_sc_0/ternary_input 0.00188f
C885 in_0_sign in_0_over 0.05861f
C886 5v0_addh_sc_tile_1/ctrl_sign 5v0_addh_sc_tile_1/m1_103_293# 0.60951f
C887 VDD_3V3_0 5v0_add_q_sc_0/nti 0.63773f
C888 5v0_addh_sc_tile_1/ternary_input 5v0_addh_sc_tile_1/pti 0.67368f
C889 5v0_addh_sc_tile_1/ternary_input in_2 0.02385f
C890 5v0_nter2oter_code_sc_1/pti 5v0_addh_sc_tile_0/inv_nti 0.00571f
C891 5v0_addh_sc_tile_0/nti 5v0_addh_sc_tile_0/carry_0_probe 0
C892 5v0_addh_sc_tile_2/ctrl_over 5v0_addh_sc_tile_2/inv_pti 0.0554f
C893 5v0_add_q_sc_0/ternary_input 5v0_add_q_sc_0/ctrl_over 0.15554f
C894 5v0_addh_sc_tile_1/ctrl_sign 5v0_addh_sc_tile_0/inv_nti 0.02847f
C895 5v0_addh_sc_tile_1/a_382_n1095# 5v0_addh_sc_tile_1/m1_103_293# 0.07764f
C896 5v0_addh_sc_tile_0/downstepper_test 5v0_addh_sc_tile_0/upstepper_test 0.38867f
C897 5v0_add_q_sc_1/5v0_half_adder_selector_sc_0/m1_n244_n517# 5v0_add_q_sc_1/nti 0
C898 5v0_addh_sc_tile_2/ctrl_over 5v0_addh_sc_tile_2/upstepper_test 0.16997f
C899 VDD_1V65_0 5v0_addh_sc_tile_0/upstepper_test 0.16859f
C900 5v0_add_q_sc_0/ternary_input 5v0_add_q_sc_0/nti 0.62238f
C901 VDD_3V3_1 5v0_addh_sc_tile_0/m1_103_293# 0.73472f
C902 5v0_addh_sc_tile_0/inv_pti 5v0_addh_sc_tile_0/inv_nti 0.25737f
C903 5v0_addh_sc_tile_1/ctrl_over 5v0_addh_sc_tile_0/upstepper_test 0
C904 in_1 in_0_sign 0
C905 5v0_add_q_sc_1/downstepper_test 5v0_add_q_sc_1/ctrl_over 0.12191f
C906 5v0_addh_sc_tile_0/downstepper_test 5v0_addh_sc_tile_0/carry_sign_probe 0
C907 5v0_add_q_sc_1/5v0_half_adder_selector_sc_0/m1_n239_179# 5v0_add_q_sc_1/ternary_input 0.00189f
C908 5v0_addh_sc_tile_1/ternary_input 5v0_add_q_sc_0/ctrl_sign 0.00787f
C909 5v0_addh_sc_tile_2/5v0_half_adder_selector_sc_0/res_stage0 5v0_addh_sc_tile_2/a_n1205_n937# 0
C910 5v0_nter2oter_code_sc_1/gf180mcu_fd_sc_mcu7t5v0__nor2_1_0/a_224_472# 5v0_addh_sc_tile_2/ctrl_sign 0.00629f
C911 5v0_addh_sc_tile_1/ctrl_sign 5v0_add_q_sc_1/nti 0.00138f
C912 5v0_addh_sc_tile_1/nti 5v0_addh_sc_tile_2/m1_103_293# 0.00116f
C913 res_0 5v0_addh_sc_tile_2/downstepper_test 0.00302f
C914 5v0_addh_sc_tile_1/ternary_input in_0_sign 0
C915 5v0_addh_sc_tile_1/a_382_n1095# 5v0_add_q_sc_1/nti 0
C916 in_0_over 5v0_addh_sc_tile_0/inv_nti 0.21462f
C917 5v0_addh_sc_tile_1/ctrl_over 5v0_addh_sc_tile_1/a_n1205_n937# 0.00169f
C918 5v0_add_q_sc_1/pti 5v0_addh_sc_tile_0/a_382_n1095# 0
C919 5v0_addh_sc_tile_0/inv_pti 5v0_add_q_sc_1/nti 0
C920 5v0_add_q_sc_1/downstepper_test 5v0_addh_sc_tile_1/inv_pti 0.00756f
C921 5v0_add_q_sc_1/ternary_input 5v0_add_q_sc_1/a_n1778_n454# 0.00116f
C922 5v0_addh_sc_tile_1/ctrl_sign 5v0_addh_sc_tile_0/m1_843_n857# 0
C923 5v0_addh_sc_tile_1/a_n1373_n454# 5v0_addh_sc_tile_1/pti 0
C924 5v0_add_q_sc_0/pti 5v0_add_q_sc_1/ctrl_over 0.00513f
C925 5v0_add_q_sc_0/ternary_input VDD_3V3_0 1.58777f
C926 5v0_add_q_sc_1/ctrl_sign 5v0_add_q_sc_1/ctrl_over 0.02923f
C927 5v0_addh_sc_tile_1/m1_843_n857# 5v0_add_q_sc_1/ctrl_over 0.18406f
C928 5v0_add_q_sc_0/ctrl_over VDD_1V65_5 0
C929 5v0_nter2oter_code_sc_1/nti 5v0_addh_sc_tile_1/downstepper_test 0
C930 5v0_addh_sc_tile_2/a_382_n1095# 5v0_addh_sc_tile_2/m1_843_n857# 0.05013f
C931 5v0_addh_sc_tile_0/nti in_2 0.0018f
C932 5v0_nter2oter_code_sc_0/in 5v0_addh_sc_tile_1/5v0_half_adder_selector_sc_0/res_stage0 0.1871f
C933 5v0_addh_sc_tile_0/inv_pti 5v0_addh_sc_tile_0/m1_843_n857# 0
C934 VDD_1V65_5 5v0_add_q_sc_0/nti 0.21326f
C935 5v0_addh_sc_tile_1/ternary_input 5v0_addh_sc_tile_2/inv_pti 0
C936 in_1 5v0_addh_sc_tile_0/inv_nti 0.28245f
C937 5v0_addh_sc_tile_2/inv_nti in_3 0.28245f
C938 5v0_addh_sc_tile_1/upstepper_test 5v0_addh_sc_tile_1/m1_103_293# 0.07773f
C939 5v0_addh_sc_tile_1/ternary_input 5v0_addh_sc_tile_2/upstepper_test 0
C940 5v0_addh_sc_tile_2/inv_nti 5v0_addh_sc_tile_2/nti 0.22786f
C941 5v0_addh_sc_tile_2/a_382_n1095# 5v0_addh_sc_tile_2/m1_103_293# 0.07764f
C942 5v0_add_q_sc_1/ternary_input 5v0_addh_sc_tile_0/carry_sign_probe 0.05455f
C943 5v0_addh_sc_tile_2/pti 5v0_addh_sc_tile_2/ctrl_sign 0.28211f
C944 5v0_nter2oter_code_sc_1/nti 5v0_addh_sc_tile_1/inv_nti 0.00264f
C945 in_0_over 5v0_add_q_sc_1/nti 0.00117f
C946 5v0_nter2oter_code_sc_0/in 5v0_addh_sc_tile_1/downstepper_test 0.03365f
C947 VDD_1V65_3 5v0_addh_sc_tile_1/upstepper_test 0.16859f
C948 5v0_addh_sc_tile_1/ctrl_over 5v0_add_q_sc_0/pti 0.00209f
C949 5v0_addh_sc_tile_2/ctrl_sign 5v0_add_q_sc_0/ctrl_over 0.00758f
C950 5v0_add_q_sc_1/ctrl_sign 5v0_addh_sc_tile_1/inv_pti 0.12531f
C951 5v0_addh_sc_tile_1/m1_843_n857# 5v0_addh_sc_tile_1/inv_pti 0
C952 5v0_addh_sc_tile_1/ternary_input 5v0_addh_sc_tile_1/m1_103_293# 0
C953 5v0_add_q_sc_1/ctrl_sign 5v0_addh_sc_tile_1/ctrl_over 0
C954 5v0_add_q_sc_1/5v0_half_adder_selector_sc_0/m1_n244_n517# VDD_3V3_1 0.28925f
C955 5v0_addh_sc_tile_1/ctrl_over 5v0_addh_sc_tile_1/m1_843_n857# 0.10251f
C956 5v0_add_q_sc_1/downstepper_test 5v0_add_q_sc_1/ternary_input 0.16195f
C957 5v0_addh_sc_tile_2/5v0_half_adder_selector_sc_0/res_stage0 5v0_addh_sc_tile_2/inv_pti 0.01003f
C958 5v0_addh_sc_tile_1/ternary_input 5v0_addh_sc_tile_0/inv_nti 0.0179f
C959 5v0_addh_sc_tile_0/5v0_half_adder_selector_sc_0/5v0_tgate_sel_2_sc_1/input_A in_0_sign 0
C960 in_0_over 5v0_addh_sc_tile_0/m1_843_n857# 0.09998f
C961 5v0_addh_sc_tile_2/5v0_half_adder_selector_sc_0/res_stage0 5v0_addh_sc_tile_2/upstepper_test 0.27475f
C962 5v0_addh_sc_tile_1/ternary_input VDD_1V65_3 0.01451f
C963 5v0_nter2oter_code_sc_0/in 5v0_addh_sc_tile_1/inv_nti 0.01488f
C964 5v0_addh_sc_tile_1/ctrl_over in_3 0
C965 5v0_addh_sc_tile_1/ctrl_over 5v0_addh_sc_tile_2/nti 0
C966 5v0_addh_sc_tile_0/nti in_0_sign 0
C967 5v0_add_q_sc_1/a_n1778_n454# 5v0_add_q_sc_1/VDD_1V65 0
C968 5v0_addh_sc_tile_1/pti 5v0_addh_sc_tile_2/m1_103_293# 0
C969 5v0_add_q_sc_0/5v0_half_adder_selector_sc_0/m1_n244_n517# 5v0_add_q_sc_0/5v0_half_adder_selector_sc_0/m1_n239_179# 0.00585f
C970 5v0_addh_sc_tile_1/inv_nti 5v0_add_q_sc_0/downstepper_test 0
C971 5v0_addh_sc_tile_0/m1_103_293# 5v0_addh_sc_tile_0/a_382_n1095# 0.07764f
C972 VDD_1V65_5 VDD_3V3_0 0.04709f
C973 5v0_addh_sc_tile_0/upstepper_test 5v0_addh_sc_tile_0/carry_0_probe 0
C974 VDD_1V65_4 5v0_addh_sc_tile_2/a_n1205_n937# 0.00354f
C975 res_0 5v0_addh_sc_tile_2/ctrl_over 0.20137f
C976 in_1 5v0_addh_sc_tile_0/m1_843_n857# 0
C977 VDD_3V3_1 5v0_nter2oter_code_sc_1/pti 0.29062f
C978 5v0_addh_sc_tile_1/ctrl_sign VDD_3V3_1 0.86538f
C979 5v0_add_q_sc_0/ternary_input 5v0_add_q_sc_1/5v0_half_adder_selector_sc_0/res_stage0 0.17113f
C980 5v0_add_q_sc_1/ctrl_sign 5v0_add_q_sc_1/ternary_input 0.20636f
C981 5v0_add_q_sc_0/5v0_half_adder_selector_sc_0/m1_n239_179# 5v0_add_q_sc_0/downstepper_test 0.09961f
C982 5v0_add_q_sc_0/ternary_input VDD_1V65_5 0.03394f
C983 5v0_addh_sc_tile_1/upstepper_test 5v0_addh_sc_tile_0/m1_843_n857# 0.00724f
C984 VDD_3V3_1 5v0_addh_sc_tile_1/a_382_n1095# 0.02507f
C985 5v0_addh_sc_tile_1/5v0_half_adder_selector_sc_0/5v0_tgate_sel_2_sc_1/input_A VDD_3V3_0 0.02871f
C986 VDD_3V3_1 5v0_addh_sc_tile_0/inv_pti 1.05126f
C987 5v0_addh_sc_tile_1/nti 5v0_addh_sc_tile_1/a_n1205_n937# 0
C988 5v0_add_q_sc_0/ctrl_sign 5v0_addh_sc_tile_2/m1_843_n857# 0.00871f
C989 5v0_addh_sc_tile_0/carry_sign_probe 5v0_addh_sc_tile_0/carry_0_probe 0.0594f
C990 5v0_addh_sc_tile_2/pti 5v0_addh_sc_tile_2/a_n1373_n454# 0
C991 5v0_addh_sc_tile_2/ctrl_sign VDD_3V3_0 1.61336f
C992 5v0_add_q_sc_0/5v0_half_adder_selector_sc_0/5v0_tgate_sel_2_sc_1/input_A 5v0_add_q_sc_0/ctrl_over 0.04656f
C993 5v0_add_q_sc_0/a_n1778_n454# 5v0_add_q_sc_0/downstepper_test 0.0031f
C994 5v0_addh_sc_tile_1/ternary_input 5v0_addh_sc_tile_0/m1_843_n857# 0
C995 VDD_3V3_1 5v0_addh_sc_tile_2/ctrl_over 0.00186f
C996 5v0_add_q_sc_1/downstepper_test 5v0_add_q_sc_1/VDD_1V65 0.13024f
C997 5v0_addh_sc_tile_0/5v0_half_adder_selector_sc_0/res_stage0 in_0_sign 0.22359f
C998 5v0_addh_sc_tile_1/ctrl_sign 5v0_add_q_sc_0/inv_pti 0
C999 5v0_addh_sc_tile_2/m1_103_293# 5v0_add_q_sc_0/ctrl_sign 0.21173f
C1000 5v0_addh_sc_tile_0/a_n1778_n454# in_1 0.00182f
C1001 5v0_addh_sc_tile_2/ctrl_sign 5v0_add_q_sc_0/ternary_input 0
C1002 5v0_add_q_sc_0/inv_pti 5v0_addh_sc_tile_1/a_382_n1095# 0
C1003 VDD_1V65_3 5v0_addh_sc_tile_1/a_n1373_n454# 0.00232f
C1004 5v0_addh_sc_tile_0/nti 5v0_addh_sc_tile_0/inv_nti 0.22786f
C1005 VDD_3V3_1 in_0_over 0.64118f
C1006 VDD_1V65_4 5v0_addh_sc_tile_2/inv_pti 0.14775f
C1007 5v0_addh_sc_tile_2/m1_843_n857# 5v0_addh_sc_tile_2/inv_pti 0
C1008 5v0_addh_sc_tile_2/ctrl_over res_c 0.00127f
C1009 5v0_add_q_sc_1/inv_nti 5v0_add_q_sc_1/a_n1373_n454# 0
C1010 5v0_nter2oter_code_sc_0/nti 5v0_addh_sc_tile_1/ctrl_over 0
C1011 5v0_addh_sc_tile_2/pti 5v0_addh_sc_tile_2/downstepper_test 0.20149f
C1012 5v0_addh_sc_tile_1/pti 5v0_add_q_sc_1/a_n1778_n454# 0
C1013 5v0_addh_sc_tile_2/pti 5v0_addh_sc_tile_2/a_n1778_n454# 0.00135f
C1014 5v0_addh_sc_tile_0/carry_sign_probe m1_n2844_n810# 0.12483f
C1015 5v0_add_q_sc_0/inv_pti 5v0_addh_sc_tile_2/ctrl_over 0
C1016 in_2 5v0_addh_sc_tile_0/upstepper_test 0
C1017 5v0_addh_sc_tile_2/upstepper_test VDD_1V65_4 0.16859f
C1018 5v0_addh_sc_tile_2/m1_103_293# 5v0_addh_sc_tile_2/inv_pti 0.17639f
C1019 5v0_nter2oter_code_sc_1/gf180mcu_fd_sc_mcu7t5v0__nor2_1_0/a_224_472# 5v0_addh_sc_tile_1/ctrl_sign 0.02563f
C1020 5v0_add_q_sc_1/ctrl_sign 5v0_add_q_sc_1/VDD_1V65 0
C1021 5v0_add_q_sc_1/ctrl_sign 5v0_addh_sc_tile_0/carry_0_probe 0.01576f
C1022 VDD_3V3_1 in_1 1.00116f
C1023 5v0_addh_sc_tile_2/upstepper_test 5v0_addh_sc_tile_2/m1_103_293# 0.07773f
C1024 5v0_addh_sc_tile_2/inv_nti 5v0_add_q_sc_0/5v0_half_adder_selector_sc_0/m1_n244_n517# 0
C1025 5v0_nter2oter_code_sc_1/nti 5v0_addh_sc_tile_0/downstepper_test 0
C1026 5v0_add_q_sc_0/5v0_half_adder_selector_sc_0/5v0_tgate_sel_2_sc_1/input_A VDD_3V3_0 0.02871f
C1027 5v0_addh_sc_tile_2/inv_nti 5v0_nter2oter_code_sc_0/in 0
C1028 5v0_nter2oter_code_sc_1/nti VDD_1V65_0 0
C1029 VDD_3V3_1 5v0_addh_sc_tile_1/upstepper_test 0.39457f
C1030 5v0_addh_sc_tile_2/a_n1373_n454# VDD_3V3_0 0.00122f
C1031 5v0_nter2oter_code_sc_0/in 5v0_add_q_sc_1/ctrl_over 0
C1032 5v0_addh_sc_tile_0/5v0_half_adder_selector_sc_0/res_stage0 5v0_addh_sc_tile_0/inv_nti 0.02878f
C1033 5v0_add_q_sc_1/a_n1373_n454# 5v0_add_q_sc_1/inv_pti 0.00135f
C1034 res_0 5v0_addh_sc_tile_2/5v0_half_adder_selector_sc_0/res_stage0 0.08533f
C1035 5v0_nter2oter_code_sc_1/nti 5v0_addh_sc_tile_1/ctrl_over 0.08789f
C1036 5v0_addh_sc_tile_2/inv_nti 5v0_add_q_sc_0/downstepper_test 0
C1037 5v0_add_q_sc_1/ctrl_over 5v0_add_q_sc_0/downstepper_test 0.0085f
C1038 5v0_addh_sc_tile_1/upstepper_test 5v0_addh_sc_tile_1/a_n1778_n454# 0
C1039 5v0_add_q_sc_1/downstepper_test 5v0_addh_sc_tile_1/pti 0.00147f
C1040 VDD_3V3_1 5v0_addh_sc_tile_1/ternary_input 1.22316f
C1041 5v0_add_q_sc_0/5v0_half_adder_selector_sc_0/m1_n244_n517# 5v0_add_q_sc_0/5v0_half_adder_selector_sc_0/res_stage0 0.08646f
C1042 5v0_addh_sc_tile_2/pti 5v0_nter2oter_code_sc_1/pti 0.00125f
C1043 in_0_sign 5v0_addh_sc_tile_0/upstepper_test 0.08746f
C1044 5v0_addh_sc_tile_1/ctrl_sign 5v0_addh_sc_tile_2/pti 0
C1045 5v0_add_q_sc_1/ctrl_sign m1_n2844_n810# 0.00441f
C1046 5v0_addh_sc_tile_1/ctrl_sign 5v0_addh_sc_tile_0/a_382_n1095# 0.01186f
C1047 5v0_addh_sc_tile_1/ternary_input 5v0_addh_sc_tile_1/a_n1778_n454# 0.00182f
C1048 5v0_add_q_sc_1/inv_nti 5v0_add_q_sc_1/a_n1205_n937# 0
C1049 5v0_addh_sc_tile_2/a_382_n1095# in_3 0.09307f
C1050 5v0_nter2oter_code_sc_0/in 5v0_addh_sc_tile_1/inv_pti 0.00119f
C1051 5v0_add_q_sc_1/downstepper_test 5v0_add_q_sc_1/5v0_half_adder_selector_sc_0/5v0_tgate_sel_2_sc_1/input_A 0
C1052 5v0_nter2oter_code_sc_0/in 5v0_addh_sc_tile_1/ctrl_over 0.27153f
C1053 5v0_addh_sc_tile_2/a_382_n1095# 5v0_addh_sc_tile_2/nti 0
C1054 5v0_addh_sc_tile_2/downstepper_test VDD_3V3_0 0.5243f
C1055 5v0_add_q_sc_0/5v0_half_adder_selector_sc_0/res_stage0 5v0_add_q_sc_0/downstepper_test 0.25483f
C1056 5v0_addh_sc_tile_0/inv_pti 5v0_addh_sc_tile_0/a_382_n1095# 0.00129f
C1057 5v0_addh_sc_tile_1/ctrl_sign 5v0_add_q_sc_0/nti 0
C1058 5v0_addh_sc_tile_1/a_382_n1095# 5v0_add_q_sc_0/ctrl_over 0
C1059 5v0_addh_sc_tile_1/ctrl_over 5v0_add_q_sc_0/downstepper_test 0
C1060 5v0_addh_sc_tile_1/a_382_n1095# 5v0_add_q_sc_0/nti 0
C1061 5v0_nter2oter_code_sc_0/pti 5v0_addh_sc_tile_0/downstepper_test 0.0027f
C1062 5v0_addh_sc_tile_0/a_n1778_n454# 5v0_addh_sc_tile_0/nti 0.00142f
C1063 in_0_sign 5v0_addh_sc_tile_0/carry_sign_probe 0.24834f
C1064 5v0_addh_sc_tile_2/nti 5v0_nter2oter_code_sc_0/gf180mcu_fd_sc_mcu7t5v0__nor2_1_0/a_224_472# 0
C1065 5v0_addh_sc_tile_2/pti 5v0_addh_sc_tile_2/ctrl_over 0.16185f
C1066 5v0_add_q_sc_1/ctrl_sign 5v0_addh_sc_tile_1/pti 0.01108f
C1067 5v0_addh_sc_tile_1/m1_843_n857# 5v0_addh_sc_tile_1/pti 0.11666f
C1068 5v0_addh_sc_tile_2/ctrl_over 5v0_add_q_sc_0/ctrl_over 0.14755f
C1069 5v0_nter2oter_code_sc_0/pti 5v0_addh_sc_tile_1/ctrl_over 0.003f
C1070 5v0_add_q_sc_0/pti 5v0_add_q_sc_0/upstepper_test 0
C1071 5v0_addh_sc_tile_2/ctrl_over 5v0_add_q_sc_0/nti 0
C1072 5v0_addh_sc_tile_1/m1_843_n857# 5v0_add_q_sc_0/upstepper_test 0.0015f
C1073 5v0_add_q_sc_1/ctrl_sign 5v0_add_q_sc_1/5v0_half_adder_selector_sc_0/5v0_tgate_sel_2_sc_1/input_A 0
C1074 5v0_add_q_sc_1/5v0_half_adder_selector_sc_0/m1_n244_n517# 5v0_add_q_sc_0/ternary_input 0.16119f
C1075 VDD_3V3_1 5v0_addh_sc_tile_0/5v0_half_adder_selector_sc_0/5v0_tgate_sel_2_sc_1/input_A 0.02871f
C1076 in_0_over 5v0_addh_sc_tile_0/a_382_n1095# 0.63576f
C1077 5v0_addh_sc_tile_0/inv_nti 5v0_addh_sc_tile_0/upstepper_test 0.00736f
C1078 VDD_3V3_1 5v0_addh_sc_tile_0/nti 0.74269f
C1079 5v0_nter2oter_code_sc_1/pti VDD_3V3_0 0.19731f
C1080 5v0_addh_sc_tile_2/a_n1205_n937# 5v0_addh_sc_tile_2/nti 0
C1081 5v0_addh_sc_tile_1/ctrl_sign VDD_3V3_0 0.23567f
C1082 5v0_add_q_sc_0/pti 5v0_add_q_sc_0/ctrl_sign 0
C1083 res_0 VDD_1V65_4 0
C1084 in_1 5v0_addh_sc_tile_0/a_382_n1095# 0.09307f
C1085 5v0_add_q_sc_0/a_n1373_n454# 5v0_add_q_sc_0/pti 0
C1086 5v0_addh_sc_tile_1/a_382_n1095# VDD_3V3_0 0.61115f
C1087 5v0_add_q_sc_1/ctrl_sign in_0_sign 0
C1088 5v0_nter2oter_code_sc_1/nti 5v0_addh_sc_tile_1/nti 0.20212f
C1089 5v0_addh_sc_tile_1/ctrl_sign 5v0_add_q_sc_0/ternary_input 0
C1090 5v0_addh_sc_tile_0/carry_sign_probe 5v0_addh_sc_tile_0/inv_nti 0.17527f
C1091 5v0_addh_sc_tile_1/upstepper_test 5v0_addh_sc_tile_0/a_382_n1095# 0.00208f
C1092 5v0_add_q_sc_0/ternary_input 5v0_addh_sc_tile_1/a_382_n1095# 0.00603f
C1093 5v0_add_q_sc_1/a_n1778_n454# 5v0_add_q_sc_1/nti 0
C1094 5v0_addh_sc_tile_2/ctrl_over VDD_3V3_0 2.01435f
C1095 VDD_1V65_3 5v0_addh_sc_tile_1/a_n1205_n937# 0.00354f
C1096 5v0_nter2oter_code_sc_0/nti 5v0_nter2oter_code_sc_0/gf180mcu_fd_sc_mcu7t5v0__nor2_1_0/a_224_472# 0.00842f
C1097 5v0_addh_sc_tile_1/5v0_half_adder_selector_sc_0/res_stage0 5v0_addh_sc_tile_1/downstepper_test 0.25483f
C1098 5v0_addh_sc_tile_1/ternary_input 5v0_addh_sc_tile_0/a_382_n1095# 0.17536f
C1099 5v0_add_q_sc_1/5v0_half_adder_selector_sc_0/m1_n244_n517# 5v0_add_q_sc_1/5v0_half_adder_selector_sc_0/res_stage0 0.08646f
C1100 5v0_nter2oter_code_sc_0/in 5v0_addh_sc_tile_1/nti 0.00446f
C1101 5v0_addh_sc_tile_1/ternary_input 5v0_add_q_sc_0/ctrl_over 0
C1102 VDD_3V3_1 5v0_addh_sc_tile_0/5v0_half_adder_selector_sc_0/res_stage0 0.16177f
C1103 5v0_addh_sc_tile_2/ctrl_over 5v0_add_q_sc_0/ternary_input 0.0068f
C1104 in_0_over VDD_3V3_0 0
C1105 5v0_addh_sc_tile_2/ctrl_sign 5v0_addh_sc_tile_2/downstepper_test 0.20835f
C1106 5v0_nter2oter_code_sc_0/nti in_2 0
C1107 5v0_addh_sc_tile_0/carry_sign_probe 5v0_add_q_sc_1/nti 0
C1108 5v0_addh_sc_tile_1/5v0_half_adder_selector_sc_0/res_stage0 5v0_addh_sc_tile_1/inv_nti 0.02399f
C1109 in_3 5v0_addh_sc_tile_2/inv_pti 0.05631f
C1110 5v0_add_q_sc_1/ctrl_over 5v0_add_q_sc_1/a_n1205_n937# 0
C1111 5v0_addh_sc_tile_2/pti 5v0_addh_sc_tile_2/5v0_half_adder_selector_sc_0/res_stage0 0.00979f
C1112 5v0_addh_sc_tile_2/nti 5v0_addh_sc_tile_2/inv_pti 0.24025f
C1113 5v0_add_q_sc_1/ctrl_sign 5v0_addh_sc_tile_1/m1_103_293# 0.22665f
C1114 5v0_addh_sc_tile_2/upstepper_test in_3 0.01604f
C1115 5v0_addh_sc_tile_1/m1_843_n857# 5v0_addh_sc_tile_1/m1_103_293# 0.20659f
C1116 5v0_addh_sc_tile_2/5v0_half_adder_selector_sc_0/res_stage0 5v0_add_q_sc_0/ctrl_over 0
C1117 5v0_add_q_sc_1/ctrl_sign 5v0_addh_sc_tile_0/inv_nti 0.00142f
C1118 5v0_addh_sc_tile_2/upstepper_test 5v0_addh_sc_tile_2/nti 0.11981f
C1119 5v0_add_q_sc_1/downstepper_test 5v0_add_q_sc_1/nti 0.06596f
C1120 5v0_addh_sc_tile_0/carry_sign_probe 5v0_addh_sc_tile_0/m1_843_n857# 0.00703f
C1121 5v0_add_q_sc_0/5v0_half_adder_selector_sc_0/m1_n244_n517# 5v0_addh_sc_tile_2/a_382_n1095# 0
C1122 5v0_addh_sc_tile_1/ctrl_sign 5v0_add_q_sc_1/pti 0
C1123 5v0_add_q_sc_1/a_n1373_n454# 5v0_add_q_sc_1/ternary_input 0.00136f
C1124 5v0_addh_sc_tile_1/inv_nti 5v0_addh_sc_tile_1/downstepper_test 0.29493f
C1125 5v0_nter2oter_code_sc_0/in 5v0_addh_sc_tile_2/a_382_n1095# 0
C1126 5v0_add_q_sc_1/inv_nti 5v0_addh_sc_tile_1/inv_nti 0
C1127 5v0_addh_sc_tile_0/a_n1778_n454# 5v0_addh_sc_tile_0/upstepper_test 0
C1128 5v0_addh_sc_tile_1/upstepper_test VDD_3V3_0 0.13286f
C1129 in_0_over 5v0_addh_sc_tile_0/a_n1205_n937# 0
C1130 5v0_addh_sc_tile_2/a_382_n1095# 5v0_add_q_sc_0/downstepper_test 0.00139f
C1131 5v0_nter2oter_code_sc_1/nti 5v0_addh_sc_tile_1/pti 0
C1132 5v0_addh_sc_tile_0/inv_pti 5v0_addh_sc_tile_0/a_n1373_n454# 0.00135f
C1133 5v0_addh_sc_tile_0/5v0_half_adder_selector_sc_0/5v0_tgate_sel_2_sc_1/input_A 5v0_addh_sc_tile_0/a_382_n1095# 0.02928f
C1134 5v0_nter2oter_code_sc_1/nti in_2 0.19632f
C1135 5v0_add_q_sc_1/inv_nti 5v0_add_q_sc_1/inv_pti 0.08256f
C1136 VDD_3V3_1 5v0_add_q_sc_1/5v0_half_adder_selector_sc_0/m1_n239_179# 0.29031f
C1137 5v0_addh_sc_tile_1/ctrl_sign 5v0_addh_sc_tile_1/5v0_half_adder_selector_sc_0/5v0_tgate_sel_2_sc_1/input_A 0
C1138 5v0_addh_sc_tile_1/ternary_input VDD_3V3_0 0.0901f
C1139 5v0_addh_sc_tile_2/ctrl_over VDD_1V65_5 0
C1140 5v0_nter2oter_code_sc_1/pti 5v0_addh_sc_tile_2/ctrl_sign 0.02991f
C1141 5v0_addh_sc_tile_1/5v0_half_adder_selector_sc_0/5v0_tgate_sel_2_sc_1/input_A 5v0_addh_sc_tile_1/a_382_n1095# 0.02928f
C1142 5v0_add_q_sc_1/ctrl_sign 5v0_add_q_sc_1/nti 0.2845f
C1143 5v0_addh_sc_tile_1/ctrl_sign 5v0_addh_sc_tile_2/ctrl_sign 0.01318f
C1144 5v0_addh_sc_tile_0/nti 5v0_addh_sc_tile_0/a_382_n1095# 0
C1145 5v0_add_q_sc_0/5v0_half_adder_selector_sc_0/m1_n239_179# 5v0_addh_sc_tile_1/inv_nti 0
C1146 5v0_add_q_sc_1/inv_nti 5v0_addh_sc_tile_0/pti 0.00104f
C1147 5v0_nter2oter_code_sc_0/in 5v0_addh_sc_tile_1/pti 0
C1148 5v0_nter2oter_code_sc_0/in in_2 0.00892f
C1149 5v0_addh_sc_tile_2/a_n1373_n454# 5v0_addh_sc_tile_2/downstepper_test 0.00442f
C1150 VDD_3V3_1 5v0_addh_sc_tile_0/upstepper_test 0.45677f
C1151 5v0_add_q_sc_1/ctrl_sign 5v0_addh_sc_tile_0/m1_843_n857# 0
C1152 5v0_addh_sc_tile_2/5v0_half_adder_selector_sc_0/res_stage0 VDD_3V3_0 0.16541f
C1153 5v0_addh_sc_tile_1/inv_nti 5v0_addh_sc_tile_0/pti 0
C1154 5v0_add_q_sc_1/ternary_input 5v0_add_q_sc_1/a_n1205_n937# 0
C1155 5v0_add_q_sc_1/a_n1373_n454# 5v0_add_q_sc_1/VDD_1V65 0.00232f
C1156 5v0_addh_sc_tile_2/ctrl_over 5v0_addh_sc_tile_2/ctrl_sign 0.63344f
C1157 5v0_add_q_sc_0/downstepper_test 5v0_add_q_sc_0/upstepper_test 0.38867f
C1158 5v0_addh_sc_tile_1/ctrl_sign 5v0_addh_sc_tile_0/m1_103_293# 0.00101f
C1159 5v0_addh_sc_tile_2/pti VDD_1V65_4 0.00234f
C1160 5v0_addh_sc_tile_2/pti 5v0_addh_sc_tile_2/m1_843_n857# 0.11666f
C1161 5v0_add_q_sc_1/ctrl_sign VDD_1V65_2 0.00149f
C1162 VDD_3V3_1 5v0_addh_sc_tile_0/carry_sign_probe 0.17781f
C1163 5v0_nter2oter_code_sc_0/pti in_2 0.00216f
C1164 in_1 5v0_addh_sc_tile_0/a_n1373_n454# 0.00163f
C1165 5v0_add_q_sc_0/ctrl_over 5v0_addh_sc_tile_2/m1_843_n857# 0.17868f
C1166 5v0_addh_sc_tile_0/5v0_half_adder_selector_sc_0/res_stage0 5v0_addh_sc_tile_0/a_382_n1095# 0.08951f
C1167 VDD_1V65_2 VSS_3 0.07318f
C1168 5v0_addh_sc_tile_2/pti VSS_3 1.17571f
C1169 VDD_1V65_4 VSS_3 0.09068f
C1170 5v0_addh_sc_tile_2/inv_nti VSS_3 1.3751f
C1171 5v0_addh_sc_tile_2/m1_843_n857# VSS_3 0.16265f ; **FLOATING
C1172 5v0_addh_sc_tile_2/ctrl_sign VSS_3 1.27398f
C1173 5v0_addh_sc_tile_2/a_n1205_n937# VSS_3 0 ; **FLOATING
C1174 5v0_addh_sc_tile_2/a_n1373_n454# VSS_3 0.00335f ; **FLOATING
C1175 5v0_addh_sc_tile_2/a_n1778_n454# VSS_3 0.00573f ; **FLOATING
C1176 5v0_addh_sc_tile_2/inv_pti VSS_3 0.92496f
C1177 5v0_addh_sc_tile_2/5v0_half_adder_selector_sc_0/5v0_tgate_sel_2_sc_1/input_A VSS_3 0
C1178 5v0_addh_sc_tile_2/a_382_n1095# VSS_3 0.83941f ; **FLOATING
C1179 in_3 VSS_3 1.64882f
C1180 res_0 VSS_3 0.02768f
C1181 5v0_addh_sc_tile_2/ctrl_over VSS_3 0.80165f
C1182 5v0_addh_sc_tile_2/m1_103_293# VSS_3 0.74864f ; **FLOATING
C1183 5v0_addh_sc_tile_2/5v0_half_adder_selector_sc_0/res_stage0 VSS_3 0.50069f
C1184 5v0_addh_sc_tile_2/downstepper_test VSS_3 0.58281f
C1185 5v0_addh_sc_tile_2/upstepper_test VSS_3 0.53687f
C1186 5v0_addh_sc_tile_2/nti VSS_3 1.2554f
C1187 5v0_addh_sc_tile_1/pti VSS_3 1.17421f
C1188 VDD_1V65_3 VSS_3 0.09068f
C1189 5v0_addh_sc_tile_1/inv_nti VSS_3 1.35629f
C1190 5v0_addh_sc_tile_1/m1_843_n857# VSS_3 0.15965f ; **FLOATING
C1191 5v0_addh_sc_tile_1/ctrl_sign VSS_3 1.01491f
C1192 5v0_addh_sc_tile_1/a_n1205_n937# VSS_3 0 ; **FLOATING
C1193 5v0_addh_sc_tile_1/a_n1373_n454# VSS_3 0.00335f ; **FLOATING
C1194 5v0_addh_sc_tile_1/a_n1778_n454# VSS_3 0.00573f ; **FLOATING
C1195 5v0_addh_sc_tile_1/inv_pti VSS_3 0.92626f
C1196 VDD_3V3_1 VSS_3 39.17125f
C1197 5v0_addh_sc_tile_1/5v0_half_adder_selector_sc_0/5v0_tgate_sel_2_sc_1/input_A VSS_3 0
C1198 5v0_addh_sc_tile_1/a_382_n1095# VSS_3 0.81445f ; **FLOATING
C1199 5v0_addh_sc_tile_1/ternary_input VSS_3 1.5479f
C1200 5v0_nter2oter_code_sc_0/in VSS_3 1.10334f
C1201 5v0_addh_sc_tile_1/ctrl_over VSS_3 1.08807f
C1202 5v0_addh_sc_tile_1/m1_103_293# VSS_3 0.74864f ; **FLOATING
C1203 5v0_addh_sc_tile_1/5v0_half_adder_selector_sc_0/res_stage0 VSS_3 0.50069f
C1204 5v0_addh_sc_tile_1/downstepper_test VSS_3 0.58281f
C1205 5v0_addh_sc_tile_1/upstepper_test VSS_3 0.53687f
C1206 5v0_addh_sc_tile_1/nti VSS_3 1.26884f
C1207 5v0_addh_sc_tile_0/pti VSS_3 1.1792f
C1208 VDD_1V65_0 VSS_3 0.09068f
C1209 5v0_addh_sc_tile_0/inv_nti VSS_3 1.36049f
C1210 5v0_addh_sc_tile_0/m1_843_n857# VSS_3 0.15969f ; **FLOATING
C1211 in_0_sign VSS_3 0.8701f
C1212 5v0_addh_sc_tile_0/a_n1205_n937# VSS_3 0 ; **FLOATING
C1213 5v0_addh_sc_tile_0/a_n1373_n454# VSS_3 0.00335f ; **FLOATING
C1214 5v0_addh_sc_tile_0/a_n1778_n454# VSS_3 0.00573f ; **FLOATING
C1215 5v0_addh_sc_tile_0/inv_pti VSS_3 0.92409f
C1216 5v0_addh_sc_tile_0/carry_sign_probe VSS_3 0.24862f
C1217 5v0_addh_sc_tile_0/carry_0_probe VSS_3 0.59349f
C1218 5v0_addh_sc_tile_0/5v0_half_adder_selector_sc_0/5v0_tgate_sel_2_sc_1/input_A VSS_3 0
C1219 5v0_addh_sc_tile_0/a_382_n1095# VSS_3 0.81488f ; **FLOATING
C1220 in_1 VSS_3 1.70172f
C1221 in_0_over VSS_3 0.49348f
C1222 5v0_addh_sc_tile_0/m1_103_293# VSS_3 0.74828f ; **FLOATING
C1223 5v0_addh_sc_tile_0/5v0_half_adder_selector_sc_0/res_stage0 VSS_3 0.50069f
C1224 5v0_addh_sc_tile_0/downstepper_test VSS_3 0.5849f
C1225 5v0_addh_sc_tile_0/upstepper_test VSS_3 0.53687f
C1226 5v0_addh_sc_tile_0/nti VSS_3 1.25562f
C1227 in_2 VSS_3 0.95085f
C1228 5v0_nter2oter_code_sc_1/pti VSS_3 0.62711f
C1229 5v0_nter2oter_code_sc_1/nti VSS_3 0.65154f
C1230 5v0_nter2oter_code_sc_1/gf180mcu_fd_sc_mcu7t5v0__nor2_1_0/a_224_472# VSS_3 0 ; **FLOATING
C1231 5v0_add_q_sc_1/pti VSS_3 0.59914f
C1232 5v0_add_q_sc_1/VDD_1V65 VSS_3 0.25926f
C1233 5v0_add_q_sc_1/inv_nti VSS_3 0.53672f
C1234 5v0_add_q_sc_1/inv_pti VSS_3 0.64307f
C1235 5v0_add_q_sc_1/a_n1205_n937# VSS_3 0.0038f ; **FLOATING
C1236 5v0_add_q_sc_1/a_n1373_n454# VSS_3 0.00345f ; **FLOATING
C1237 5v0_add_q_sc_1/a_n1778_n454# VSS_3 0.00577f ; **FLOATING
C1238 5v0_add_q_sc_1/5v0_half_adder_selector_sc_0/5v0_tgate_sel_2_sc_1/input_A VSS_3 0
C1239 5v0_add_q_sc_1/5v0_half_adder_selector_sc_0/m1_n244_n517# VSS_3 0.29628f ; **FLOATING
C1240 5v0_add_q_sc_1/ternary_input VSS_3 1.9522f
C1241 5v0_add_q_sc_1/ctrl_over VSS_3 0.98262f
C1242 5v0_add_q_sc_1/5v0_half_adder_selector_sc_0/m1_n239_179# VSS_3 0.37403f ; **FLOATING
C1243 5v0_add_q_sc_1/5v0_half_adder_selector_sc_0/res_stage0 VSS_3 0.78312f
C1244 5v0_add_q_sc_1/downstepper_test VSS_3 1.03196f
C1245 5v0_add_q_sc_1/ctrl_sign VSS_3 1.15654f
C1246 5v0_add_q_sc_1/nti VSS_3 1.38585f
C1247 5v0_nter2oter_code_sc_0/pti VSS_3 0.61125f
C1248 5v0_nter2oter_code_sc_0/nti VSS_3 0.66288f
C1249 5v0_nter2oter_code_sc_0/gf180mcu_fd_sc_mcu7t5v0__nor2_1_0/a_224_472# VSS_3 0 ; **FLOATING
C1250 5v0_add_q_sc_0/pti VSS_3 0.59945f
C1251 VDD_1V65_5 VSS_3 0.09068f
C1252 5v0_add_q_sc_0/inv_nti VSS_3 0.53562f
C1253 5v0_add_q_sc_0/inv_pti VSS_3 0.59603f
C1254 5v0_add_q_sc_0/a_n1205_n937# VSS_3 0 ; **FLOATING
C1255 5v0_add_q_sc_0/a_n1373_n454# VSS_3 0.00335f ; **FLOATING
C1256 5v0_add_q_sc_0/a_n1778_n454# VSS_3 0.00573f ; **FLOATING
C1257 5v0_add_q_sc_0/5v0_half_adder_selector_sc_0/5v0_tgate_sel_2_sc_1/input_A VSS_3 0
C1258 5v0_add_q_sc_0/5v0_half_adder_selector_sc_0/m1_n244_n517# VSS_3 0.29628f ; **FLOATING
C1259 5v0_add_q_sc_0/ternary_input VSS_3 2.49693f
C1260 res_c VSS_3 0.0293f
C1261 5v0_add_q_sc_0/ctrl_over VSS_3 0.76005f
C1262 5v0_add_q_sc_0/5v0_half_adder_selector_sc_0/m1_n239_179# VSS_3 0.29907f ; **FLOATING
C1263 5v0_add_q_sc_0/5v0_half_adder_selector_sc_0/res_stage0 VSS_3 0.50905f
C1264 5v0_add_q_sc_0/downstepper_test VSS_3 0.64239f
C1265 5v0_add_q_sc_0/ctrl_sign VSS_3 0.4943f
C1266 VDD_3V3_0 VSS_3 47.32191f
C1267 5v0_add_q_sc_0/upstepper_test VSS_3 0.54953f
C1268 5v0_add_q_sc_0/nti VSS_3 1.27003f
C1269 m1_n2844_n810# VSS_3 0.41232f ; **FLOATING
