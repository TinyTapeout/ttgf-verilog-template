* NGSPICE file created from 5v0_add3_sc.ext - technology: gf180mcuD

.option scale=5n

X0 5v0_add_q_sc_1/ternary_input m1_n2844_n810# 5v0_addh_sc_tile_0/carry_sign_probe VSS_3 nfet_06v0 ad=14.432n pd=0.504m as=14.432n ps=0.504m w=164 l=120
X1 VDD_1V65_2 5v0_addh_sc_tile_0/carry_0_probe 5v0_add_q_sc_1/ternary_input VSS_3 nfet_06v0 ad=14.432n pd=0.504m as=14.432n ps=0.504m w=164 l=120
X2 5v0_add_q_sc_0/pti 5v0_add_q_sc_0/ternary_input VSS_3 VSS_3 nfet_06v0 ad=6.336n pd=0.32m as=6.478n ps=0.255m w=72 l=578
X3 VDD_3V3_0 5v0_add_q_sc_0/ternary_input 5v0_add_q_sc_0/pti VDD_3V3_0 pfet_06v0 ad=12.81n pd=0.349m as=12.688n ps=0.348m w=244 l=100
X4 VDD_3V3_0 5v0_add_q_sc_0/ternary_input 5v0_add_q_sc_0/nti VDD_3V3_0 pfet_06v0 ad=13.616n pd=0.392m as=9.696n ps=0.394m w=96 l=150
X5 VSS_3 5v0_add_q_sc_0/ternary_input 5v0_add_q_sc_0/nti VSS_3 nfet_06v0 ad=6.478n pd=0.255m as=12.7n ps=0.454m w=127 l=120
X6 5v0_add_q_sc_0/pti 5v0_add_q_sc_0/ternary_input VDD_3V3_0 VDD_3V3_0 pfet_06v0 ad=12.688n pd=0.348m as=13.616n ps=0.392m w=244 l=100
X7 5v0_add_q_sc_0/pti 5v0_add_q_sc_0/ternary_input VDD_3V3_0 VDD_3V3_0 pfet_06v0 ad=27.328n pd=0.712m as=12.81n ps=0.349m w=244 l=100
X8 5v0_add_q_sc_0/5v0_half_adder_selector_sc_0/res_stage0 5v0_add_q_sc_0/5v0_half_adder_selector_sc_0/m1_n239_179# 5v0_add_q_sc_0/downstepper_test VSS_3 nfet_06v0 ad=14.432n pd=0.504m as=14.432n ps=0.504m w=164 l=120
X9 5v0_add_q_sc_0/5v0_half_adder_selector_sc_0/res_stage0 5v0_add_q_sc_0/5v0_half_adder_selector_sc_0/m1_n239_179# 5v0_add_q_sc_0/upstepper_test VDD_3V3_0 pfet_06v0 ad=21.472n pd=0.664m as=21.472n ps=0.664m w=244 l=100
X10 5v0_add_q_sc_0/5v0_half_adder_selector_sc_0/m1_n239_179# 5v0_add_q_sc_0/ctrl_sign VSS_3 VSS_3 nfet_06v0 ad=14.432n pd=0.504m as=14.432n ps=0.504m w=164 l=120
X11 5v0_add_q_sc_0/5v0_half_adder_selector_sc_0/m1_n239_179# 5v0_add_q_sc_0/ctrl_sign VDD_3V3_0 VDD_3V3_0 pfet_06v0 ad=21.472n pd=0.664m as=21.472n ps=0.664m w=244 l=100
X12 5v0_add_q_sc_0/5v0_half_adder_selector_sc_0/res_stage0 5v0_add_q_sc_0/ctrl_sign 5v0_add_q_sc_0/upstepper_test VSS_3 nfet_06v0 ad=31.489n pd=1.041m as=43.711n ps=1.504m w=164 l=120
X13 5v0_add_q_sc_0/5v0_half_adder_selector_sc_0/res_stage0 5v0_add_q_sc_0/ctrl_sign 5v0_add_q_sc_0/downstepper_test VDD_3V3_0 pfet_06v0 ad=46.849n pd=1.361m as=42.856n ps=1.326m w=244 l=100
X14 res_c 5v0_add_q_sc_0/5v0_half_adder_selector_sc_0/m1_n244_n517# 5v0_add_q_sc_0/5v0_half_adder_selector_sc_0/res_stage0 VSS_3 nfet_06v0 ad=17.057n pd=0.537m as=0 ps=0 w=164 l=120
X15 res_c 5v0_add_q_sc_0/5v0_half_adder_selector_sc_0/m1_n244_n517# 5v0_add_q_sc_0/ternary_input VDD_3V3_0 pfet_06v0 ad=25.377n pd=0.697m as=46.849n ps=1.361m w=244 l=100
X16 5v0_add_q_sc_0/5v0_half_adder_selector_sc_0/m1_n244_n517# 5v0_add_q_sc_0/ctrl_over VSS_3 VSS_3 nfet_06v0 ad=14.432n pd=0.504m as=0.63612u ps=0.02242 w=164 l=120
X17 5v0_add_q_sc_0/5v0_half_adder_selector_sc_0/m1_n244_n517# 5v0_add_q_sc_0/ctrl_over VDD_3V3_0 VDD_3V3_0 pfet_06v0 ad=21.472n pd=0.664m as=0.50045u ps=0.0145 w=244 l=100
X18 res_c 5v0_add_q_sc_0/ctrl_over 5v0_add_q_sc_0/ternary_input VSS_3 nfet_06v0 ad=0 pd=0 as=31.489n ps=1.041m w=164 l=120
X19 res_c 5v0_add_q_sc_0/ctrl_over 5v0_add_q_sc_0/5v0_half_adder_selector_sc_0/res_stage0 VDD_3V3_0 pfet_06v0 ad=0 pd=0 as=0 ps=0 w=244 l=100
X20 5v0_add_q_sc_0/inv_pti 5v0_add_q_sc_0/pti VSS_3 VSS_3 nfet_06v0 ad=14.432n pd=0.504m as=14.432n ps=0.504m w=164 l=120
X21 5v0_add_q_sc_0/inv_pti 5v0_add_q_sc_0/pti VDD_3V3_0 VDD_3V3_0 pfet_06v0 ad=21.472n pd=0.664m as=21.472n ps=0.664m w=244 l=100
X22 5v0_add_q_sc_0/a_n1373_n454# 5v0_add_q_sc_0/inv_nti 5v0_add_q_sc_0/downstepper_test VSS_3 nfet_06v0 ad=3.528n pd=0.195m as=8.599n ps=0.264m w=147 l=120
X23 5v0_add_q_sc_0/upstepper_test 5v0_add_q_sc_0/nti 5v0_add_q_sc_0/a_n1205_n937# VDD_3V3_0 pfet_06v0 ad=21.384n pd=0.662m as=5.832n ps=0.291m w=243 l=100
X24 5v0_add_q_sc_0/inv_nti 5v0_add_q_sc_0/nti VDD_3V3_0 VDD_3V3_0 pfet_06v0 ad=21.472n pd=0.664m as=21.472n ps=0.664m w=244 l=100
X25 5v0_add_q_sc_0/upstepper_test 5v0_add_q_sc_0/nti VDD_1V65_5 VSS_3 nfet_06v0 ad=14.847n pd=0.496m as=10.51n ps=0.29m w=147 l=120
X26 5v0_add_q_sc_0/a_n1205_n937# 5v0_add_q_sc_0/inv_pti VDD_3V3_0 VDD_3V3_0 pfet_06v0 ad=5.832n pd=0.291m as=21.384n ps=0.662m w=243 l=100
X27 5v0_add_q_sc_0/downstepper_test 5v0_add_q_sc_0/pti 5v0_add_q_sc_0/a_n1778_n454# VSS_3 nfet_06v0 ad=8.599n pd=0.264m as=3.528n ps=0.195m w=147 l=120
X28 5v0_add_q_sc_0/inv_nti 5v0_add_q_sc_0/nti VSS_3 VSS_3 nfet_06v0 ad=14.432n pd=0.504m as=14.432n ps=0.504m w=164 l=120
X29 5v0_add_q_sc_0/a_n1778_n454# 5v0_add_q_sc_0/inv_nti VSS_3 VSS_3 nfet_06v0 ad=3.528n pd=0.195m as=14.847n ps=0.496m w=147 l=120
X30 5v0_add_q_sc_0/upstepper_test 5v0_add_q_sc_0/inv_pti VSS_3 VSS_3 nfet_06v0 ad=14.432n pd=0.504m as=14.432n ps=0.504m w=164 l=120
X31 VDD_1V65_5 5v0_add_q_sc_0/inv_pti 5v0_add_q_sc_0/a_n1373_n454# VSS_3 nfet_06v0 ad=10.51n pd=0.29m as=3.528n ps=0.195m w=147 l=120
X32 5v0_add_q_sc_0/downstepper_test 5v0_add_q_sc_0/inv_nti VDD_3V3_0 VDD_3V3_0 pfet_06v0 ad=21.384n pd=0.662m as=21.384n ps=0.662m w=243 l=100
X33 5v0_addh_sc_tile_2/ctrl_over 5v0_addh_sc_tile_2/ctrl_sign 5v0_nter2oter_code_sc_0/gf180mcu_fd_sc_mcu7t5v0__nor2_1_0/a_224_472# VDD_3V3_0 pfet_06v0 ad=21.472n pd=0.664m as=16.348n ps=0.378m w=244 l=100
X34 VSS_3 5v0_addh_sc_tile_2/ctrl_sign 5v0_addh_sc_tile_2/ctrl_over VSS_3 nfet_06v0 ad=9.944n pd=0.402m as=5.876n ps=0.217m w=113 l=120
X35 5v0_nter2oter_code_sc_0/gf180mcu_fd_sc_mcu7t5v0__nor2_1_0/a_224_472# 5v0_nter2oter_code_sc_0/nti VDD_3V3_0 VDD_3V3_0 pfet_06v0 ad=16.348n pd=0.378m as=20.932n ps=0.664m w=244 l=100
X36 5v0_addh_sc_tile_2/ctrl_over 5v0_nter2oter_code_sc_0/nti VSS_3 VSS_3 nfet_06v0 ad=5.876n pd=0.217m as=9.944n ps=0.402m w=113 l=120
X37 5v0_addh_sc_tile_2/ctrl_sign 5v0_nter2oter_code_sc_0/pti VSS_3 VSS_3 nfet_06v0 ad=14.432n pd=0.504m as=0 ps=0 w=164 l=120
X38 5v0_addh_sc_tile_2/ctrl_sign 5v0_nter2oter_code_sc_0/pti VDD_3V3_0 VDD_3V3_0 pfet_06v0 ad=21.472n pd=0.664m as=0 ps=0 w=244 l=100
X39 5v0_nter2oter_code_sc_0/pti 5v0_nter2oter_code_sc_0/in VSS_3 VSS_3 nfet_06v0 ad=6.336n pd=0.32m as=6.478n ps=0.255m w=72 l=578
X40 VDD_3V3_1 5v0_nter2oter_code_sc_0/in 5v0_nter2oter_code_sc_0/pti VDD_3V3_1 pfet_06v0 ad=12.81n pd=0.349m as=12.688n ps=0.348m w=244 l=100
X41 VDD_3V3_1 5v0_nter2oter_code_sc_0/in 5v0_nter2oter_code_sc_0/nti VDD_3V3_1 pfet_06v0 ad=13.616n pd=0.392m as=9.696n ps=0.394m w=96 l=150
X42 VSS_3 5v0_nter2oter_code_sc_0/in 5v0_nter2oter_code_sc_0/nti VSS_3 nfet_06v0 ad=6.478n pd=0.255m as=12.7n ps=0.454m w=127 l=120
X43 5v0_nter2oter_code_sc_0/pti 5v0_nter2oter_code_sc_0/in VDD_3V3_1 VDD_3V3_1 pfet_06v0 ad=12.688n pd=0.348m as=13.616n ps=0.392m w=244 l=100
X44 5v0_nter2oter_code_sc_0/pti 5v0_nter2oter_code_sc_0/in VDD_3V3_1 VDD_3V3_1 pfet_06v0 ad=27.328n pd=0.712m as=12.81n ps=0.349m w=244 l=100
X45 5v0_add_q_sc_1/pti 5v0_add_q_sc_1/ternary_input VSS_3 VSS_3 nfet_06v0 ad=6.336n pd=0.32m as=0 ps=0 w=72 l=578
X46 VDD_3V3_1 5v0_add_q_sc_1/ternary_input 5v0_add_q_sc_1/pti VDD_3V3_1 pfet_06v0 ad=0.54021u pd=0.01553 as=52.704n ps=1.408m w=244 l=100
X47 VDD_3V3_1 5v0_add_q_sc_1/ternary_input 5v0_add_q_sc_1/nti VDD_3V3_1 pfet_06v0 ad=0 pd=0 as=9.696n ps=0.394m w=96 l=150
X48 VSS_3 5v0_add_q_sc_1/ternary_input 5v0_add_q_sc_1/nti VSS_3 nfet_06v0 ad=0 pd=0 as=12.7n ps=0.454m w=127 l=120
X49 5v0_add_q_sc_1/pti 5v0_add_q_sc_1/ternary_input VDD_3V3_1 VDD_3V3_1 pfet_06v0 ad=0 pd=0 as=0 ps=0 w=244 l=100
X50 5v0_add_q_sc_1/pti 5v0_add_q_sc_1/ternary_input VDD_3V3_1 VDD_3V3_1 pfet_06v0 ad=0 pd=0 as=0 ps=0 w=244 l=100
X51 5v0_add_q_sc_1/5v0_half_adder_selector_sc_0/res_stage0 5v0_add_q_sc_1/5v0_half_adder_selector_sc_0/m1_n239_179# 5v0_add_q_sc_1/downstepper_test VSS_3 nfet_06v0 ad=31.489n pd=1.041m as=31.631n ps=1.032m w=164 l=120
X52 5v0_add_q_sc_1/5v0_half_adder_selector_sc_0/res_stage0 5v0_add_q_sc_1/5v0_half_adder_selector_sc_0/m1_n239_179# VSS_3 VDD_3V3_1 pfet_06v0 ad=46.849n pd=1.361m as=0.15934u ps=5.646m w=244 l=100
X53 5v0_add_q_sc_1/5v0_half_adder_selector_sc_0/m1_n239_179# 5v0_add_q_sc_1/ctrl_sign VSS_3 VSS_3 nfet_06v0 ad=14.432n pd=0.504m as=0 ps=0 w=164 l=120
X54 5v0_add_q_sc_1/5v0_half_adder_selector_sc_0/m1_n239_179# 5v0_add_q_sc_1/ctrl_sign VDD_3V3_1 VDD_3V3_1 pfet_06v0 ad=21.472n pd=0.664m as=0 ps=0 w=244 l=100
X55 5v0_add_q_sc_1/5v0_half_adder_selector_sc_0/res_stage0 5v0_add_q_sc_1/ctrl_sign VSS_3 VSS_3 nfet_06v0 ad=0 pd=0 as=0 ps=0 w=164 l=120
X56 5v0_add_q_sc_1/5v0_half_adder_selector_sc_0/res_stage0 5v0_add_q_sc_1/ctrl_sign 5v0_add_q_sc_1/downstepper_test VDD_3V3_1 pfet_06v0 ad=0 pd=0 as=42.856n ps=1.326m w=244 l=100
X57 5v0_add_q_sc_0/ternary_input 5v0_add_q_sc_1/5v0_half_adder_selector_sc_0/m1_n244_n517# 5v0_add_q_sc_1/5v0_half_adder_selector_sc_0/res_stage0 VSS_3 nfet_06v0 ad=0 pd=0 as=0 ps=0 w=164 l=120
X58 5v0_add_q_sc_0/ternary_input 5v0_add_q_sc_1/5v0_half_adder_selector_sc_0/m1_n244_n517# 5v0_add_q_sc_1/ternary_input VDD_3V3_1 pfet_06v0 ad=0 pd=0 as=42.945n ps=1.329m w=244 l=100
X59 5v0_add_q_sc_1/5v0_half_adder_selector_sc_0/m1_n244_n517# 5v0_add_q_sc_1/ctrl_over VSS_3 VSS_3 nfet_06v0 ad=14.432n pd=0.504m as=0 ps=0 w=164 l=120
X60 5v0_add_q_sc_1/5v0_half_adder_selector_sc_0/m1_n244_n517# 5v0_add_q_sc_1/ctrl_over VDD_3V3_1 VDD_3V3_1 pfet_06v0 ad=21.472n pd=0.664m as=0 ps=0 w=244 l=100
X61 5v0_add_q_sc_0/ternary_input 5v0_add_q_sc_1/ctrl_over 5v0_add_q_sc_1/ternary_input VSS_3 nfet_06v0 ad=0 pd=0 as=31.489n ps=1.041m w=164 l=120
X62 5v0_add_q_sc_0/ternary_input 5v0_add_q_sc_1/ctrl_over 5v0_add_q_sc_1/5v0_half_adder_selector_sc_0/res_stage0 VDD_3V3_1 pfet_06v0 ad=0 pd=0 as=0 ps=0 w=244 l=100
X63 5v0_add_q_sc_1/inv_pti 5v0_add_q_sc_1/pti VSS_3 VSS_3 nfet_06v0 ad=14.432n pd=0.504m as=0 ps=0 w=164 l=120
X64 5v0_add_q_sc_1/inv_pti 5v0_add_q_sc_1/pti VDD_3V3_1 VDD_3V3_1 pfet_06v0 ad=21.472n pd=0.664m as=0 ps=0 w=244 l=100
X65 5v0_add_q_sc_1/a_n1373_n454# 5v0_add_q_sc_1/inv_nti 5v0_add_q_sc_1/downstepper_test VSS_3 nfet_06v0 ad=7.056n pd=0.39m as=0 ps=0 w=147 l=120
X66 VSS_3 5v0_add_q_sc_1/nti 5v0_add_q_sc_1/a_n1205_n937# VDD_3V3_1 pfet_06v0 ad=0 pd=0 as=11.664n ps=0.582m w=243 l=100
X67 5v0_add_q_sc_1/inv_nti 5v0_add_q_sc_1/nti VDD_3V3_1 VDD_3V3_1 pfet_06v0 ad=21.472n pd=0.664m as=0 ps=0 w=244 l=100
X68 VSS_3 5v0_add_q_sc_1/nti 5v0_add_q_sc_1/VDD_1V65 VSS_3 nfet_06v0 ad=0 pd=0 as=21.021n ps=0.58m w=147 l=120
X69 5v0_add_q_sc_1/a_n1205_n937# 5v0_add_q_sc_1/inv_pti VDD_3V3_1 VDD_3V3_1 pfet_06v0 ad=0 pd=0 as=0 ps=0 w=243 l=100
X70 5v0_add_q_sc_1/downstepper_test 5v0_add_q_sc_1/pti 5v0_add_q_sc_1/a_n1778_n454# VSS_3 nfet_06v0 ad=0 pd=0 as=7.056n ps=0.39m w=147 l=120
X71 5v0_add_q_sc_1/inv_nti 5v0_add_q_sc_1/nti VSS_3 VSS_3 nfet_06v0 ad=14.432n pd=0.504m as=0 ps=0 w=164 l=120
X72 5v0_add_q_sc_1/a_n1778_n454# 5v0_add_q_sc_1/inv_nti VSS_3 VSS_3 nfet_06v0 ad=0 pd=0 as=0 ps=0 w=147 l=120
X73 VSS_3 5v0_add_q_sc_1/inv_pti VSS_3 VSS_3 nfet_06v0 ad=0 pd=0 as=0 ps=0 w=164 l=120
X74 5v0_add_q_sc_1/VDD_1V65 5v0_add_q_sc_1/inv_pti 5v0_add_q_sc_1/a_n1373_n454# VSS_3 nfet_06v0 ad=0 pd=0 as=0 ps=0 w=147 l=120
X75 5v0_add_q_sc_1/downstepper_test 5v0_add_q_sc_1/inv_nti VDD_3V3_1 VDD_3V3_1 pfet_06v0 ad=0 pd=0 as=0 ps=0 w=243 l=100
X76 5v0_addh_sc_tile_1/ctrl_over 5v0_addh_sc_tile_1/ctrl_sign 5v0_nter2oter_code_sc_1/gf180mcu_fd_sc_mcu7t5v0__nor2_1_0/a_224_472# VDD_3V3_0 pfet_06v0 ad=21.472n pd=0.664m as=32.696n ps=0.756m w=244 l=100
X77 VSS_3 5v0_addh_sc_tile_1/ctrl_sign 5v0_addh_sc_tile_1/ctrl_over VSS_3 nfet_06v0 ad=0 pd=0 as=11.752n ps=0.434m w=113 l=120
X78 5v0_nter2oter_code_sc_1/gf180mcu_fd_sc_mcu7t5v0__nor2_1_0/a_224_472# 5v0_nter2oter_code_sc_1/nti VDD_3V3_0 VDD_3V3_0 pfet_06v0 ad=0 pd=0 as=0 ps=0 w=244 l=100
X79 5v0_addh_sc_tile_1/ctrl_over 5v0_nter2oter_code_sc_1/nti VSS_3 VSS_3 nfet_06v0 ad=0 pd=0 as=0 ps=0 w=113 l=120
X80 5v0_addh_sc_tile_1/ctrl_sign 5v0_nter2oter_code_sc_1/pti VSS_3 VSS_3 nfet_06v0 ad=14.432n pd=0.504m as=0 ps=0 w=164 l=120
X81 5v0_addh_sc_tile_1/ctrl_sign 5v0_nter2oter_code_sc_1/pti VDD_3V3_0 VDD_3V3_0 pfet_06v0 ad=21.472n pd=0.664m as=0 ps=0 w=244 l=100
X82 5v0_nter2oter_code_sc_1/pti in_2 VSS_3 VSS_3 nfet_06v0 ad=6.336n pd=0.32m as=0 ps=0 w=72 l=578
X83 VDD_3V3_1 in_2 5v0_nter2oter_code_sc_1/pti VDD_3V3_1 pfet_06v0 ad=0 pd=0 as=52.704n ps=1.408m w=244 l=100
X84 VDD_3V3_1 in_2 5v0_nter2oter_code_sc_1/nti VDD_3V3_1 pfet_06v0 ad=0 pd=0 as=9.696n ps=0.394m w=96 l=150
X85 VSS_3 in_2 5v0_nter2oter_code_sc_1/nti VSS_3 nfet_06v0 ad=0 pd=0 as=12.7n ps=0.454m w=127 l=120
X86 5v0_nter2oter_code_sc_1/pti in_2 VDD_3V3_1 VDD_3V3_1 pfet_06v0 ad=0 pd=0 as=0 ps=0 w=244 l=100
X87 5v0_nter2oter_code_sc_1/pti in_2 VDD_3V3_1 VDD_3V3_1 pfet_06v0 ad=0 pd=0 as=0 ps=0 w=244 l=100
X88 m1_n2844_n810# 5v0_addh_sc_tile_0/carry_0_probe VSS_3 VSS_3 nfet_06v0 ad=14.432n pd=0.504m as=0 ps=0 w=164 l=120
X89 m1_n2844_n810# 5v0_addh_sc_tile_0/carry_0_probe VDD_3V3_1 VDD_3V3_1 pfet_06v0 ad=21.472n pd=0.664m as=0 ps=0 w=244 l=100
X90 5v0_addh_sc_tile_0/pti in_1 VSS_3 VSS_3 nfet_06v0 ad=20.768n pd=0.824m as=0 ps=0 w=72 l=578
X91 VDD_3V3_1 in_1 5v0_addh_sc_tile_0/pti VDD_3V3_1 pfet_06v0 ad=0 pd=0 as=74.176n ps=2.072m w=244 l=100
X92 VDD_3V3_1 in_1 5v0_addh_sc_tile_0/nti VDD_3V3_1 pfet_06v0 ad=0 pd=0 as=9.696n ps=0.394m w=96 l=150
X93 VSS_3 in_1 5v0_addh_sc_tile_0/nti VSS_3 nfet_06v0 ad=0 pd=0 as=12.7n ps=0.454m w=127 l=120
X94 5v0_addh_sc_tile_0/pti in_1 VDD_3V3_1 VDD_3V3_1 pfet_06v0 ad=0 pd=0 as=0 ps=0 w=244 l=100
X95 5v0_addh_sc_tile_0/pti in_1 VDD_3V3_1 VDD_3V3_1 pfet_06v0 ad=0 pd=0 as=0 ps=0 w=244 l=100
X96 5v0_addh_sc_tile_0/5v0_half_adder_selector_sc_0/res_stage0 5v0_addh_sc_tile_0/m1_103_293# 5v0_addh_sc_tile_0/downstepper_test VSS_3 nfet_06v0 ad=31.489n pd=1.041m as=31.631n ps=1.032m w=164 l=120
X97 5v0_addh_sc_tile_0/5v0_half_adder_selector_sc_0/res_stage0 5v0_addh_sc_tile_0/m1_103_293# 5v0_addh_sc_tile_0/upstepper_test VDD_3V3_1 pfet_06v0 ad=46.849n pd=1.361m as=42.856n ps=1.326m w=244 l=100
X98 5v0_addh_sc_tile_0/m1_103_293# in_0_sign VSS_3 VSS_3 nfet_06v0 ad=14.432n pd=0.504m as=0 ps=0 w=164 l=120
X99 5v0_addh_sc_tile_0/m1_103_293# in_0_sign VDD_3V3_1 VDD_3V3_1 pfet_06v0 ad=21.472n pd=0.664m as=0 ps=0 w=244 l=100
X100 5v0_addh_sc_tile_0/5v0_half_adder_selector_sc_0/res_stage0 in_0_sign 5v0_addh_sc_tile_0/upstepper_test VSS_3 nfet_06v0 ad=0 pd=0 as=43.711n ps=1.504m w=164 l=120
X101 5v0_addh_sc_tile_0/5v0_half_adder_selector_sc_0/res_stage0 in_0_sign 5v0_addh_sc_tile_0/downstepper_test VDD_3V3_1 pfet_06v0 ad=0 pd=0 as=42.856n ps=1.326m w=244 l=100
X102 5v0_addh_sc_tile_1/ternary_input 5v0_addh_sc_tile_0/a_382_n1095# 5v0_addh_sc_tile_0/5v0_half_adder_selector_sc_0/res_stage0 VSS_3 nfet_06v0 ad=31.489n pd=1.041m as=0 ps=0 w=164 l=120
X103 5v0_addh_sc_tile_1/ternary_input 5v0_addh_sc_tile_0/a_382_n1095# in_1 VDD_3V3_1 pfet_06v0 ad=46.849n pd=1.361m as=21.472n ps=0.664m w=244 l=100
X104 5v0_addh_sc_tile_0/a_382_n1095# in_0_over VSS_3 VSS_3 nfet_06v0 ad=14.432n pd=0.504m as=0 ps=0 w=164 l=120
X105 5v0_addh_sc_tile_0/a_382_n1095# in_0_over VDD_3V3_1 VDD_3V3_1 pfet_06v0 ad=21.472n pd=0.664m as=0 ps=0 w=244 l=100
X106 5v0_addh_sc_tile_1/ternary_input in_0_over in_1 VSS_3 nfet_06v0 ad=0 pd=0 as=14.432n ps=0.504m w=164 l=120
X107 5v0_addh_sc_tile_1/ternary_input in_0_over 5v0_addh_sc_tile_0/5v0_half_adder_selector_sc_0/res_stage0 VDD_3V3_1 pfet_06v0 ad=0 pd=0 as=0 ps=0 w=244 l=100
X108 5v0_addh_sc_tile_0/inv_pti 5v0_addh_sc_tile_0/pti VSS_3 VSS_3 nfet_06v0 ad=28.864n pd=1.008m as=0 ps=0 w=164 l=120
X109 5v0_addh_sc_tile_0/inv_pti 5v0_addh_sc_tile_0/pti VDD_3V3_1 VDD_3V3_1 pfet_06v0 ad=42.944n pd=1.328m as=0 ps=0 w=244 l=100
X110 5v0_addh_sc_tile_0/carry_0_probe 5v0_addh_sc_tile_0/a_382_n1095# 5v0_addh_sc_tile_0/m1_843_n857# VSS_3 nfet_06v0 ad=14.432n pd=0.504m as=14.432n ps=0.504m w=164 l=120
X111 5v0_addh_sc_tile_0/carry_0_probe in_0_over 5v0_addh_sc_tile_0/m1_843_n857# VDD_3V3_1 pfet_06v0 ad=21.472n pd=0.664m as=21.472n ps=0.664m w=244 l=100
X112 5v0_addh_sc_tile_0/inv_nti in_0_sign 5v0_addh_sc_tile_0/carry_sign_probe VDD_3V3_1 pfet_06v0 ad=21.472n pd=0.664m as=12.688n ps=0.348m w=244 l=100
X113 5v0_addh_sc_tile_0/carry_sign_probe 5v0_addh_sc_tile_0/m1_103_293# 5v0_addh_sc_tile_0/inv_nti VSS_3 nfet_06v0 ad=8.528n pd=0.268m as=14.432n ps=0.504m w=164 l=120
X114 5v0_addh_sc_tile_0/carry_sign_probe 5v0_addh_sc_tile_0/m1_103_293# 5v0_addh_sc_tile_0/inv_pti VDD_3V3_1 pfet_06v0 ad=12.688n pd=0.348m as=21.472n ps=0.664m w=244 l=100
X115 5v0_addh_sc_tile_0/inv_pti in_0_sign 5v0_addh_sc_tile_0/carry_sign_probe VSS_3 nfet_06v0 ad=14.432n pd=0.504m as=8.528n ps=0.268m w=164 l=120
X116 5v0_addh_sc_tile_0/inv_nti in_0_sign 5v0_addh_sc_tile_0/m1_843_n857# VDD_3V3_1 pfet_06v0 ad=64.416n pd=1.992m as=46.848n ps=1.36m w=244 l=100
X117 5v0_addh_sc_tile_0/m1_843_n857# 5v0_addh_sc_tile_0/m1_103_293# 5v0_addh_sc_tile_0/inv_nti VSS_3 nfet_06v0 ad=31.488n pd=1.04m as=43.296n ps=1.512m w=164 l=120
X118 5v0_addh_sc_tile_0/m1_843_n857# 5v0_addh_sc_tile_0/m1_103_293# 5v0_addh_sc_tile_0/pti VDD_3V3_1 pfet_06v0 ad=0 pd=0 as=0 ps=0 w=244 l=100
X119 5v0_addh_sc_tile_0/pti in_0_sign 5v0_addh_sc_tile_0/m1_843_n857# VSS_3 nfet_06v0 ad=0 pd=0 as=0 ps=0 w=164 l=120
X120 5v0_addh_sc_tile_0/a_n1373_n454# 5v0_addh_sc_tile_0/inv_nti 5v0_addh_sc_tile_0/downstepper_test VSS_3 nfet_06v0 ad=3.528n pd=0.195m as=8.599n ps=0.264m w=147 l=120
X121 5v0_addh_sc_tile_0/upstepper_test 5v0_addh_sc_tile_0/nti 5v0_addh_sc_tile_0/a_n1205_n937# VDD_3V3_1 pfet_06v0 ad=21.384n pd=0.662m as=5.832n ps=0.291m w=243 l=100
X122 5v0_addh_sc_tile_0/inv_nti 5v0_addh_sc_tile_0/nti VDD_3V3_1 VDD_3V3_1 pfet_06v0 ad=21.472n pd=0.664m as=21.472n ps=0.664m w=244 l=100
X123 5v0_addh_sc_tile_0/upstepper_test 5v0_addh_sc_tile_0/nti VDD_1V65_0 VSS_3 nfet_06v0 ad=14.847n pd=0.496m as=10.51n ps=0.29m w=147 l=120
X124 5v0_addh_sc_tile_0/carry_0_probe 5v0_addh_sc_tile_0/a_382_n1095# VDD_3V3_1 VDD_3V3_1 pfet_06v0 ad=21.472n pd=0.664m as=21.472n ps=0.664m w=244 l=100
X125 5v0_addh_sc_tile_0/a_n1205_n937# 5v0_addh_sc_tile_0/inv_pti VDD_3V3_1 VDD_3V3_1 pfet_06v0 ad=5.832n pd=0.291m as=21.384n ps=0.662m w=243 l=100
X126 5v0_addh_sc_tile_0/downstepper_test 5v0_addh_sc_tile_0/pti 5v0_addh_sc_tile_0/a_n1778_n454# VSS_3 nfet_06v0 ad=8.599n pd=0.264m as=3.528n ps=0.195m w=147 l=120
X127 5v0_addh_sc_tile_0/inv_nti 5v0_addh_sc_tile_0/nti VSS_3 VSS_3 nfet_06v0 ad=14.432n pd=0.504m as=14.432n ps=0.504m w=164 l=120
X128 5v0_addh_sc_tile_0/a_n1778_n454# 5v0_addh_sc_tile_0/inv_nti VSS_3 VSS_3 nfet_06v0 ad=3.528n pd=0.195m as=14.847n ps=0.496m w=147 l=120
X129 5v0_addh_sc_tile_0/upstepper_test 5v0_addh_sc_tile_0/inv_pti VSS_3 VSS_3 nfet_06v0 ad=14.432n pd=0.504m as=14.432n ps=0.504m w=164 l=120
X130 VDD_1V65_0 5v0_addh_sc_tile_0/inv_pti 5v0_addh_sc_tile_0/a_n1373_n454# VSS_3 nfet_06v0 ad=10.51n pd=0.29m as=3.528n ps=0.195m w=147 l=120
X131 5v0_addh_sc_tile_0/downstepper_test 5v0_addh_sc_tile_0/inv_nti VDD_3V3_1 VDD_3V3_1 pfet_06v0 ad=21.384n pd=0.662m as=21.384n ps=0.662m w=243 l=100
X132 5v0_addh_sc_tile_1/pti 5v0_addh_sc_tile_1/ternary_input VSS_3 VSS_3 nfet_06v0 ad=20.768n pd=0.824m as=0 ps=0 w=72 l=578
X133 VDD_3V3_1 5v0_addh_sc_tile_1/ternary_input 5v0_addh_sc_tile_1/pti VDD_3V3_1 pfet_06v0 ad=0 pd=0 as=74.176n ps=2.072m w=244 l=100
X134 VDD_3V3_1 5v0_addh_sc_tile_1/ternary_input 5v0_addh_sc_tile_1/nti VDD_3V3_1 pfet_06v0 ad=0 pd=0 as=9.696n ps=0.394m w=96 l=150
X135 VSS_3 5v0_addh_sc_tile_1/ternary_input 5v0_addh_sc_tile_1/nti VSS_3 nfet_06v0 ad=0 pd=0 as=12.7n ps=0.454m w=127 l=120
X136 5v0_addh_sc_tile_1/pti 5v0_addh_sc_tile_1/ternary_input VDD_3V3_1 VDD_3V3_1 pfet_06v0 ad=0 pd=0 as=0 ps=0 w=244 l=100
X137 5v0_addh_sc_tile_1/pti 5v0_addh_sc_tile_1/ternary_input VDD_3V3_1 VDD_3V3_1 pfet_06v0 ad=0 pd=0 as=0 ps=0 w=244 l=100
X138 5v0_addh_sc_tile_1/5v0_half_adder_selector_sc_0/res_stage0 5v0_addh_sc_tile_1/m1_103_293# 5v0_addh_sc_tile_1/downstepper_test VSS_3 nfet_06v0 ad=31.489n pd=1.041m as=31.631n ps=1.032m w=164 l=120
X139 5v0_addh_sc_tile_1/5v0_half_adder_selector_sc_0/res_stage0 5v0_addh_sc_tile_1/m1_103_293# 5v0_addh_sc_tile_1/upstepper_test VDD_3V3_1 pfet_06v0 ad=46.849n pd=1.361m as=42.856n ps=1.326m w=244 l=100
X140 5v0_addh_sc_tile_1/m1_103_293# 5v0_addh_sc_tile_1/ctrl_sign VSS_3 VSS_3 nfet_06v0 ad=14.432n pd=0.504m as=0 ps=0 w=164 l=120
X141 5v0_addh_sc_tile_1/m1_103_293# 5v0_addh_sc_tile_1/ctrl_sign VDD_3V3_1 VDD_3V3_1 pfet_06v0 ad=21.472n pd=0.664m as=0 ps=0 w=244 l=100
X142 5v0_addh_sc_tile_1/5v0_half_adder_selector_sc_0/res_stage0 5v0_addh_sc_tile_1/ctrl_sign 5v0_addh_sc_tile_1/upstepper_test VSS_3 nfet_06v0 ad=0 pd=0 as=43.711n ps=1.504m w=164 l=120
X143 5v0_addh_sc_tile_1/5v0_half_adder_selector_sc_0/res_stage0 5v0_addh_sc_tile_1/ctrl_sign 5v0_addh_sc_tile_1/downstepper_test VDD_3V3_1 pfet_06v0 ad=0 pd=0 as=42.856n ps=1.326m w=244 l=100
X144 5v0_nter2oter_code_sc_0/in 5v0_addh_sc_tile_1/a_382_n1095# 5v0_addh_sc_tile_1/5v0_half_adder_selector_sc_0/res_stage0 VSS_3 nfet_06v0 ad=17.057n pd=0.537m as=0 ps=0 w=164 l=120
X145 5v0_nter2oter_code_sc_0/in 5v0_addh_sc_tile_1/a_382_n1095# 5v0_addh_sc_tile_1/ternary_input VDD_3V3_0 pfet_06v0 ad=25.377n pd=0.697m as=0 ps=0 w=244 l=100
X146 5v0_addh_sc_tile_1/a_382_n1095# 5v0_addh_sc_tile_1/ctrl_over VSS_3 VSS_3 nfet_06v0 ad=14.432n pd=0.504m as=0 ps=0 w=164 l=120
X147 5v0_addh_sc_tile_1/a_382_n1095# 5v0_addh_sc_tile_1/ctrl_over VDD_3V3_0 VDD_3V3_0 pfet_06v0 ad=21.472n pd=0.664m as=0 ps=0 w=244 l=100
X148 5v0_nter2oter_code_sc_0/in 5v0_addh_sc_tile_1/ctrl_over 5v0_addh_sc_tile_1/ternary_input VSS_3 nfet_06v0 ad=0 pd=0 as=0 ps=0 w=164 l=120
X149 5v0_nter2oter_code_sc_0/in 5v0_addh_sc_tile_1/ctrl_over 5v0_addh_sc_tile_1/5v0_half_adder_selector_sc_0/res_stage0 VDD_3V3_0 pfet_06v0 ad=0 pd=0 as=0 ps=0 w=244 l=100
X150 5v0_addh_sc_tile_1/inv_pti 5v0_addh_sc_tile_1/pti VSS_3 VSS_3 nfet_06v0 ad=28.864n pd=1.008m as=0 ps=0 w=164 l=120
X151 5v0_addh_sc_tile_1/inv_pti 5v0_addh_sc_tile_1/pti VDD_3V3_1 VDD_3V3_1 pfet_06v0 ad=42.944n pd=1.328m as=0 ps=0 w=244 l=100
X152 5v0_add_q_sc_1/ctrl_over 5v0_addh_sc_tile_1/a_382_n1095# 5v0_addh_sc_tile_1/m1_843_n857# VSS_3 nfet_06v0 ad=14.432n pd=0.504m as=31.488n ps=1.04m w=164 l=120
X153 5v0_add_q_sc_1/ctrl_over 5v0_addh_sc_tile_1/ctrl_over 5v0_addh_sc_tile_1/m1_843_n857# VDD_3V3_0 pfet_06v0 ad=42.944n pd=1.328m as=46.848n ps=1.36m w=244 l=100
X154 5v0_addh_sc_tile_1/inv_nti 5v0_addh_sc_tile_1/ctrl_sign 5v0_add_q_sc_1/ctrl_sign VDD_3V3_1 pfet_06v0 ad=64.416n pd=1.992m as=25.376n ps=0.696m w=244 l=100
X155 5v0_add_q_sc_1/ctrl_sign 5v0_addh_sc_tile_1/m1_103_293# 5v0_addh_sc_tile_1/inv_nti VSS_3 nfet_06v0 ad=17.056n pd=0.536m as=43.296n ps=1.512m w=164 l=120
X156 5v0_add_q_sc_1/ctrl_sign 5v0_addh_sc_tile_1/m1_103_293# 5v0_addh_sc_tile_1/inv_pti VDD_3V3_1 pfet_06v0 ad=0 pd=0 as=0 ps=0 w=244 l=100
X157 5v0_addh_sc_tile_1/inv_pti 5v0_addh_sc_tile_1/ctrl_sign 5v0_add_q_sc_1/ctrl_sign VSS_3 nfet_06v0 ad=0 pd=0 as=0 ps=0 w=164 l=120
X158 5v0_addh_sc_tile_1/inv_nti 5v0_addh_sc_tile_1/ctrl_sign 5v0_addh_sc_tile_1/m1_843_n857# VDD_3V3_0 pfet_06v0 ad=0 pd=0 as=0 ps=0 w=244 l=100
X159 5v0_addh_sc_tile_1/m1_843_n857# 5v0_addh_sc_tile_1/m1_103_293# 5v0_addh_sc_tile_1/inv_nti VSS_3 nfet_06v0 ad=0 pd=0 as=0 ps=0 w=164 l=120
X160 5v0_addh_sc_tile_1/m1_843_n857# 5v0_addh_sc_tile_1/m1_103_293# 5v0_addh_sc_tile_1/pti VDD_3V3_0 pfet_06v0 ad=0 pd=0 as=0 ps=0 w=244 l=100
X161 5v0_addh_sc_tile_1/pti 5v0_addh_sc_tile_1/ctrl_sign 5v0_addh_sc_tile_1/m1_843_n857# VSS_3 nfet_06v0 ad=0 pd=0 as=0 ps=0 w=164 l=120
X162 5v0_addh_sc_tile_1/a_n1373_n454# 5v0_addh_sc_tile_1/inv_nti 5v0_addh_sc_tile_1/downstepper_test VSS_3 nfet_06v0 ad=7.056n pd=0.39m as=0 ps=0 w=147 l=120
X163 5v0_addh_sc_tile_1/upstepper_test 5v0_addh_sc_tile_1/nti 5v0_addh_sc_tile_1/a_n1205_n937# VDD_3V3_0 pfet_06v0 ad=0 pd=0 as=11.664n ps=0.582m w=243 l=100
X164 5v0_addh_sc_tile_1/inv_nti 5v0_addh_sc_tile_1/nti VDD_3V3_0 VDD_3V3_0 pfet_06v0 ad=0 pd=0 as=0 ps=0 w=244 l=100
X165 5v0_addh_sc_tile_1/upstepper_test 5v0_addh_sc_tile_1/nti VDD_1V65_3 VSS_3 nfet_06v0 ad=0 pd=0 as=21.021n ps=0.58m w=147 l=120
X166 5v0_add_q_sc_1/ctrl_over 5v0_addh_sc_tile_1/a_382_n1095# VDD_3V3_0 VDD_3V3_0 pfet_06v0 ad=0 pd=0 as=0 ps=0 w=244 l=100
X167 5v0_addh_sc_tile_1/a_n1205_n937# 5v0_addh_sc_tile_1/inv_pti VDD_3V3_0 VDD_3V3_0 pfet_06v0 ad=0 pd=0 as=0 ps=0 w=243 l=100
X168 5v0_addh_sc_tile_1/downstepper_test 5v0_addh_sc_tile_1/pti 5v0_addh_sc_tile_1/a_n1778_n454# VSS_3 nfet_06v0 ad=0 pd=0 as=7.056n ps=0.39m w=147 l=120
X169 5v0_addh_sc_tile_1/inv_nti 5v0_addh_sc_tile_1/nti VSS_3 VSS_3 nfet_06v0 ad=0 pd=0 as=0 ps=0 w=164 l=120
X170 5v0_addh_sc_tile_1/a_n1778_n454# 5v0_addh_sc_tile_1/inv_nti VSS_3 VSS_3 nfet_06v0 ad=0 pd=0 as=0 ps=0 w=147 l=120
X171 5v0_addh_sc_tile_1/upstepper_test 5v0_addh_sc_tile_1/inv_pti VSS_3 VSS_3 nfet_06v0 ad=0 pd=0 as=0 ps=0 w=164 l=120
X172 VDD_1V65_3 5v0_addh_sc_tile_1/inv_pti 5v0_addh_sc_tile_1/a_n1373_n454# VSS_3 nfet_06v0 ad=0 pd=0 as=0 ps=0 w=147 l=120
X173 5v0_addh_sc_tile_1/downstepper_test 5v0_addh_sc_tile_1/inv_nti VDD_3V3_0 VDD_3V3_0 pfet_06v0 ad=0 pd=0 as=0 ps=0 w=243 l=100
X174 5v0_addh_sc_tile_2/pti in_3 VSS_3 VSS_3 nfet_06v0 ad=20.768n pd=0.824m as=0 ps=0 w=72 l=578
X175 VDD_3V3_0 in_3 5v0_addh_sc_tile_2/pti VDD_3V3_0 pfet_06v0 ad=0 pd=0 as=74.176n ps=2.072m w=244 l=100
X176 VDD_3V3_0 in_3 5v0_addh_sc_tile_2/nti VDD_3V3_0 pfet_06v0 ad=0 pd=0 as=9.696n ps=0.394m w=96 l=150
X177 VSS_3 in_3 5v0_addh_sc_tile_2/nti VSS_3 nfet_06v0 ad=0 pd=0 as=12.7n ps=0.454m w=127 l=120
X178 5v0_addh_sc_tile_2/pti in_3 VDD_3V3_0 VDD_3V3_0 pfet_06v0 ad=0 pd=0 as=0 ps=0 w=244 l=100
X179 5v0_addh_sc_tile_2/pti in_3 VDD_3V3_0 VDD_3V3_0 pfet_06v0 ad=0 pd=0 as=0 ps=0 w=244 l=100
X180 5v0_addh_sc_tile_2/5v0_half_adder_selector_sc_0/res_stage0 5v0_addh_sc_tile_2/m1_103_293# 5v0_addh_sc_tile_2/downstepper_test VSS_3 nfet_06v0 ad=31.489n pd=1.041m as=31.631n ps=1.032m w=164 l=120
X181 5v0_addh_sc_tile_2/5v0_half_adder_selector_sc_0/res_stage0 5v0_addh_sc_tile_2/m1_103_293# 5v0_addh_sc_tile_2/upstepper_test VDD_3V3_0 pfet_06v0 ad=46.849n pd=1.361m as=42.856n ps=1.326m w=244 l=100
X182 5v0_addh_sc_tile_2/m1_103_293# 5v0_addh_sc_tile_2/ctrl_sign VSS_3 VSS_3 nfet_06v0 ad=14.432n pd=0.504m as=0 ps=0 w=164 l=120
X183 5v0_addh_sc_tile_2/m1_103_293# 5v0_addh_sc_tile_2/ctrl_sign VDD_3V3_0 VDD_3V3_0 pfet_06v0 ad=21.472n pd=0.664m as=0 ps=0 w=244 l=100
X184 5v0_addh_sc_tile_2/5v0_half_adder_selector_sc_0/res_stage0 5v0_addh_sc_tile_2/ctrl_sign 5v0_addh_sc_tile_2/upstepper_test VSS_3 nfet_06v0 ad=0 pd=0 as=43.711n ps=1.504m w=164 l=120
X185 5v0_addh_sc_tile_2/5v0_half_adder_selector_sc_0/res_stage0 5v0_addh_sc_tile_2/ctrl_sign 5v0_addh_sc_tile_2/downstepper_test VDD_3V3_0 pfet_06v0 ad=0 pd=0 as=42.856n ps=1.326m w=244 l=100
X186 res_0 5v0_addh_sc_tile_2/a_382_n1095# 5v0_addh_sc_tile_2/5v0_half_adder_selector_sc_0/res_stage0 VSS_3 nfet_06v0 ad=17.057n pd=0.537m as=0 ps=0 w=164 l=120
X187 res_0 5v0_addh_sc_tile_2/a_382_n1095# in_3 VDD_3V3_0 pfet_06v0 ad=25.377n pd=0.697m as=21.472n ps=0.664m w=244 l=100
X188 5v0_addh_sc_tile_2/a_382_n1095# 5v0_addh_sc_tile_2/ctrl_over VSS_3 VSS_3 nfet_06v0 ad=14.432n pd=0.504m as=0 ps=0 w=164 l=120
X189 5v0_addh_sc_tile_2/a_382_n1095# 5v0_addh_sc_tile_2/ctrl_over VDD_3V3_0 VDD_3V3_0 pfet_06v0 ad=21.472n pd=0.664m as=0 ps=0 w=244 l=100
X190 res_0 5v0_addh_sc_tile_2/ctrl_over in_3 VSS_3 nfet_06v0 ad=0 pd=0 as=14.432n ps=0.504m w=164 l=120
X191 res_0 5v0_addh_sc_tile_2/ctrl_over 5v0_addh_sc_tile_2/5v0_half_adder_selector_sc_0/res_stage0 VDD_3V3_0 pfet_06v0 ad=0 pd=0 as=0 ps=0 w=244 l=100
X192 5v0_addh_sc_tile_2/inv_pti 5v0_addh_sc_tile_2/pti VSS_3 VSS_3 nfet_06v0 ad=28.864n pd=1.008m as=0 ps=0 w=164 l=120
X193 5v0_addh_sc_tile_2/inv_pti 5v0_addh_sc_tile_2/pti VDD_3V3_0 VDD_3V3_0 pfet_06v0 ad=42.944n pd=1.328m as=0 ps=0 w=244 l=100
X194 5v0_add_q_sc_0/ctrl_over 5v0_addh_sc_tile_2/a_382_n1095# 5v0_addh_sc_tile_2/m1_843_n857# VSS_3 nfet_06v0 ad=14.432n pd=0.504m as=31.488n ps=1.04m w=164 l=120
X195 5v0_add_q_sc_0/ctrl_over 5v0_addh_sc_tile_2/ctrl_over 5v0_addh_sc_tile_2/m1_843_n857# VDD_3V3_0 pfet_06v0 ad=42.944n pd=1.328m as=46.848n ps=1.36m w=244 l=100
X196 5v0_addh_sc_tile_2/inv_nti 5v0_addh_sc_tile_2/ctrl_sign 5v0_add_q_sc_0/ctrl_sign VDD_3V3_0 pfet_06v0 ad=64.416n pd=1.992m as=25.376n ps=0.696m w=244 l=100
X197 5v0_add_q_sc_0/ctrl_sign 5v0_addh_sc_tile_2/m1_103_293# 5v0_addh_sc_tile_2/inv_nti VSS_3 nfet_06v0 ad=17.056n pd=0.536m as=43.296n ps=1.512m w=164 l=120
X198 5v0_add_q_sc_0/ctrl_sign 5v0_addh_sc_tile_2/m1_103_293# 5v0_addh_sc_tile_2/inv_pti VDD_3V3_0 pfet_06v0 ad=0 pd=0 as=0 ps=0 w=244 l=100
X199 5v0_addh_sc_tile_2/inv_pti 5v0_addh_sc_tile_2/ctrl_sign 5v0_add_q_sc_0/ctrl_sign VSS_3 nfet_06v0 ad=0 pd=0 as=0 ps=0 w=164 l=120
X200 5v0_addh_sc_tile_2/inv_nti 5v0_addh_sc_tile_2/ctrl_sign 5v0_addh_sc_tile_2/m1_843_n857# VDD_3V3_0 pfet_06v0 ad=0 pd=0 as=0 ps=0 w=244 l=100
X201 5v0_addh_sc_tile_2/m1_843_n857# 5v0_addh_sc_tile_2/m1_103_293# 5v0_addh_sc_tile_2/inv_nti VSS_3 nfet_06v0 ad=0 pd=0 as=0 ps=0 w=164 l=120
X202 5v0_addh_sc_tile_2/m1_843_n857# 5v0_addh_sc_tile_2/m1_103_293# 5v0_addh_sc_tile_2/pti VDD_3V3_0 pfet_06v0 ad=0 pd=0 as=0 ps=0 w=244 l=100
X203 5v0_addh_sc_tile_2/pti 5v0_addh_sc_tile_2/ctrl_sign 5v0_addh_sc_tile_2/m1_843_n857# VSS_3 nfet_06v0 ad=0 pd=0 as=0 ps=0 w=164 l=120
X204 5v0_addh_sc_tile_2/a_n1373_n454# 5v0_addh_sc_tile_2/inv_nti 5v0_addh_sc_tile_2/downstepper_test VSS_3 nfet_06v0 ad=7.056n pd=0.39m as=0 ps=0 w=147 l=120
X205 5v0_addh_sc_tile_2/upstepper_test 5v0_addh_sc_tile_2/nti 5v0_addh_sc_tile_2/a_n1205_n937# VDD_3V3_0 pfet_06v0 ad=0 pd=0 as=11.664n ps=0.582m w=243 l=100
X206 5v0_addh_sc_tile_2/inv_nti 5v0_addh_sc_tile_2/nti VDD_3V3_0 VDD_3V3_0 pfet_06v0 ad=0 pd=0 as=0 ps=0 w=244 l=100
X207 5v0_addh_sc_tile_2/upstepper_test 5v0_addh_sc_tile_2/nti VDD_1V65_4 VSS_3 nfet_06v0 ad=0 pd=0 as=21.021n ps=0.58m w=147 l=120
X208 5v0_add_q_sc_0/ctrl_over 5v0_addh_sc_tile_2/a_382_n1095# VDD_3V3_0 VDD_3V3_0 pfet_06v0 ad=0 pd=0 as=0 ps=0 w=244 l=100
X209 5v0_addh_sc_tile_2/a_n1205_n937# 5v0_addh_sc_tile_2/inv_pti VDD_3V3_0 VDD_3V3_0 pfet_06v0 ad=0 pd=0 as=0 ps=0 w=243 l=100
X210 5v0_addh_sc_tile_2/downstepper_test 5v0_addh_sc_tile_2/pti 5v0_addh_sc_tile_2/a_n1778_n454# VSS_3 nfet_06v0 ad=0 pd=0 as=7.056n ps=0.39m w=147 l=120
X211 5v0_addh_sc_tile_2/inv_nti 5v0_addh_sc_tile_2/nti VSS_3 VSS_3 nfet_06v0 ad=0 pd=0 as=0 ps=0 w=164 l=120
X212 5v0_addh_sc_tile_2/a_n1778_n454# 5v0_addh_sc_tile_2/inv_nti VSS_3 VSS_3 nfet_06v0 ad=0 pd=0 as=0 ps=0 w=147 l=120
X213 5v0_addh_sc_tile_2/upstepper_test 5v0_addh_sc_tile_2/inv_pti VSS_3 VSS_3 nfet_06v0 ad=0 pd=0 as=0 ps=0 w=164 l=120
X214 VDD_1V65_4 5v0_addh_sc_tile_2/inv_pti 5v0_addh_sc_tile_2/a_n1373_n454# VSS_3 nfet_06v0 ad=0 pd=0 as=0 ps=0 w=147 l=120
X215 5v0_addh_sc_tile_2/downstepper_test 5v0_addh_sc_tile_2/inv_nti VDD_3V3_0 VDD_3V3_0 pfet_06v0 ad=0 pd=0 as=0 ps=0 w=243 l=100
C0 in_3 5v0_addh_sc_tile_1/ctrl_sign 0
C1 5v0_addh_sc_tile_1/a_n1373_n454# VDD_1V65_3 0.00232f
C2 5v0_addh_sc_tile_2/a_382_n1095# 5v0_add_q_sc_0/nti 0
C3 in_1 in_2 0
C4 5v0_addh_sc_tile_2/5v0_half_adder_selector_sc_0/res_stage0 5v0_addh_sc_tile_2/a_382_n1095# 0.08951f
C5 5v0_add_q_sc_1/5v0_half_adder_selector_sc_0/m1_n244_n517# 5v0_add_q_sc_1/ctrl_sign 0
C6 5v0_nter2oter_code_sc_1/pti 5v0_nter2oter_code_sc_0/pti 0.20957f
C7 VDD_3V3_0 5v0_nter2oter_code_sc_0/nti 0.31492f
C8 5v0_addh_sc_tile_1/inv_nti VDD_3V3_0 0.66943f
C9 5v0_add_q_sc_0/ctrl_sign 5v0_addh_sc_tile_1/downstepper_test 0.00426f
C10 5v0_addh_sc_tile_0/nti 5v0_nter2oter_code_sc_0/pti 0
C11 VDD_1V65_4 VDD_3V3_0 0.0468f
C12 5v0_addh_sc_tile_1/ctrl_over 5v0_add_q_sc_0/nti 0
C13 5v0_addh_sc_tile_2/inv_nti VDD_3V3_0 0.88474f
C14 5v0_addh_sc_tile_1/downstepper_test 5v0_nter2oter_code_sc_0/in 0.03365f
C15 5v0_addh_sc_tile_1/pti 5v0_add_q_sc_0/inv_pti 0
C16 5v0_addh_sc_tile_1/ctrl_over 5v0_addh_sc_tile_1/ctrl_sign 0.49329f
C17 in_2 5v0_addh_sc_tile_0/pti 0
C18 5v0_add_q_sc_0/inv_pti VDD_1V65_5 0.14775f
C19 5v0_add_q_sc_1/5v0_half_adder_selector_sc_0/res_stage0 5v0_add_q_sc_1/inv_pti 0
C20 5v0_addh_sc_tile_1/pti 5v0_addh_sc_tile_1/a_n1778_n454# 0.00135f
C21 5v0_addh_sc_tile_2/ctrl_sign VDD_3V3_0 1.61336f
C22 5v0_addh_sc_tile_0/carry_sign_probe in_0_sign 0.24834f
C23 5v0_addh_sc_tile_0/5v0_half_adder_selector_sc_0/res_stage0 5v0_addh_sc_tile_0/m1_103_293# 0.18549f
C24 5v0_addh_sc_tile_1/a_382_n1095# 5v0_addh_sc_tile_1/downstepper_test 0.00679f
C25 5v0_add_q_sc_0/a_n1373_n454# 5v0_add_q_sc_0/inv_nti 0
C26 5v0_addh_sc_tile_0/a_382_n1095# 5v0_addh_sc_tile_1/inv_pti 0
C27 5v0_add_q_sc_1/ternary_input 5v0_addh_sc_tile_0/pti 0.00103f
C28 5v0_add_q_sc_0/ctrl_over 5v0_add_q_sc_0/5v0_half_adder_selector_sc_0/5v0_tgate_sel_2_sc_1/input_A 0.04656f
C29 VDD_3V3_0 5v0_addh_sc_tile_2/downstepper_test 0.5243f
C30 5v0_addh_sc_tile_0/carry_0_probe 5v0_addh_sc_tile_1/inv_nti 0
C31 in_2 5v0_nter2oter_code_sc_0/in 0.00863f
C32 5v0_add_q_sc_1/pti 5v0_add_q_sc_1/inv_pti 0.19726f
C33 in_1 5v0_nter2oter_code_sc_0/pti 0
C34 5v0_addh_sc_tile_1/m1_103_293# 5v0_addh_sc_tile_1/m1_843_n857# 0.20659f
C35 5v0_addh_sc_tile_1/m1_103_293# 5v0_addh_sc_tile_1/inv_pti 0.17653f
C36 5v0_add_q_sc_1/a_n1778_n454# 5v0_add_q_sc_1/downstepper_test 0.0031f
C37 5v0_addh_sc_tile_1/inv_pti 5v0_addh_sc_tile_1/upstepper_test 0.06901f
C38 VDD_3V3_1 5v0_add_q_sc_1/5v0_half_adder_selector_sc_0/res_stage0 0.14945f
C39 5v0_addh_sc_tile_1/downstepper_test 5v0_addh_sc_tile_2/inv_pti 0.01675f
C40 5v0_addh_sc_tile_2/a_382_n1095# 5v0_add_q_sc_0/ternary_input 0.0013f
C41 5v0_addh_sc_tile_1/5v0_half_adder_selector_sc_0/res_stage0 5v0_add_q_sc_1/ctrl_sign 0
C42 5v0_addh_sc_tile_1/m1_103_293# 5v0_add_q_sc_0/upstepper_test 0.00268f
C43 5v0_add_q_sc_1/nti 5v0_addh_sc_tile_0/carry_0_probe 0.11163f
C44 5v0_addh_sc_tile_0/5v0_half_adder_selector_sc_0/res_stage0 5v0_addh_sc_tile_0/nti 0.00372f
C45 5v0_add_q_sc_1/5v0_half_adder_selector_sc_0/res_stage0 5v0_add_q_sc_1/5v0_half_adder_selector_sc_0/m1_n244_n517# 0.08646f
C46 5v0_addh_sc_tile_2/upstepper_test 5v0_addh_sc_tile_2/ctrl_over 0.16997f
C47 5v0_addh_sc_tile_0/downstepper_test 5v0_addh_sc_tile_0/m1_103_293# 0.10533f
C48 VDD_3V3_1 5v0_add_q_sc_1/pti 0.56896f
C49 5v0_add_q_sc_0/5v0_half_adder_selector_sc_0/m1_n239_179# 5v0_add_q_sc_0/upstepper_test 0.07502f
C50 5v0_addh_sc_tile_1/ctrl_over 5v0_add_q_sc_0/ternary_input 0.01695f
C51 5v0_addh_sc_tile_0/carry_sign_probe 5v0_addh_sc_tile_0/m1_843_n857# 0.00703f
C52 5v0_addh_sc_tile_0/inv_nti 5v0_addh_sc_tile_1/nti 0
C53 in_2 5v0_addh_sc_tile_2/inv_pti 0
C54 5v0_add_q_sc_1/ternary_input VDD_1V65_2 0.02356f
C55 in_0_sign 5v0_addh_sc_tile_1/ctrl_sign 0
C56 5v0_addh_sc_tile_1/ternary_input 5v0_addh_sc_tile_0/inv_nti 0.0179f
C57 5v0_add_q_sc_0/downstepper_test 5v0_add_q_sc_1/ctrl_over 0.0085f
C58 5v0_addh_sc_tile_1/ctrl_over 5v0_add_q_sc_0/pti 0.00209f
C59 5v0_addh_sc_tile_0/a_382_n1095# 5v0_addh_sc_tile_1/inv_nti 0
C60 5v0_addh_sc_tile_2/a_n1373_n454# 5v0_addh_sc_tile_2/pti 0
C61 5v0_add_q_sc_0/ctrl_sign 5v0_addh_sc_tile_2/m1_103_293# 0.21173f
C62 5v0_addh_sc_tile_0/5v0_half_adder_selector_sc_0/res_stage0 5v0_addh_sc_tile_0/5v0_half_adder_selector_sc_0/5v0_tgate_sel_2_sc_1/input_A 0.00253f
C63 5v0_addh_sc_tile_2/m1_103_293# 5v0_nter2oter_code_sc_0/in 0.00332f
C64 5v0_add_q_sc_1/a_n1778_n454# 5v0_add_q_sc_1/ctrl_sign 0
C65 5v0_nter2oter_code_sc_0/in 5v0_nter2oter_code_sc_0/pti 0.58802f
C66 5v0_add_q_sc_1/a_n1373_n454# 5v0_add_q_sc_1/pti 0
C67 VDD_3V3_0 5v0_add_q_sc_0/5v0_half_adder_selector_sc_0/5v0_tgate_sel_2_sc_1/input_A 0.02871f
C68 VDD_3V3_1 5v0_nter2oter_code_sc_1/nti 0.0701f
C69 VDD_3V3_1 5v0_add_q_sc_1/inv_pti 0.40305f
C70 5v0_nter2oter_code_sc_1/pti 5v0_addh_sc_tile_0/downstepper_test 0.00775f
C71 5v0_addh_sc_tile_1/m1_103_293# 5v0_addh_sc_tile_1/inv_nti 0.35313f
C72 5v0_addh_sc_tile_1/inv_nti 5v0_addh_sc_tile_1/upstepper_test 0.00736f
C73 in_1 5v0_addh_sc_tile_0/5v0_half_adder_selector_sc_0/res_stage0 0.2646f
C74 5v0_nter2oter_code_sc_1/nti 5v0_addh_sc_tile_2/pti 0
C75 5v0_addh_sc_tile_0/downstepper_test 5v0_addh_sc_tile_0/nti 0.06935f
C76 5v0_addh_sc_tile_1/pti 5v0_addh_sc_tile_1/nti 0.24193f
C77 5v0_addh_sc_tile_0/upstepper_test VDD_1V65_0 0.16859f
C78 5v0_add_q_sc_0/5v0_half_adder_selector_sc_0/m1_n239_179# 5v0_addh_sc_tile_1/inv_nti 0
C79 5v0_addh_sc_tile_0/a_382_n1095# 5v0_add_q_sc_1/nti 0
C80 5v0_addh_sc_tile_1/ctrl_over res_c 0
C81 5v0_addh_sc_tile_1/pti 5v0_addh_sc_tile_1/ternary_input 0.67368f
C82 5v0_addh_sc_tile_2/upstepper_test VDD_3V3_0 0.46517f
C83 5v0_addh_sc_tile_1/downstepper_test 5v0_addh_sc_tile_1/a_n1205_n937# 0.00453f
C84 5v0_add_q_sc_1/a_n1373_n454# 5v0_add_q_sc_1/inv_pti 0.00135f
C85 5v0_addh_sc_tile_2/inv_nti 5v0_add_q_sc_0/5v0_half_adder_selector_sc_0/m1_n239_179# 0
C86 5v0_addh_sc_tile_2/ctrl_sign 5v0_addh_sc_tile_1/upstepper_test 0
C87 5v0_addh_sc_tile_1/m1_103_293# 5v0_add_q_sc_1/nti 0.00685f
C88 5v0_addh_sc_tile_2/m1_103_293# 5v0_addh_sc_tile_2/inv_pti 0.17639f
C89 VDD_3V3_1 in_0_over 0.64118f
C90 5v0_add_q_sc_1/5v0_half_adder_selector_sc_0/5v0_tgate_sel_2_sc_1/input_A 5v0_add_q_sc_1/ctrl_over 0.04656f
C91 5v0_addh_sc_tile_1/ctrl_sign 5v0_addh_sc_tile_0/m1_843_n857# 0
C92 5v0_addh_sc_tile_2/a_n1778_n454# 5v0_addh_sc_tile_2/pti 0.00135f
C93 5v0_addh_sc_tile_0/5v0_half_adder_selector_sc_0/res_stage0 5v0_addh_sc_tile_0/pti 0.01078f
C94 5v0_addh_sc_tile_2/nti 5v0_nter2oter_code_sc_0/nti 0.00237f
C95 5v0_add_q_sc_1/ctrl_over 5v0_nter2oter_code_sc_0/in 0
C96 5v0_addh_sc_tile_0/downstepper_test 5v0_addh_sc_tile_0/5v0_half_adder_selector_sc_0/5v0_tgate_sel_2_sc_1/input_A 0
C97 VDD_3V3_1 5v0_add_q_sc_1/5v0_half_adder_selector_sc_0/m1_n244_n517# 0.28925f
C98 VDD_1V65_4 5v0_addh_sc_tile_2/nti 0.21326f
C99 5v0_addh_sc_tile_2/inv_nti 5v0_addh_sc_tile_2/nti 0.22786f
C100 in_1 5v0_addh_sc_tile_0/downstepper_test 0.18203f
C101 m1_n2844_n810# 5v0_addh_sc_tile_0/inv_nti 0.02458f
C102 5v0_addh_sc_tile_1/a_382_n1095# 5v0_add_q_sc_1/ctrl_over 0.08702f
C103 VDD_3V3_1 5v0_add_q_sc_1/a_n1373_n454# 0.00122f
C104 5v0_addh_sc_tile_2/5v0_half_adder_selector_sc_0/res_stage0 5v0_add_q_sc_0/ctrl_over 0
C105 5v0_add_q_sc_0/ctrl_over 5v0_add_q_sc_0/nti 0.00167f
C106 5v0_addh_sc_tile_2/nti 5v0_addh_sc_tile_2/ctrl_sign 0.01914f
C107 5v0_add_q_sc_0/downstepper_test 5v0_add_q_sc_0/inv_pti 0.07797f
C108 5v0_add_q_sc_0/nti 5v0_addh_sc_tile_2/ctrl_over 0
C109 5v0_addh_sc_tile_0/inv_pti in_2 0.00153f
C110 5v0_addh_sc_tile_2/nti 5v0_addh_sc_tile_2/downstepper_test 0.06935f
C111 5v0_addh_sc_tile_2/5v0_half_adder_selector_sc_0/res_stage0 5v0_addh_sc_tile_2/ctrl_over 0.09179f
C112 5v0_addh_sc_tile_1/downstepper_test 5v0_addh_sc_tile_1/a_n1373_n454# 0.00442f
C113 5v0_addh_sc_tile_1/ctrl_over 5v0_add_q_sc_1/ctrl_sign 0
C114 5v0_addh_sc_tile_1/ctrl_sign 5v0_addh_sc_tile_2/ctrl_over 0
C115 5v0_add_q_sc_1/inv_nti 5v0_addh_sc_tile_1/ctrl_sign 0
C116 5v0_addh_sc_tile_0/downstepper_test 5v0_addh_sc_tile_0/pti 0.20149f
C117 res_0 5v0_addh_sc_tile_1/nti 0
C118 5v0_addh_sc_tile_1/a_n1778_n454# VDD_1V65_3 0
C119 5v0_addh_sc_tile_0/m1_103_293# 5v0_addh_sc_tile_1/nti 0
C120 5v0_addh_sc_tile_0/inv_pti 5v0_add_q_sc_1/ternary_input 0.00639f
C121 5v0_add_q_sc_1/a_n1778_n454# 5v0_add_q_sc_1/pti 0.00135f
C122 5v0_add_q_sc_1/ctrl_over 5v0_add_q_sc_0/inv_nti 0
C123 5v0_addh_sc_tile_0/m1_103_293# 5v0_addh_sc_tile_1/ternary_input 0
C124 5v0_add_q_sc_0/ctrl_sign 5v0_add_q_sc_0/inv_pti 0.00263f
C125 5v0_add_q_sc_0/downstepper_test 5v0_add_q_sc_0/5v0_half_adder_selector_sc_0/m1_n244_n517# 0.00507f
C126 VDD_3V3_1 5v0_addh_sc_tile_1/5v0_half_adder_selector_sc_0/res_stage0 0.01812f
C127 5v0_addh_sc_tile_0/carry_sign_probe 5v0_addh_sc_tile_0/carry_0_probe 0.0594f
C128 5v0_addh_sc_tile_1/5v0_half_adder_selector_sc_0/res_stage0 in_0_over 0
C129 5v0_add_q_sc_1/VDD_1V65 5v0_add_q_sc_1/downstepper_test 0.13024f
C130 5v0_nter2oter_code_sc_1/pti 5v0_addh_sc_tile_1/nti 0
C131 5v0_addh_sc_tile_1/inv_pti 5v0_addh_sc_tile_0/inv_nti 0
C132 5v0_nter2oter_code_sc_1/pti 5v0_addh_sc_tile_1/ternary_input 0
C133 5v0_addh_sc_tile_2/5v0_half_adder_selector_sc_0/res_stage0 VDD_3V3_0 0.16541f
C134 5v0_add_q_sc_0/ctrl_over 5v0_add_q_sc_0/ternary_input 0.15554f
C135 5v0_add_q_sc_0/nti VDD_3V3_0 0.63773f
C136 5v0_addh_sc_tile_1/a_382_n1095# 5v0_add_q_sc_0/inv_pti 0
C137 5v0_addh_sc_tile_1/ternary_input 5v0_addh_sc_tile_0/nti 0
C138 5v0_addh_sc_tile_1/ctrl_sign VDD_3V3_0 0.42962f
C139 5v0_add_q_sc_0/inv_pti 5v0_add_q_sc_0/5v0_half_adder_selector_sc_0/res_stage0 0
C140 5v0_add_q_sc_0/ternary_input 5v0_addh_sc_tile_2/ctrl_over 0.0068f
C141 in_0_sign 5v0_add_q_sc_1/ctrl_sign 0
C142 5v0_add_q_sc_0/ctrl_over 5v0_add_q_sc_0/pti 0
C143 5v0_addh_sc_tile_2/m1_103_293# 5v0_addh_sc_tile_1/downstepper_test 0.00921f
C144 in_3 5v0_addh_sc_tile_2/a_n1373_n454# 0.00163f
C145 5v0_add_q_sc_0/ctrl_sign 5v0_add_q_sc_0/5v0_half_adder_selector_sc_0/m1_n244_n517# 0
C146 5v0_addh_sc_tile_0/m1_103_293# m1_n2844_n810# 0
C147 5v0_addh_sc_tile_0/carry_sign_probe 5v0_addh_sc_tile_0/upstepper_test 0
C148 5v0_addh_sc_tile_1/m1_843_n857# 5v0_addh_sc_tile_1/pti 0.11666f
C149 5v0_addh_sc_tile_1/pti 5v0_addh_sc_tile_1/inv_pti 0.37325f
C150 5v0_add_q_sc_1/VDD_1V65 5v0_add_q_sc_1/ctrl_sign 0
C151 5v0_addh_sc_tile_2/upstepper_test 5v0_addh_sc_tile_2/nti 0.11981f
C152 5v0_nter2oter_code_sc_1/nti in_3 0
C153 in_1 5v0_addh_sc_tile_1/nti 0.00579f
C154 5v0_addh_sc_tile_0/a_n1778_n454# 5v0_addh_sc_tile_0/upstepper_test 0
C155 5v0_addh_sc_tile_0/carry_sign_probe 5v0_addh_sc_tile_0/a_382_n1095# 0.02324f
C156 5v0_addh_sc_tile_1/pti 5v0_add_q_sc_0/upstepper_test 0.0029f
C157 5v0_add_q_sc_0/inv_pti 5v0_add_q_sc_0/inv_nti 0.08256f
C158 in_2 5v0_nter2oter_code_sc_0/pti 0.00216f
C159 5v0_addh_sc_tile_0/carry_0_probe 5v0_addh_sc_tile_1/ctrl_sign 0.02298f
C160 in_1 5v0_addh_sc_tile_1/ternary_input 0.18462f
C161 VDD_1V65_5 5v0_add_q_sc_0/upstepper_test 0.16859f
C162 5v0_add_q_sc_0/ctrl_over res_c 0.20178f
C163 5v0_addh_sc_tile_1/a_382_n1095# 5v0_add_q_sc_0/5v0_half_adder_selector_sc_0/m1_n244_n517# 0
C164 VDD_1V65_3 5v0_addh_sc_tile_1/nti 0.21326f
C165 5v0_addh_sc_tile_0/carry_sign_probe 5v0_addh_sc_tile_1/upstepper_test 0
C166 5v0_add_q_sc_0/5v0_half_adder_selector_sc_0/m1_n244_n517# 5v0_add_q_sc_0/5v0_half_adder_selector_sc_0/res_stage0 0.08646f
C167 res_c 5v0_addh_sc_tile_2/ctrl_over 0.00127f
C168 5v0_addh_sc_tile_1/ternary_input VDD_1V65_3 0.01451f
C169 5v0_add_q_sc_1/ctrl_over 5v0_addh_sc_tile_1/downstepper_test 0
C170 5v0_addh_sc_tile_0/inv_pti 5v0_addh_sc_tile_0/5v0_half_adder_selector_sc_0/res_stage0 0.01365f
C171 5v0_add_q_sc_1/ctrl_sign 5v0_addh_sc_tile_0/m1_843_n857# 0
C172 in_3 5v0_addh_sc_tile_2/a_n1778_n454# 0.00182f
C173 5v0_add_q_sc_0/ternary_input VDD_3V3_0 1.58777f
C174 5v0_add_q_sc_1/inv_nti 5v0_add_q_sc_1/downstepper_test 0.17947f
C175 5v0_addh_sc_tile_0/pti 5v0_addh_sc_tile_1/nti 0
C176 5v0_nter2oter_code_sc_1/nti 5v0_addh_sc_tile_1/ctrl_over 0.2759f
C177 5v0_add_q_sc_0/ctrl_sign 5v0_addh_sc_tile_2/m1_843_n857# 0.00871f
C178 5v0_addh_sc_tile_1/5v0_half_adder_selector_sc_0/res_stage0 5v0_addh_sc_tile_1/5v0_half_adder_selector_sc_0/5v0_tgate_sel_2_sc_1/input_A 0.00253f
C179 5v0_addh_sc_tile_1/ternary_input 5v0_addh_sc_tile_0/pti 0
C180 5v0_add_q_sc_0/a_n1205_n937# VDD_1V65_5 0.00354f
C181 5v0_addh_sc_tile_2/ctrl_sign 5v0_addh_sc_tile_0/inv_nti 0
C182 5v0_add_q_sc_0/pti VDD_3V3_0 0.57843f
C183 in_3 5v0_addh_sc_tile_2/pti 0.66373f
C184 5v0_add_q_sc_0/ctrl_sign 5v0_addh_sc_tile_1/nti 0
C185 5v0_addh_sc_tile_0/inv_nti VDD_1V65_0 0.08611f
C186 5v0_add_q_sc_0/a_n1778_n454# VDD_1V65_5 0
C187 5v0_addh_sc_tile_0/upstepper_test 5v0_addh_sc_tile_1/ctrl_sign 0
C188 5v0_nter2oter_code_sc_0/in 5v0_addh_sc_tile_1/nti 0.0044f
C189 5v0_addh_sc_tile_1/pti 5v0_addh_sc_tile_1/inv_nti 0.42143f
C190 5v0_add_q_sc_0/ctrl_sign 5v0_addh_sc_tile_1/ternary_input 0.00787f
C191 5v0_addh_sc_tile_2/a_382_n1095# 5v0_addh_sc_tile_2/pti 0.12254f
C192 5v0_addh_sc_tile_1/ternary_input 5v0_nter2oter_code_sc_0/in 0.17192f
C193 5v0_addh_sc_tile_0/a_382_n1095# 5v0_addh_sc_tile_1/ctrl_sign 0.01186f
C194 VDD_3V3_1 5v0_addh_sc_tile_1/ctrl_over 0.02424f
C195 5v0_add_q_sc_1/ctrl_over 5v0_add_q_sc_1/ternary_input 0.24448f
C196 5v0_addh_sc_tile_1/inv_pti 5v0_addh_sc_tile_0/m1_103_293# 0.00205f
C197 5v0_addh_sc_tile_1/a_382_n1095# 5v0_addh_sc_tile_1/nti 0
C198 5v0_add_q_sc_0/inv_pti 5v0_add_q_sc_0/a_n1373_n454# 0.00135f
C199 in_0_over 5v0_addh_sc_tile_1/ctrl_over 0
C200 VDD_3V3_1 5v0_addh_sc_tile_0/a_n1205_n937# 0.00891f
C201 5v0_addh_sc_tile_0/inv_pti 5v0_addh_sc_tile_0/downstepper_test 0.14186f
C202 5v0_addh_sc_tile_1/a_382_n1095# 5v0_addh_sc_tile_1/ternary_input 0.09307f
C203 in_0_over 5v0_addh_sc_tile_0/a_n1205_n937# 0
C204 res_c VDD_3V3_0 0.09697f
C205 5v0_addh_sc_tile_1/ctrl_over 5v0_addh_sc_tile_2/pti 0
C206 5v0_add_q_sc_1/inv_nti 5v0_add_q_sc_1/ctrl_sign 0.10096f
C207 5v0_addh_sc_tile_1/ctrl_sign 5v0_addh_sc_tile_1/upstepper_test 0.10431f
C208 5v0_addh_sc_tile_1/m1_103_293# 5v0_addh_sc_tile_1/ctrl_sign 0.60951f
C209 5v0_addh_sc_tile_1/pti 5v0_addh_sc_tile_2/ctrl_sign 0
C210 5v0_addh_sc_tile_2/inv_pti 5v0_addh_sc_tile_2/m1_843_n857# 0
C211 5v0_addh_sc_tile_1/pti 5v0_add_q_sc_1/nti 0
C212 5v0_add_q_sc_0/5v0_half_adder_selector_sc_0/m1_n239_179# 5v0_addh_sc_tile_1/ctrl_sign 0
C213 5v0_add_q_sc_1/nti 5v0_add_q_sc_1/a_n1205_n937# 0
C214 5v0_addh_sc_tile_2/inv_pti 5v0_addh_sc_tile_1/nti 0
C215 5v0_add_q_sc_1/pti 5v0_add_q_sc_1/VDD_1V65 0.00115f
C216 5v0_addh_sc_tile_1/ternary_input 5v0_addh_sc_tile_2/inv_pti 0
C217 5v0_addh_sc_tile_2/5v0_half_adder_selector_sc_0/res_stage0 5v0_addh_sc_tile_2/nti 0.00372f
C218 m1_n2844_n810# 5v0_addh_sc_tile_0/pti 0.00645f
C219 5v0_addh_sc_tile_2/nti 5v0_addh_sc_tile_1/ctrl_sign 0
C220 5v0_addh_sc_tile_1/downstepper_test 5v0_addh_sc_tile_1/a_n1778_n454# 0.0031f
C221 in_2 5v0_addh_sc_tile_0/downstepper_test 0.0129f
C222 VDD_3V3_1 5v0_addh_sc_tile_0/a_n1373_n454# 0.00122f
C223 5v0_add_q_sc_1/VDD_1V65 5v0_add_q_sc_1/inv_pti 0.14775f
C224 5v0_addh_sc_tile_1/5v0_half_adder_selector_sc_0/res_stage0 5v0_addh_sc_tile_2/a_382_n1095# 0
C225 VDD_1V65_4 res_0 0
C226 5v0_addh_sc_tile_2/inv_nti res_0 0.01449f
C227 5v0_addh_sc_tile_1/m1_103_293# 5v0_add_q_sc_0/ternary_input 0
C228 VDD_3V3_1 in_0_sign 0.65887f
C229 in_0_sign in_0_over 0.05861f
C230 5v0_add_q_sc_0/5v0_half_adder_selector_sc_0/m1_n239_179# 5v0_add_q_sc_0/ternary_input 0.00189f
C231 5v0_addh_sc_tile_1/5v0_half_adder_selector_sc_0/res_stage0 5v0_addh_sc_tile_1/ctrl_over 0.11033f
C232 m1_n2844_n810# VDD_1V65_2 0.00448f
C233 5v0_addh_sc_tile_1/ctrl_over 5v0_addh_sc_tile_1/5v0_half_adder_selector_sc_0/5v0_tgate_sel_2_sc_1/input_A 0.04656f
C234 VDD_3V3_1 5v0_add_q_sc_1/VDD_1V65 0.0427f
C235 res_0 5v0_addh_sc_tile_2/downstepper_test 0.00302f
C236 5v0_add_q_sc_0/downstepper_test 5v0_add_q_sc_0/upstepper_test 0.38867f
C237 5v0_addh_sc_tile_1/inv_pti VDD_1V65_3 0.14775f
C238 5v0_addh_sc_tile_0/nti 5v0_nter2oter_code_sc_0/nti 0.00244f
C239 5v0_addh_sc_tile_0/carry_0_probe 5v0_add_q_sc_1/ctrl_sign 0.01576f
C240 5v0_addh_sc_tile_2/inv_nti 5v0_nter2oter_code_sc_1/pti 0
C241 5v0_addh_sc_tile_1/a_n1205_n937# 5v0_addh_sc_tile_1/nti 0
C242 5v0_addh_sc_tile_0/downstepper_test 5v0_nter2oter_code_sc_0/pti 0.0027f
C243 5v0_add_q_sc_1/inv_nti 5v0_add_q_sc_1/pti 0.10916f
C244 5v0_addh_sc_tile_1/ctrl_over 5v0_nter2oter_code_sc_0/gf180mcu_fd_sc_mcu7t5v0__nor2_1_0/a_224_472# 0
C245 5v0_addh_sc_tile_1/inv_pti 5v0_addh_sc_tile_0/pti 0.00107f
C246 5v0_nter2oter_code_sc_1/pti 5v0_addh_sc_tile_2/ctrl_sign 0.0299f
C247 5v0_add_q_sc_1/a_n1373_n454# 5v0_add_q_sc_1/VDD_1V65 0.00232f
C248 VDD_3V3_1 5v0_addh_sc_tile_0/m1_843_n857# 0.22222f
C249 in_0_over 5v0_addh_sc_tile_0/m1_843_n857# 0.09998f
C250 5v0_add_q_sc_0/downstepper_test 5v0_add_q_sc_0/a_n1205_n937# 0.00453f
C251 5v0_nter2oter_code_sc_1/pti 5v0_addh_sc_tile_2/downstepper_test 0
C252 5v0_addh_sc_tile_0/carry_sign_probe 5v0_addh_sc_tile_0/inv_nti 0.17527f
C253 5v0_add_q_sc_0/ctrl_sign 5v0_addh_sc_tile_1/inv_pti 0
C254 5v0_nter2oter_code_sc_1/nti 5v0_addh_sc_tile_2/ctrl_over 0
C255 5v0_addh_sc_tile_1/inv_pti 5v0_nter2oter_code_sc_0/in 0.00119f
C256 5v0_addh_sc_tile_0/nti VDD_1V65_0 0.21326f
C257 5v0_addh_sc_tile_0/a_n1778_n454# 5v0_addh_sc_tile_0/inv_nti 0.00226f
C258 5v0_add_q_sc_1/inv_nti 5v0_add_q_sc_1/inv_pti 0.08256f
C259 5v0_add_q_sc_0/downstepper_test 5v0_add_q_sc_0/a_n1778_n454# 0.0031f
C260 5v0_addh_sc_tile_1/downstepper_test 5v0_addh_sc_tile_1/nti 0.06935f
C261 5v0_add_q_sc_0/ctrl_sign 5v0_add_q_sc_0/upstepper_test 0.08746f
C262 5v0_add_q_sc_0/downstepper_test 5v0_addh_sc_tile_1/inv_nti 0
C263 5v0_addh_sc_tile_1/downstepper_test 5v0_addh_sc_tile_1/ternary_input 0.18203f
C264 5v0_addh_sc_tile_2/a_382_n1095# in_3 0.09307f
C265 5v0_addh_sc_tile_1/a_n1373_n454# 5v0_addh_sc_tile_1/nti 0
C266 5v0_addh_sc_tile_1/a_382_n1095# 5v0_addh_sc_tile_1/inv_pti 0.00129f
C267 5v0_addh_sc_tile_1/a_382_n1095# 5v0_addh_sc_tile_1/m1_843_n857# 0.05013f
C268 5v0_add_q_sc_0/downstepper_test 5v0_addh_sc_tile_2/inv_nti 0
C269 VDD_1V65_3 5v0_addh_sc_tile_1/inv_nti 0.08611f
C270 5v0_addh_sc_tile_0/a_382_n1095# 5v0_add_q_sc_1/ctrl_sign 0
C271 5v0_addh_sc_tile_1/ternary_input 5v0_addh_sc_tile_1/a_n1373_n454# 0.00163f
C272 5v0_addh_sc_tile_1/a_382_n1095# 5v0_add_q_sc_0/upstepper_test 0.0104f
C273 5v0_add_q_sc_0/5v0_half_adder_selector_sc_0/res_stage0 5v0_add_q_sc_0/upstepper_test 0.27475f
C274 5v0_add_q_sc_0/inv_pti 5v0_add_q_sc_1/ctrl_over 0.00278f
C275 VDD_3V3_1 5v0_addh_sc_tile_2/ctrl_over 0.00186f
C276 5v0_add_q_sc_0/ctrl_over 5v0_addh_sc_tile_2/pti 0.1334f
C277 in_2 5v0_addh_sc_tile_1/nti 0.00613f
C278 VDD_3V3_0 5v0_addh_sc_tile_2/a_n1373_n454# 0.00122f
C279 5v0_addh_sc_tile_0/downstepper_test 5v0_addh_sc_tile_0/5v0_half_adder_selector_sc_0/res_stage0 0.25483f
C280 VDD_3V3_1 5v0_add_q_sc_1/inv_nti 0.56275f
C281 5v0_add_q_sc_1/ctrl_sign 5v0_addh_sc_tile_1/upstepper_test 0
C282 5v0_addh_sc_tile_1/m1_103_293# 5v0_add_q_sc_1/ctrl_sign 0.22665f
C283 5v0_addh_sc_tile_0/pti 5v0_addh_sc_tile_1/inv_nti 0
C284 5v0_add_q_sc_1/inv_nti in_0_over 0.00113f
C285 in_1 VDD_1V65_0 0.01451f
C286 in_2 5v0_addh_sc_tile_1/ternary_input 0.02606f
C287 5v0_addh_sc_tile_2/ctrl_sign 5v0_nter2oter_code_sc_1/gf180mcu_fd_sc_mcu7t5v0__nor2_1_0/a_224_472# 0.00629f
C288 5v0_addh_sc_tile_1/inv_pti 5v0_addh_sc_tile_2/inv_pti 0
C289 5v0_addh_sc_tile_2/pti 5v0_addh_sc_tile_2/ctrl_over 0.16185f
C290 VDD_1V65_3 5v0_addh_sc_tile_2/ctrl_sign 0
C291 5v0_addh_sc_tile_2/a_382_n1095# 5v0_addh_sc_tile_1/ctrl_over 0
C292 5v0_addh_sc_tile_2/inv_pti 5v0_add_q_sc_0/upstepper_test 0
C293 5v0_add_q_sc_0/ctrl_sign 5v0_addh_sc_tile_1/inv_nti 0
C294 5v0_addh_sc_tile_0/inv_nti 5v0_addh_sc_tile_1/ctrl_sign 0.02895f
C295 5v0_nter2oter_code_sc_1/nti VDD_3V3_0 0.31259f
C296 5v0_nter2oter_code_sc_0/in 5v0_nter2oter_code_sc_0/nti 0.23186f
C297 5v0_addh_sc_tile_1/inv_nti 5v0_nter2oter_code_sc_0/in 0.01488f
C298 5v0_add_q_sc_1/a_n1373_n454# 5v0_add_q_sc_1/inv_nti 0
C299 5v0_add_q_sc_0/a_n1205_n937# 5v0_add_q_sc_0/5v0_half_adder_selector_sc_0/res_stage0 0
C300 5v0_add_q_sc_0/inv_nti 5v0_add_q_sc_0/upstepper_test 0.0011f
C301 5v0_add_q_sc_1/pti 5v0_addh_sc_tile_0/carry_0_probe 0
C302 5v0_addh_sc_tile_0/inv_pti m1_n2844_n810# 0.00753f
C303 5v0_add_q_sc_0/ctrl_sign 5v0_addh_sc_tile_2/inv_nti 0.12058f
C304 5v0_add_q_sc_1/nti 5v0_addh_sc_tile_0/pti 0.00264f
C305 5v0_addh_sc_tile_0/pti VDD_1V65_0 0.00234f
C306 5v0_addh_sc_tile_2/inv_nti 5v0_nter2oter_code_sc_0/in 0
C307 5v0_addh_sc_tile_2/m1_103_293# 5v0_addh_sc_tile_2/m1_843_n857# 0.20659f
C308 5v0_addh_sc_tile_1/a_382_n1095# 5v0_addh_sc_tile_1/inv_nti 0.28394f
C309 5v0_add_q_sc_1/a_n1778_n454# 5v0_add_q_sc_1/VDD_1V65 0
C310 5v0_add_q_sc_0/ctrl_sign 5v0_addh_sc_tile_2/ctrl_sign 0.27145f
C311 5v0_addh_sc_tile_1/downstepper_test m1_n2844_n810# 0
C312 5v0_addh_sc_tile_2/ctrl_sign 5v0_nter2oter_code_sc_0/in 0.30294f
C313 5v0_addh_sc_tile_1/pti 5v0_add_q_sc_0/nti 0
C314 5v0_addh_sc_tile_2/m1_103_293# 5v0_addh_sc_tile_1/nti 0.00116f
C315 VDD_3V3_1 VDD_3V3_0 0.00215f
C316 5v0_addh_sc_tile_2/inv_nti 5v0_add_q_sc_0/5v0_half_adder_selector_sc_0/res_stage0 0
C317 5v0_add_q_sc_0/ctrl_sign 5v0_addh_sc_tile_2/downstepper_test 0
C318 5v0_add_q_sc_0/nti VDD_1V65_5 0.21326f
C319 in_0_over VDD_3V3_0 0
C320 5v0_addh_sc_tile_2/5v0_half_adder_selector_sc_0/5v0_tgate_sel_2_sc_1/input_A 5v0_addh_sc_tile_2/ctrl_sign 0
C321 5v0_addh_sc_tile_1/pti 5v0_addh_sc_tile_1/ctrl_sign 0.48393f
C322 5v0_addh_sc_tile_2/m1_103_293# 5v0_addh_sc_tile_1/ternary_input 0
C323 5v0_add_q_sc_0/a_n1205_n937# 5v0_add_q_sc_0/inv_nti 0
C324 5v0_addh_sc_tile_1/inv_nti 5v0_addh_sc_tile_2/inv_pti 0
C325 5v0_addh_sc_tile_1/ternary_input 5v0_nter2oter_code_sc_0/pti 0
C326 VDD_3V3_0 5v0_addh_sc_tile_2/pti 0.71212f
C327 5v0_addh_sc_tile_2/5v0_half_adder_selector_sc_0/5v0_tgate_sel_2_sc_1/input_A 5v0_addh_sc_tile_2/downstepper_test 0
C328 5v0_addh_sc_tile_1/a_382_n1095# 5v0_add_q_sc_1/nti 0
C329 VDD_1V65_4 5v0_addh_sc_tile_2/inv_pti 0.14775f
C330 5v0_addh_sc_tile_0/carry_sign_probe 5v0_addh_sc_tile_0/m1_103_293# 0.21008f
C331 5v0_add_q_sc_0/a_n1778_n454# 5v0_add_q_sc_0/inv_nti 0.00214f
C332 5v0_add_q_sc_0/downstepper_test 5v0_add_q_sc_0/5v0_half_adder_selector_sc_0/5v0_tgate_sel_2_sc_1/input_A 0
C333 5v0_addh_sc_tile_2/inv_nti 5v0_addh_sc_tile_2/inv_pti 0.2615f
C334 5v0_add_q_sc_1/nti VDD_1V65_2 0.02331f
C335 5v0_addh_sc_tile_1/5v0_half_adder_selector_sc_0/res_stage0 5v0_addh_sc_tile_2/ctrl_over 0.00478f
C336 5v0_addh_sc_tile_0/a_382_n1095# 5v0_add_q_sc_1/pti 0
C337 m1_n2844_n810# 5v0_add_q_sc_1/ternary_input 0.11751f
C338 5v0_addh_sc_tile_2/inv_pti 5v0_addh_sc_tile_2/ctrl_sign 0.28426f
C339 VDD_3V3_1 5v0_addh_sc_tile_0/carry_0_probe 0.82136f
C340 5v0_add_q_sc_0/a_n1373_n454# 5v0_add_q_sc_0/upstepper_test 0
C341 5v0_addh_sc_tile_0/carry_0_probe in_0_over 0.12282f
C342 5v0_addh_sc_tile_2/inv_pti 5v0_addh_sc_tile_2/downstepper_test 0.13388f
C343 5v0_add_q_sc_1/ctrl_over 5v0_addh_sc_tile_1/nti 0
C344 5v0_nter2oter_code_sc_1/nti 5v0_addh_sc_tile_0/upstepper_test 0
C345 VDD_1V65_4 5v0_addh_sc_tile_2/a_n1205_n937# 0.00354f
C346 5v0_add_q_sc_1/ctrl_over 5v0_addh_sc_tile_1/ternary_input 0.00136f
C347 5v0_addh_sc_tile_2/inv_nti 5v0_addh_sc_tile_2/a_n1205_n937# 0
C348 5v0_nter2oter_code_sc_0/gf180mcu_fd_sc_mcu7t5v0__nor2_1_0/a_224_472# 5v0_addh_sc_tile_2/ctrl_over 0.0326f
C349 5v0_addh_sc_tile_1/pti 5v0_add_q_sc_0/ternary_input 0
C350 5v0_addh_sc_tile_0/a_n1778_n454# 5v0_addh_sc_tile_0/nti 0.00142f
C351 5v0_addh_sc_tile_2/5v0_half_adder_selector_sc_0/res_stage0 res_0 0.08533f
C352 5v0_addh_sc_tile_1/inv_pti 5v0_addh_sc_tile_1/downstepper_test 0.1369f
C353 5v0_add_q_sc_1/a_n1778_n454# 5v0_add_q_sc_1/inv_nti 0.00214f
C354 5v0_add_q_sc_0/ternary_input VDD_1V65_5 0.03394f
C355 5v0_add_q_sc_0/ctrl_sign 5v0_add_q_sc_0/5v0_half_adder_selector_sc_0/5v0_tgate_sel_2_sc_1/input_A 0
C356 5v0_addh_sc_tile_0/5v0_half_adder_selector_sc_0/res_stage0 5v0_addh_sc_tile_1/ternary_input 0.0902f
C357 5v0_addh_sc_tile_1/inv_pti 5v0_addh_sc_tile_1/a_n1373_n454# 0.00135f
C358 5v0_addh_sc_tile_0/m1_103_293# 5v0_addh_sc_tile_1/ctrl_sign 0.00101f
C359 5v0_addh_sc_tile_2/a_n1205_n937# 5v0_addh_sc_tile_2/downstepper_test 0.00453f
C360 5v0_add_q_sc_0/pti VDD_1V65_5 0.00115f
C361 5v0_addh_sc_tile_1/5v0_half_adder_selector_sc_0/res_stage0 VDD_3V3_0 0.11354f
C362 VDD_3V3_1 5v0_addh_sc_tile_0/upstepper_test 0.45677f
C363 5v0_addh_sc_tile_1/a_n1205_n937# 5v0_addh_sc_tile_1/inv_nti 0
C364 5v0_addh_sc_tile_2/nti 5v0_addh_sc_tile_2/a_n1373_n454# 0
C365 VDD_3V3_0 5v0_addh_sc_tile_1/5v0_half_adder_selector_sc_0/5v0_tgate_sel_2_sc_1/input_A 0.02871f
C366 5v0_addh_sc_tile_0/upstepper_test in_0_over 0.00168f
C367 VDD_3V3_1 5v0_addh_sc_tile_0/a_382_n1095# 0.63349f
C368 5v0_add_q_sc_0/5v0_half_adder_selector_sc_0/res_stage0 5v0_add_q_sc_0/5v0_half_adder_selector_sc_0/5v0_tgate_sel_2_sc_1/input_A 0.00253f
C369 in_2 5v0_addh_sc_tile_1/inv_pti 0
C370 5v0_addh_sc_tile_0/a_382_n1095# in_0_over 0.63576f
C371 5v0_add_q_sc_0/ctrl_over in_3 0.00136f
C372 5v0_addh_sc_tile_2/upstepper_test 5v0_addh_sc_tile_2/5v0_half_adder_selector_sc_0/5v0_tgate_sel_2_sc_1/input_A 0
C373 VDD_3V3_1 5v0_addh_sc_tile_1/m1_103_293# 0.62378f
C374 in_1 5v0_addh_sc_tile_0/a_n1778_n454# 0.00182f
C375 5v0_addh_sc_tile_1/inv_pti 5v0_add_q_sc_1/ternary_input 0.00686f
C376 VDD_3V3_1 5v0_addh_sc_tile_1/upstepper_test 0.39457f
C377 VDD_3V3_0 5v0_nter2oter_code_sc_0/gf180mcu_fd_sc_mcu7t5v0__nor2_1_0/a_224_472# 0.01413f
C378 5v0_nter2oter_code_sc_1/pti 5v0_addh_sc_tile_1/ctrl_sign 0.28956f
C379 in_0_over 5v0_addh_sc_tile_1/upstepper_test 0.01202f
C380 5v0_add_q_sc_0/ctrl_over 5v0_addh_sc_tile_2/a_382_n1095# 0.06871f
C381 in_3 5v0_addh_sc_tile_2/ctrl_over 0.1551f
C382 5v0_addh_sc_tile_1/pti 5v0_add_q_sc_1/downstepper_test 0.00147f
C383 5v0_addh_sc_tile_0/downstepper_test 5v0_addh_sc_tile_1/ternary_input 0.00308f
C384 5v0_addh_sc_tile_0/nti 5v0_addh_sc_tile_1/ctrl_sign 0
C385 5v0_addh_sc_tile_1/5v0_half_adder_selector_sc_0/res_stage0 5v0_addh_sc_tile_0/carry_0_probe 0.00121f
C386 5v0_addh_sc_tile_1/downstepper_test 5v0_addh_sc_tile_1/inv_nti 0.29493f
C387 5v0_add_q_sc_1/ctrl_sign 5v0_addh_sc_tile_0/inv_nti 0.00142f
C388 5v0_addh_sc_tile_2/a_382_n1095# 5v0_addh_sc_tile_2/ctrl_over 0.69037f
C389 5v0_add_q_sc_1/a_n1205_n937# 5v0_add_q_sc_1/downstepper_test 0.00453f
C390 5v0_addh_sc_tile_0/carry_sign_probe 5v0_addh_sc_tile_0/pti 0.01168f
C391 5v0_add_q_sc_0/5v0_half_adder_selector_sc_0/m1_n239_179# 5v0_addh_sc_tile_2/pti 0
C392 5v0_addh_sc_tile_1/a_n1778_n454# 5v0_addh_sc_tile_1/nti 0.00142f
C393 5v0_addh_sc_tile_1/a_n1373_n454# 5v0_addh_sc_tile_1/inv_nti 0
C394 5v0_add_q_sc_0/ctrl_over 5v0_addh_sc_tile_1/ctrl_over 0
C395 5v0_addh_sc_tile_2/inv_nti 5v0_addh_sc_tile_1/downstepper_test 0.00392f
C396 5v0_addh_sc_tile_2/nti 5v0_addh_sc_tile_2/a_n1778_n454# 0.00142f
C397 5v0_addh_sc_tile_0/a_n1778_n454# 5v0_addh_sc_tile_0/pti 0.00135f
C398 5v0_addh_sc_tile_0/inv_pti 5v0_add_q_sc_1/nti 0
C399 5v0_addh_sc_tile_2/upstepper_test 5v0_addh_sc_tile_2/inv_pti 0.07254f
C400 5v0_addh_sc_tile_1/ternary_input 5v0_addh_sc_tile_1/a_n1778_n454# 0.00182f
C401 5v0_addh_sc_tile_0/inv_pti VDD_1V65_0 0.14775f
C402 5v0_addh_sc_tile_1/downstepper_test 5v0_addh_sc_tile_2/ctrl_sign 0.00468f
C403 5v0_addh_sc_tile_1/inv_pti 5v0_addh_sc_tile_2/m1_103_293# 0
C404 in_2 5v0_nter2oter_code_sc_0/nti 0
C405 5v0_addh_sc_tile_1/ctrl_over 5v0_addh_sc_tile_2/ctrl_over 0.02247f
C406 5v0_addh_sc_tile_2/nti 5v0_addh_sc_tile_2/pti 0.24563f
C407 5v0_add_q_sc_0/downstepper_test 5v0_add_q_sc_0/nti 0.07205f
C408 in_1 5v0_addh_sc_tile_1/ctrl_sign 0.01394f
C409 5v0_add_q_sc_1/ternary_input 5v0_addh_sc_tile_1/inv_nti 0
C410 5v0_addh_sc_tile_1/pti 5v0_add_q_sc_1/ctrl_sign 0.01108f
C411 5v0_addh_sc_tile_1/ctrl_sign 5v0_nter2oter_code_sc_1/gf180mcu_fd_sc_mcu7t5v0__nor2_1_0/a_224_472# 0
C412 5v0_addh_sc_tile_2/upstepper_test 5v0_addh_sc_tile_2/a_n1205_n937# 0.00334f
C413 in_3 VDD_3V3_0 1.10285f
C414 in_0_sign 5v0_addh_sc_tile_0/m1_843_n857# 0.24363f
C415 in_2 5v0_addh_sc_tile_2/ctrl_sign 0.0048f
C416 5v0_addh_sc_tile_0/a_382_n1095# 5v0_addh_sc_tile_1/5v0_half_adder_selector_sc_0/res_stage0 0
C417 5v0_addh_sc_tile_2/a_382_n1095# VDD_3V3_0 0.66129f
C418 in_2 VDD_1V65_0 0
C419 5v0_addh_sc_tile_0/downstepper_test m1_n2844_n810# 0
C420 5v0_addh_sc_tile_0/pti 5v0_addh_sc_tile_1/ctrl_sign 0.00125f
C421 5v0_addh_sc_tile_1/m1_103_293# 5v0_addh_sc_tile_1/5v0_half_adder_selector_sc_0/res_stage0 0.18549f
C422 5v0_addh_sc_tile_1/5v0_half_adder_selector_sc_0/res_stage0 5v0_addh_sc_tile_1/upstepper_test 0.27475f
C423 5v0_addh_sc_tile_1/inv_pti 5v0_add_q_sc_1/ctrl_over 0.01474f
C424 5v0_addh_sc_tile_1/m1_843_n857# 5v0_add_q_sc_1/ctrl_over 0.18406f
C425 5v0_add_q_sc_1/nti 5v0_add_q_sc_1/ternary_input 0.68929f
C426 5v0_addh_sc_tile_1/5v0_half_adder_selector_sc_0/5v0_tgate_sel_2_sc_1/input_A 5v0_addh_sc_tile_1/upstepper_test 0
C427 5v0_add_q_sc_0/ctrl_sign 5v0_add_q_sc_0/nti 0
C428 5v0_addh_sc_tile_1/ctrl_over VDD_3V3_0 1.20698f
C429 5v0_add_q_sc_1/ctrl_over 5v0_add_q_sc_0/upstepper_test 0.01814f
C430 5v0_add_q_sc_0/ctrl_sign 5v0_addh_sc_tile_1/ctrl_sign 0
C431 5v0_addh_sc_tile_2/m1_103_293# 5v0_addh_sc_tile_1/inv_nti 0.00513f
C432 5v0_nter2oter_code_sc_0/pti 5v0_nter2oter_code_sc_0/nti 0.00234f
C433 5v0_addh_sc_tile_2/5v0_half_adder_selector_sc_0/res_stage0 5v0_addh_sc_tile_2/5v0_half_adder_selector_sc_0/5v0_tgate_sel_2_sc_1/input_A 0.00253f
C434 5v0_nter2oter_code_sc_0/in 5v0_addh_sc_tile_1/ctrl_sign 0.01034f
C435 5v0_add_q_sc_1/5v0_half_adder_selector_sc_0/m1_n239_179# 5v0_add_q_sc_1/ternary_input 0.00189f
C436 5v0_addh_sc_tile_2/inv_nti 5v0_addh_sc_tile_2/m1_103_293# 0.35313f
C437 5v0_addh_sc_tile_1/a_382_n1095# 5v0_add_q_sc_0/nti 0
C438 5v0_add_q_sc_0/downstepper_test 5v0_add_q_sc_0/ternary_input 0.17146f
C439 5v0_add_q_sc_0/nti 5v0_add_q_sc_0/5v0_half_adder_selector_sc_0/res_stage0 0.00372f
C440 5v0_addh_sc_tile_1/a_382_n1095# 5v0_addh_sc_tile_1/ctrl_sign 0.07412f
C441 5v0_addh_sc_tile_2/m1_103_293# 5v0_addh_sc_tile_2/ctrl_sign 0.61512f
C442 5v0_addh_sc_tile_1/ternary_input 5v0_addh_sc_tile_1/nti 0.54752f
C443 5v0_addh_sc_tile_2/ctrl_sign 5v0_nter2oter_code_sc_0/pti 0.23385f
C444 5v0_add_q_sc_0/downstepper_test 5v0_add_q_sc_0/pti 0.0825f
C445 5v0_addh_sc_tile_0/m1_103_293# 5v0_add_q_sc_1/ctrl_sign 0
C446 5v0_add_q_sc_1/inv_nti 5v0_add_q_sc_1/VDD_1V65 0.01114f
C447 5v0_addh_sc_tile_0/carry_0_probe 5v0_addh_sc_tile_1/ctrl_over 0
C448 5v0_addh_sc_tile_2/5v0_half_adder_selector_sc_0/res_stage0 5v0_addh_sc_tile_2/inv_pti 0.01003f
C449 5v0_addh_sc_tile_2/m1_103_293# 5v0_addh_sc_tile_2/downstepper_test 0.0934f
C450 5v0_addh_sc_tile_2/nti 5v0_nter2oter_code_sc_0/gf180mcu_fd_sc_mcu7t5v0__nor2_1_0/a_224_472# 0
C451 5v0_addh_sc_tile_2/inv_pti 5v0_addh_sc_tile_1/ctrl_sign 0.00447f
C452 5v0_add_q_sc_1/5v0_half_adder_selector_sc_0/res_stage0 5v0_add_q_sc_1/a_n1205_n937# 0
C453 5v0_add_q_sc_1/ctrl_over 5v0_addh_sc_tile_1/inv_nti 0.03482f
C454 5v0_nter2oter_code_sc_1/nti 5v0_addh_sc_tile_0/inv_nti 0.00216f
C455 5v0_add_q_sc_0/nti 5v0_add_q_sc_0/inv_nti 0.20874f
C456 5v0_addh_sc_tile_1/pti 5v0_add_q_sc_1/pti 0
C457 5v0_add_q_sc_0/ctrl_sign 5v0_add_q_sc_0/ternary_input 0.00264f
C458 5v0_add_q_sc_0/downstepper_test res_c 0.00302f
C459 in_0_sign VDD_3V3_0 0
C460 5v0_addh_sc_tile_1/m1_843_n857# 5v0_add_q_sc_0/inv_pti 0
C461 5v0_addh_sc_tile_2/5v0_half_adder_selector_sc_0/res_stage0 5v0_addh_sc_tile_2/a_n1205_n937# 0
C462 5v0_add_q_sc_0/ctrl_sign 5v0_add_q_sc_0/pti 0
C463 5v0_add_q_sc_1/nti 5v0_add_q_sc_1/ctrl_over 0.00725f
C464 5v0_add_q_sc_0/inv_pti 5v0_add_q_sc_0/upstepper_test 0.0467f
C465 5v0_addh_sc_tile_1/a_382_n1095# 5v0_add_q_sc_0/ternary_input 0.00603f
C466 VDD_3V3_1 5v0_addh_sc_tile_0/inv_nti 0.85215f
C467 5v0_addh_sc_tile_0/carry_sign_probe 5v0_addh_sc_tile_0/inv_pti 0.17523f
C468 5v0_addh_sc_tile_0/upstepper_test 5v0_addh_sc_tile_1/ctrl_over 0
C469 5v0_add_q_sc_0/ternary_input 5v0_add_q_sc_0/5v0_half_adder_selector_sc_0/res_stage0 0.27792f
C470 5v0_addh_sc_tile_1/pti 5v0_nter2oter_code_sc_1/nti 0
C471 in_0_over 5v0_addh_sc_tile_0/inv_nti 0.21462f
C472 5v0_addh_sc_tile_0/upstepper_test 5v0_addh_sc_tile_0/a_n1205_n937# 0.00334f
C473 5v0_addh_sc_tile_0/a_382_n1095# 5v0_addh_sc_tile_1/ctrl_over 0
C474 5v0_add_q_sc_1/5v0_half_adder_selector_sc_0/m1_n239_179# 5v0_add_q_sc_1/ctrl_over 0.00258f
C475 5v0_addh_sc_tile_1/a_382_n1095# 5v0_add_q_sc_0/pti 0
C476 5v0_add_q_sc_0/ctrl_over 5v0_addh_sc_tile_2/ctrl_over 0.14755f
C477 5v0_addh_sc_tile_1/ctrl_over 5v0_addh_sc_tile_1/upstepper_test 0.0043f
C478 5v0_addh_sc_tile_1/m1_103_293# 5v0_addh_sc_tile_1/ctrl_over 0.02786f
C479 in_3 5v0_addh_sc_tile_2/nti 0.52138f
C480 in_0_sign 5v0_addh_sc_tile_0/carry_0_probe 0.01013f
C481 5v0_add_q_sc_0/ctrl_sign res_c 0
C482 5v0_add_q_sc_1/5v0_half_adder_selector_sc_0/5v0_tgate_sel_2_sc_1/input_A 5v0_add_q_sc_1/downstepper_test 0
C483 5v0_add_q_sc_0/a_n1373_n454# 5v0_add_q_sc_0/nti 0
C484 5v0_add_q_sc_0/5v0_half_adder_selector_sc_0/m1_n239_179# 5v0_addh_sc_tile_1/ctrl_over 0.00107f
C485 5v0_addh_sc_tile_2/a_382_n1095# 5v0_addh_sc_tile_2/nti 0
C486 VDD_3V3_1 5v0_addh_sc_tile_1/pti 0.57114f
C487 5v0_add_q_sc_0/ternary_input 5v0_add_q_sc_0/inv_nti 0.02537f
C488 5v0_addh_sc_tile_1/pti in_0_over 0.00417f
C489 5v0_add_q_sc_0/inv_pti 5v0_addh_sc_tile_1/inv_nti 0
C490 5v0_addh_sc_tile_2/upstepper_test 5v0_addh_sc_tile_2/m1_103_293# 0.07773f
C491 VDD_3V3_1 5v0_add_q_sc_1/a_n1205_n937# 0.00891f
C492 5v0_addh_sc_tile_1/pti 5v0_addh_sc_tile_2/pti 0
C493 res_c 5v0_add_q_sc_0/5v0_half_adder_selector_sc_0/res_stage0 0.08533f
C494 5v0_add_q_sc_0/inv_nti 5v0_add_q_sc_0/pti 0.11055f
C495 5v0_addh_sc_tile_1/a_382_n1095# 5v0_add_q_sc_1/downstepper_test 0.00433f
C496 5v0_addh_sc_tile_1/a_n1778_n454# 5v0_addh_sc_tile_1/inv_nti 0.00226f
C497 5v0_addh_sc_tile_0/upstepper_test 5v0_addh_sc_tile_0/a_n1373_n454# 0
C498 5v0_addh_sc_tile_1/ctrl_over 5v0_addh_sc_tile_2/nti 0
C499 5v0_addh_sc_tile_0/carry_sign_probe 5v0_add_q_sc_1/ternary_input 0.05455f
C500 5v0_addh_sc_tile_0/pti 5v0_add_q_sc_1/ctrl_sign 0.00768f
C501 5v0_addh_sc_tile_0/downstepper_test VDD_1V65_0 0.13024f
C502 in_0_sign 5v0_addh_sc_tile_0/upstepper_test 0.08746f
C503 5v0_add_q_sc_0/ctrl_over VDD_3V3_0 0.96278f
C504 5v0_addh_sc_tile_0/carry_0_probe 5v0_addh_sc_tile_0/m1_843_n857# 0.18376f
C505 5v0_addh_sc_tile_1/inv_pti 5v0_addh_sc_tile_2/m1_843_n857# 0
C506 5v0_addh_sc_tile_1/downstepper_test 5v0_addh_sc_tile_1/ctrl_sign 0.20144f
C507 5v0_add_q_sc_1/5v0_half_adder_selector_sc_0/5v0_tgate_sel_2_sc_1/input_A 5v0_add_q_sc_1/ctrl_sign 0
C508 5v0_addh_sc_tile_0/a_382_n1095# in_0_sign 0.07412f
C509 VDD_3V3_0 5v0_addh_sc_tile_2/ctrl_over 2.01435f
C510 5v0_addh_sc_tile_1/inv_pti 5v0_addh_sc_tile_1/nti 0.23171f
C511 5v0_addh_sc_tile_1/m1_843_n857# 5v0_addh_sc_tile_1/ternary_input 0
C512 5v0_addh_sc_tile_1/inv_pti 5v0_addh_sc_tile_1/ternary_input 0.05503f
C513 5v0_addh_sc_tile_1/a_382_n1095# 5v0_add_q_sc_1/ctrl_sign 0.00155f
C514 5v0_add_q_sc_0/a_n1373_n454# 5v0_add_q_sc_0/ternary_input 0.00136f
C515 5v0_add_q_sc_0/5v0_half_adder_selector_sc_0/m1_n244_n517# 5v0_addh_sc_tile_2/inv_nti 0
C516 in_2 5v0_addh_sc_tile_1/ctrl_sign 0.1696f
C517 5v0_add_q_sc_1/ctrl_sign VDD_1V65_2 0.00149f
C518 VDD_3V3_1 5v0_addh_sc_tile_0/m1_103_293# 0.73472f
C519 5v0_nter2oter_code_sc_1/nti 5v0_nter2oter_code_sc_1/pti 0.00234f
C520 5v0_addh_sc_tile_0/m1_103_293# in_0_over 0.02633f
C521 5v0_add_q_sc_0/a_n1373_n454# 5v0_add_q_sc_0/pti 0
C522 5v0_add_q_sc_1/ternary_input 5v0_addh_sc_tile_1/ctrl_sign 0
C523 res_0 5v0_addh_sc_tile_2/pti 0
C524 5v0_nter2oter_code_sc_1/nti 5v0_addh_sc_tile_0/nti 0
C525 5v0_addh_sc_tile_1/5v0_half_adder_selector_sc_0/res_stage0 5v0_addh_sc_tile_1/pti 0.01078f
C526 5v0_add_q_sc_1/inv_nti 5v0_addh_sc_tile_0/carry_0_probe 0.00204f
C527 5v0_addh_sc_tile_0/a_382_n1095# 5v0_addh_sc_tile_0/m1_843_n857# 0.05013f
C528 VDD_3V3_1 5v0_nter2oter_code_sc_1/pti 0.29062f
C529 5v0_addh_sc_tile_0/m1_843_n857# 5v0_addh_sc_tile_1/upstepper_test 0.00724f
C530 5v0_addh_sc_tile_2/inv_nti 5v0_addh_sc_tile_2/m1_843_n857# 0.36668f
C531 5v0_addh_sc_tile_1/inv_nti 5v0_addh_sc_tile_1/nti 0.22702f
C532 5v0_addh_sc_tile_2/5v0_half_adder_selector_sc_0/res_stage0 5v0_addh_sc_tile_2/m1_103_293# 0.18487f
C533 VDD_3V3_1 5v0_addh_sc_tile_0/nti 0.74269f
C534 5v0_nter2oter_code_sc_1/pti 5v0_addh_sc_tile_2/pti 0.00125f
C535 5v0_addh_sc_tile_1/ternary_input 5v0_addh_sc_tile_1/inv_nti 0.28104f
C536 5v0_add_q_sc_1/5v0_half_adder_selector_sc_0/5v0_tgate_sel_2_sc_1/input_A 5v0_add_q_sc_1/5v0_half_adder_selector_sc_0/res_stage0 0.00253f
C537 5v0_addh_sc_tile_1/pti 5v0_add_q_sc_1/a_n1778_n454# 0
C538 in_0_over 5v0_addh_sc_tile_0/nti 0.00162f
C539 5v0_addh_sc_tile_2/inv_nti 5v0_addh_sc_tile_1/nti 0
C540 in_1 5v0_nter2oter_code_sc_1/nti 0
C541 5v0_addh_sc_tile_2/m1_843_n857# 5v0_addh_sc_tile_2/ctrl_sign 0.24363f
C542 5v0_addh_sc_tile_1/ctrl_sign 5v0_nter2oter_code_sc_0/pti 0.00632f
C543 5v0_addh_sc_tile_0/carry_sign_probe 5v0_addh_sc_tile_0/5v0_half_adder_selector_sc_0/res_stage0 0
C544 5v0_addh_sc_tile_1/inv_pti m1_n2844_n810# 0
C545 5v0_nter2oter_code_sc_1/nti 5v0_nter2oter_code_sc_1/gf180mcu_fd_sc_mcu7t5v0__nor2_1_0/a_224_472# 0.00898f
C546 5v0_addh_sc_tile_2/ctrl_sign 5v0_addh_sc_tile_1/nti 0.01236f
C547 5v0_addh_sc_tile_0/carry_0_probe VDD_3V3_0 0
C548 5v0_addh_sc_tile_0/a_382_n1095# 5v0_add_q_sc_1/inv_nti 0
C549 VDD_3V3_1 5v0_addh_sc_tile_0/5v0_half_adder_selector_sc_0/5v0_tgate_sel_2_sc_1/input_A 0.02871f
C550 5v0_add_q_sc_0/ternary_input 5v0_add_q_sc_1/ternary_input 0.17661f
C551 5v0_addh_sc_tile_1/ternary_input 5v0_addh_sc_tile_2/ctrl_sign 0
C552 in_0_over 5v0_addh_sc_tile_0/5v0_half_adder_selector_sc_0/5v0_tgate_sel_2_sc_1/input_A 0.04656f
C553 5v0_addh_sc_tile_1/nti 5v0_addh_sc_tile_2/downstepper_test 0
C554 VDD_3V3_1 in_1 1.00116f
C555 5v0_addh_sc_tile_2/ctrl_over 5v0_addh_sc_tile_1/upstepper_test 0
C556 5v0_addh_sc_tile_1/m1_103_293# 5v0_add_q_sc_1/inv_nti 0.00334f
C557 5v0_add_q_sc_0/5v0_half_adder_selector_sc_0/m1_n239_179# 5v0_add_q_sc_0/ctrl_over 0.00258f
C558 5v0_add_q_sc_0/5v0_half_adder_selector_sc_0/m1_n244_n517# 5v0_add_q_sc_0/5v0_half_adder_selector_sc_0/5v0_tgate_sel_2_sc_1/input_A 0.02928f
C559 in_1 in_0_over 0.13684f
C560 5v0_add_q_sc_1/ctrl_over 5v0_add_q_sc_0/nti 0.01581f
C561 5v0_add_q_sc_0/downstepper_test 5v0_addh_sc_tile_2/pti 0
C562 5v0_add_q_sc_0/5v0_half_adder_selector_sc_0/m1_n239_179# 5v0_addh_sc_tile_2/ctrl_over 0.00716f
C563 5v0_addh_sc_tile_1/ctrl_over 5v0_addh_sc_tile_0/inv_nti 0
C564 5v0_add_q_sc_1/ctrl_over 5v0_addh_sc_tile_1/ctrl_sign 0.01552f
C565 5v0_nter2oter_code_sc_1/nti 5v0_nter2oter_code_sc_0/in 0.00204f
C566 5v0_addh_sc_tile_0/inv_nti 5v0_addh_sc_tile_0/a_n1205_n937# 0
C567 5v0_addh_sc_tile_0/carry_sign_probe 5v0_addh_sc_tile_0/downstepper_test 0
C568 5v0_add_q_sc_0/ctrl_over 5v0_addh_sc_tile_2/nti 0
C569 5v0_addh_sc_tile_0/a_n1778_n454# 5v0_addh_sc_tile_0/downstepper_test 0.0031f
C570 5v0_addh_sc_tile_0/inv_pti 5v0_add_q_sc_1/ctrl_sign 0
C571 5v0_addh_sc_tile_0/5v0_half_adder_selector_sc_0/res_stage0 5v0_addh_sc_tile_1/ctrl_sign 0.00758f
C572 VDD_3V3_1 5v0_addh_sc_tile_0/pti 0.68621f
C573 5v0_addh_sc_tile_2/nti 5v0_addh_sc_tile_2/ctrl_over 0.007f
C574 in_0_over 5v0_addh_sc_tile_0/pti 0.10966f
C575 5v0_addh_sc_tile_1/a_382_n1095# 5v0_add_q_sc_1/inv_pti 0
C576 5v0_addh_sc_tile_0/a_382_n1095# VDD_3V3_0 0
C577 5v0_addh_sc_tile_2/inv_pti 5v0_addh_sc_tile_2/a_n1373_n454# 0.00135f
C578 5v0_add_q_sc_1/ternary_input 5v0_add_q_sc_1/downstepper_test 0.16195f
C579 VDD_3V3_1 5v0_add_q_sc_1/5v0_half_adder_selector_sc_0/5v0_tgate_sel_2_sc_1/input_A 0.02871f
C580 5v0_addh_sc_tile_1/downstepper_test 5v0_add_q_sc_1/ctrl_sign 0
C581 5v0_addh_sc_tile_1/m1_843_n857# 5v0_addh_sc_tile_1/inv_pti 0
C582 5v0_addh_sc_tile_1/pti 5v0_addh_sc_tile_1/ctrl_over 0.11567f
C583 VDD_3V3_1 5v0_nter2oter_code_sc_0/in 0.92139f
C584 5v0_addh_sc_tile_1/ctrl_over VDD_1V65_5 0
C585 5v0_addh_sc_tile_1/m1_103_293# VDD_3V3_0 0.14668f
C586 VDD_3V3_0 5v0_addh_sc_tile_1/upstepper_test 0.13286f
C587 5v0_addh_sc_tile_1/m1_843_n857# 5v0_add_q_sc_0/upstepper_test 0.0015f
C588 5v0_nter2oter_code_sc_1/nti 5v0_addh_sc_tile_2/inv_pti 0
C589 5v0_add_q_sc_0/ctrl_sign 5v0_addh_sc_tile_2/pti 0.011f
C590 5v0_nter2oter_code_sc_0/in 5v0_addh_sc_tile_2/pti 0.00286f
C591 5v0_add_q_sc_1/nti m1_n2844_n810# 0.00573f
C592 5v0_add_q_sc_1/5v0_half_adder_selector_sc_0/5v0_tgate_sel_2_sc_1/input_A 5v0_add_q_sc_1/5v0_half_adder_selector_sc_0/m1_n244_n517# 0.02928f
C593 5v0_addh_sc_tile_0/inv_nti 5v0_addh_sc_tile_0/a_n1373_n454# 0
C594 VDD_3V3_1 5v0_addh_sc_tile_1/a_382_n1095# 0.02507f
C595 5v0_add_q_sc_0/5v0_half_adder_selector_sc_0/m1_n239_179# VDD_3V3_0 0.30519f
C596 5v0_addh_sc_tile_0/upstepper_test 5v0_addh_sc_tile_0/carry_0_probe 0
C597 5v0_add_q_sc_1/ctrl_over 5v0_add_q_sc_0/ternary_input 0.30261f
C598 5v0_addh_sc_tile_0/downstepper_test 5v0_addh_sc_tile_1/ctrl_sign 0.02017f
C599 5v0_addh_sc_tile_0/a_382_n1095# 5v0_addh_sc_tile_0/carry_0_probe 0.08241f
C600 VDD_3V3_1 VDD_1V65_2 0.01209f
C601 5v0_add_q_sc_0/5v0_half_adder_selector_sc_0/res_stage0 5v0_addh_sc_tile_2/pti 0
C602 5v0_addh_sc_tile_2/upstepper_test 5v0_addh_sc_tile_1/nti 0.00102f
C603 in_0_sign 5v0_addh_sc_tile_0/inv_nti 0.24892f
C604 in_3 res_0 0.16326f
C605 5v0_add_q_sc_1/ternary_input 5v0_add_q_sc_1/ctrl_sign 0.20636f
C606 5v0_add_q_sc_0/inv_pti 5v0_add_q_sc_0/nti 0.21873f
C607 5v0_add_q_sc_1/ctrl_over 5v0_add_q_sc_0/pti 0.00513f
C608 5v0_addh_sc_tile_2/upstepper_test 5v0_addh_sc_tile_1/ternary_input 0
C609 5v0_addh_sc_tile_2/nti VDD_3V3_0 0.7527f
C610 5v0_add_q_sc_0/inv_pti 5v0_addh_sc_tile_1/ctrl_sign 0
C611 5v0_addh_sc_tile_1/m1_103_293# 5v0_addh_sc_tile_0/carry_0_probe 0.002f
C612 5v0_addh_sc_tile_0/carry_0_probe 5v0_addh_sc_tile_1/upstepper_test 0.02787f
C613 5v0_add_q_sc_0/a_n1205_n937# 5v0_add_q_sc_0/upstepper_test 0.00334f
C614 5v0_addh_sc_tile_2/a_382_n1095# res_0 0.16245f
C615 5v0_addh_sc_tile_2/inv_pti 5v0_addh_sc_tile_2/pti 0.44081f
C616 5v0_addh_sc_tile_1/m1_843_n857# 5v0_addh_sc_tile_1/inv_nti 0.36668f
C617 5v0_addh_sc_tile_1/inv_pti 5v0_addh_sc_tile_1/inv_nti 0.26136f
C618 5v0_add_q_sc_0/a_n1778_n454# 5v0_add_q_sc_0/upstepper_test 0
C619 5v0_addh_sc_tile_1/inv_nti 5v0_add_q_sc_0/upstepper_test 0.00109f
C620 5v0_addh_sc_tile_2/inv_nti 5v0_addh_sc_tile_1/inv_pti 0
C621 in_0_sign 5v0_addh_sc_tile_1/pti 0
C622 5v0_add_q_sc_1/ctrl_over 5v0_add_q_sc_1/downstepper_test 0.12191f
C623 5v0_addh_sc_tile_1/5v0_half_adder_selector_sc_0/res_stage0 5v0_add_q_sc_0/ctrl_sign 0
C624 5v0_addh_sc_tile_1/inv_pti 5v0_addh_sc_tile_2/ctrl_sign 0
C625 5v0_addh_sc_tile_0/inv_nti 5v0_addh_sc_tile_0/m1_843_n857# 0.36668f
C626 5v0_add_q_sc_0/5v0_half_adder_selector_sc_0/m1_n244_n517# 5v0_add_q_sc_0/nti 0
C627 5v0_add_q_sc_1/nti 5v0_addh_sc_tile_1/inv_pti 0.00413f
C628 5v0_addh_sc_tile_1/5v0_half_adder_selector_sc_0/res_stage0 5v0_nter2oter_code_sc_0/in 0.1871f
C629 5v0_addh_sc_tile_0/a_382_n1095# 5v0_addh_sc_tile_1/upstepper_test 0.00208f
C630 5v0_add_q_sc_1/a_n1205_n937# 5v0_add_q_sc_1/VDD_1V65 0.00354f
C631 5v0_addh_sc_tile_1/5v0_half_adder_selector_sc_0/res_stage0 5v0_addh_sc_tile_1/a_382_n1095# 0.08951f
C632 5v0_nter2oter_code_sc_1/pti 5v0_addh_sc_tile_1/ctrl_over 0.00583f
C633 5v0_add_q_sc_0/inv_pti 5v0_add_q_sc_0/ternary_input 0.08665f
C634 5v0_addh_sc_tile_1/a_382_n1095# 5v0_addh_sc_tile_1/5v0_half_adder_selector_sc_0/5v0_tgate_sel_2_sc_1/input_A 0.02928f
C635 5v0_addh_sc_tile_1/ctrl_over 5v0_addh_sc_tile_0/nti 0
C636 5v0_addh_sc_tile_1/m1_103_293# 5v0_addh_sc_tile_1/upstepper_test 0.07773f
C637 5v0_add_q_sc_1/5v0_half_adder_selector_sc_0/res_stage0 5v0_add_q_sc_1/ternary_input 0.27251f
C638 5v0_add_q_sc_0/inv_pti 5v0_add_q_sc_0/pti 0.19726f
C639 5v0_addh_sc_tile_1/pti 5v0_addh_sc_tile_0/m1_843_n857# 0
C640 5v0_addh_sc_tile_0/nti 5v0_addh_sc_tile_0/a_n1205_n937# 0
C641 5v0_nter2oter_code_sc_1/nti 5v0_addh_sc_tile_1/downstepper_test 0
C642 5v0_addh_sc_tile_1/m1_103_293# 5v0_add_q_sc_0/5v0_half_adder_selector_sc_0/m1_n239_179# 0
C643 5v0_addh_sc_tile_2/inv_nti 5v0_addh_sc_tile_1/inv_nti 0
C644 5v0_add_q_sc_1/ctrl_over 5v0_add_q_sc_1/ctrl_sign 0.02923f
C645 5v0_add_q_sc_1/inv_nti 5v0_addh_sc_tile_0/inv_nti 0
C646 5v0_add_q_sc_0/downstepper_test 5v0_addh_sc_tile_2/a_382_n1095# 0.00139f
C647 VDD_1V65_4 5v0_addh_sc_tile_2/inv_nti 0.08611f
C648 5v0_add_q_sc_1/pti 5v0_add_q_sc_1/ternary_input 0.54174f
C649 5v0_addh_sc_tile_1/inv_nti 5v0_addh_sc_tile_2/ctrl_sign 0.00386f
C650 5v0_addh_sc_tile_2/ctrl_sign 5v0_nter2oter_code_sc_0/nti 0.03693f
C651 5v0_addh_sc_tile_2/5v0_half_adder_selector_sc_0/res_stage0 5v0_addh_sc_tile_1/nti 0
C652 VDD_3V3_1 5v0_addh_sc_tile_0/inv_pti 1.05126f
C653 5v0_add_q_sc_1/nti 5v0_addh_sc_tile_1/inv_nti 0
C654 5v0_addh_sc_tile_0/inv_pti in_0_over 0
C655 in_0_sign 5v0_addh_sc_tile_0/m1_103_293# 0.60072f
C656 5v0_addh_sc_tile_2/5v0_half_adder_selector_sc_0/res_stage0 5v0_addh_sc_tile_1/ternary_input 0
C657 5v0_addh_sc_tile_1/ctrl_sign 5v0_addh_sc_tile_1/nti 0.14557f
C658 VDD_1V65_4 5v0_addh_sc_tile_2/ctrl_sign 0
C659 5v0_addh_sc_tile_2/inv_nti 5v0_addh_sc_tile_2/ctrl_sign 0.24905f
C660 5v0_nter2oter_code_sc_1/nti in_2 0.19929f
C661 5v0_add_q_sc_0/5v0_half_adder_selector_sc_0/m1_n244_n517# 5v0_add_q_sc_0/ternary_input 0.07888f
C662 5v0_addh_sc_tile_1/ternary_input 5v0_addh_sc_tile_1/ctrl_sign 0.17378f
C663 5v0_add_q_sc_0/downstepper_test 5v0_addh_sc_tile_1/ctrl_over 0
C664 in_1 5v0_addh_sc_tile_1/ctrl_over 0
C665 VDD_3V3_1 5v0_addh_sc_tile_1/downstepper_test 0.09186f
C666 VDD_1V65_4 5v0_addh_sc_tile_2/downstepper_test 0.13024f
C667 5v0_addh_sc_tile_1/downstepper_test in_0_over 0
C668 5v0_add_q_sc_0/ctrl_over VDD_1V65_5 0
C669 5v0_addh_sc_tile_2/inv_nti 5v0_addh_sc_tile_2/downstepper_test 0.29987f
C670 5v0_addh_sc_tile_1/ctrl_over 5v0_nter2oter_code_sc_1/gf180mcu_fd_sc_mcu7t5v0__nor2_1_0/a_224_472# 0.02885f
C671 5v0_addh_sc_tile_0/carry_sign_probe m1_n2844_n810# 0.12483f
C672 5v0_addh_sc_tile_1/pti 5v0_addh_sc_tile_2/ctrl_over 0
C673 5v0_addh_sc_tile_1/ctrl_over VDD_1V65_3 0.02438f
C674 5v0_addh_sc_tile_0/nti 5v0_addh_sc_tile_0/a_n1373_n454# 0
C675 5v0_add_q_sc_1/ternary_input 5v0_add_q_sc_1/inv_pti 0.08427f
C676 5v0_add_q_sc_0/5v0_half_adder_selector_sc_0/5v0_tgate_sel_2_sc_1/input_A 5v0_add_q_sc_0/upstepper_test 0
C677 5v0_addh_sc_tile_1/pti 5v0_add_q_sc_1/inv_nti 0.00257f
C678 VDD_1V65_5 5v0_addh_sc_tile_2/ctrl_over 0
C679 in_3 5v0_nter2oter_code_sc_0/in 0.01005f
C680 5v0_addh_sc_tile_2/ctrl_sign 5v0_addh_sc_tile_2/downstepper_test 0.20835f
C681 5v0_add_q_sc_1/a_n1205_n937# 5v0_add_q_sc_1/inv_nti 0
C682 5v0_add_q_sc_0/ctrl_sign 5v0_addh_sc_tile_2/a_382_n1095# 0.00651f
C683 VDD_3V3_1 in_2 0.90866f
C684 5v0_addh_sc_tile_2/a_382_n1095# 5v0_nter2oter_code_sc_0/in 0
C685 in_0_sign 5v0_addh_sc_tile_0/nti 0
C686 5v0_addh_sc_tile_2/a_382_n1095# 5v0_addh_sc_tile_2/5v0_half_adder_selector_sc_0/5v0_tgate_sel_2_sc_1/input_A 0.02928f
C687 5v0_add_q_sc_0/ternary_input 5v0_addh_sc_tile_2/m1_843_n857# 0
C688 in_2 5v0_addh_sc_tile_2/pti 0
C689 5v0_addh_sc_tile_0/m1_103_293# 5v0_addh_sc_tile_0/m1_843_n857# 0.20659f
C690 5v0_add_q_sc_0/5v0_half_adder_selector_sc_0/m1_n244_n517# res_c 0.16119f
C691 VDD_3V3_1 5v0_add_q_sc_1/ternary_input 1.23209f
C692 5v0_add_q_sc_0/ctrl_sign 5v0_addh_sc_tile_1/ctrl_over 0.00366f
C693 5v0_addh_sc_tile_2/a_382_n1095# 5v0_add_q_sc_0/5v0_half_adder_selector_sc_0/res_stage0 0.0013f
C694 5v0_addh_sc_tile_1/5v0_half_adder_selector_sc_0/res_stage0 5v0_addh_sc_tile_1/a_n1205_n937# 0
C695 5v0_add_q_sc_1/5v0_half_adder_selector_sc_0/res_stage0 5v0_add_q_sc_1/ctrl_over 0.11645f
C696 5v0_addh_sc_tile_1/ctrl_over 5v0_nter2oter_code_sc_0/in 0.27048f
C697 in_1 5v0_addh_sc_tile_0/a_n1373_n454# 0.00163f
C698 in_0_sign 5v0_addh_sc_tile_0/5v0_half_adder_selector_sc_0/5v0_tgate_sel_2_sc_1/input_A 0
C699 in_3 5v0_addh_sc_tile_2/inv_pti 0.05631f
C700 5v0_add_q_sc_1/ternary_input 5v0_add_q_sc_1/5v0_half_adder_selector_sc_0/m1_n244_n517# 0.07888f
C701 5v0_addh_sc_tile_1/pti VDD_3V3_0 0.08682f
C702 m1_n2844_n810# 5v0_addh_sc_tile_1/ctrl_sign 0.00105f
C703 5v0_addh_sc_tile_1/a_382_n1095# 5v0_addh_sc_tile_1/ctrl_over 0.70472f
C704 5v0_add_q_sc_1/a_n1373_n454# 5v0_add_q_sc_1/ternary_input 0.00136f
C705 5v0_addh_sc_tile_1/ctrl_over 5v0_add_q_sc_0/5v0_half_adder_selector_sc_0/res_stage0 0
C706 5v0_add_q_sc_0/ctrl_over res_0 0
C707 5v0_addh_sc_tile_2/a_382_n1095# 5v0_addh_sc_tile_2/inv_pti 0.00129f
C708 in_1 in_0_sign 0
C709 5v0_addh_sc_tile_0/carry_0_probe 5v0_addh_sc_tile_0/inv_nti 0.03001f
C710 5v0_add_q_sc_1/ctrl_over 5v0_add_q_sc_1/pti 0
C711 VDD_3V3_0 VDD_1V65_5 0.04709f
C712 in_0_sign VDD_1V65_3 0
C713 5v0_addh_sc_tile_0/pti 5v0_addh_sc_tile_0/a_n1373_n454# 0
C714 res_0 5v0_addh_sc_tile_2/ctrl_over 0.20137f
C715 5v0_addh_sc_tile_1/5v0_half_adder_selector_sc_0/res_stage0 5v0_addh_sc_tile_1/downstepper_test 0.25483f
C716 VDD_3V3_1 5v0_nter2oter_code_sc_0/pti 0.29053f
C717 5v0_addh_sc_tile_1/downstepper_test 5v0_addh_sc_tile_1/5v0_half_adder_selector_sc_0/5v0_tgate_sel_2_sc_1/input_A 0
C718 5v0_addh_sc_tile_1/ctrl_over 5v0_addh_sc_tile_2/inv_pti 0.00359f
C719 5v0_addh_sc_tile_2/upstepper_test VDD_1V65_4 0.16859f
C720 5v0_addh_sc_tile_2/m1_103_293# 5v0_addh_sc_tile_2/pti 0.10002f
C721 5v0_addh_sc_tile_2/upstepper_test 5v0_addh_sc_tile_2/inv_nti 0.00736f
C722 5v0_nter2oter_code_sc_0/pti 5v0_addh_sc_tile_2/pti 0
C723 5v0_add_q_sc_1/ctrl_over 5v0_add_q_sc_1/inv_pti 0.0024f
C724 in_0_sign 5v0_addh_sc_tile_0/pti 0.27027f
C725 5v0_addh_sc_tile_1/ctrl_over 5v0_add_q_sc_0/inv_nti 0
C726 5v0_addh_sc_tile_1/pti 5v0_addh_sc_tile_0/carry_0_probe 0.0051f
C727 5v0_addh_sc_tile_2/upstepper_test 5v0_addh_sc_tile_2/ctrl_sign 0.15846f
C728 5v0_addh_sc_tile_0/upstepper_test 5v0_addh_sc_tile_0/inv_nti 0.00736f
C729 5v0_nter2oter_code_sc_1/pti 5v0_addh_sc_tile_2/ctrl_over 0
C730 in_1 5v0_addh_sc_tile_0/m1_843_n857# 0
C731 5v0_addh_sc_tile_2/upstepper_test 5v0_addh_sc_tile_2/downstepper_test 0.38555f
C732 5v0_addh_sc_tile_0/a_382_n1095# 5v0_addh_sc_tile_0/inv_nti 0.28672f
C733 VDD_3V3_1 5v0_add_q_sc_1/ctrl_over 0.6465f
C734 5v0_addh_sc_tile_1/m1_843_n857# 5v0_add_q_sc_0/nti 0
C735 res_0 VDD_3V3_0 0.09575f
C736 5v0_addh_sc_tile_1/m1_843_n857# 5v0_addh_sc_tile_1/ctrl_sign 0.24363f
C737 5v0_addh_sc_tile_1/inv_pti 5v0_addh_sc_tile_1/ctrl_sign 0.41772f
C738 5v0_add_q_sc_0/nti 5v0_add_q_sc_0/upstepper_test 0.11981f
C739 5v0_add_q_sc_1/ctrl_over 5v0_add_q_sc_1/5v0_half_adder_selector_sc_0/m1_n244_n517# 0.34508f
C740 VDD_3V3_1 5v0_addh_sc_tile_0/5v0_half_adder_selector_sc_0/res_stage0 0.16177f
C741 5v0_addh_sc_tile_1/ctrl_sign 5v0_add_q_sc_0/upstepper_test 0
C742 5v0_addh_sc_tile_0/pti 5v0_addh_sc_tile_0/m1_843_n857# 0.11666f
C743 5v0_addh_sc_tile_0/5v0_half_adder_selector_sc_0/res_stage0 in_0_over 0.09179f
C744 5v0_add_q_sc_0/downstepper_test 5v0_add_q_sc_0/ctrl_over 0.02328f
C745 5v0_addh_sc_tile_1/a_382_n1095# 5v0_add_q_sc_1/VDD_1V65 0
C746 5v0_addh_sc_tile_0/a_382_n1095# 5v0_addh_sc_tile_1/pti 0.00485f
C747 5v0_nter2oter_code_sc_1/nti 5v0_addh_sc_tile_0/downstepper_test 0
C748 5v0_add_q_sc_1/a_n1778_n454# 5v0_add_q_sc_1/ternary_input 0.00116f
C749 5v0_add_q_sc_0/downstepper_test 5v0_addh_sc_tile_2/ctrl_over 0.01272f
C750 5v0_addh_sc_tile_0/carry_sign_probe 5v0_add_q_sc_1/nti 0
C751 5v0_addh_sc_tile_1/ctrl_over 5v0_addh_sc_tile_1/a_n1205_n937# 0.00169f
C752 5v0_addh_sc_tile_1/m1_103_293# 5v0_addh_sc_tile_1/pti 0.10002f
C753 5v0_nter2oter_code_sc_1/pti VDD_3V3_0 0.19634f
C754 5v0_addh_sc_tile_1/pti 5v0_addh_sc_tile_1/upstepper_test 0.02161f
C755 5v0_add_q_sc_0/a_n1205_n937# 5v0_add_q_sc_0/nti 0
C756 5v0_addh_sc_tile_0/a_n1778_n454# VDD_1V65_0 0
C757 5v0_addh_sc_tile_0/carry_0_probe 5v0_addh_sc_tile_0/m1_103_293# 0.01488f
C758 5v0_addh_sc_tile_0/nti VDD_3V3_0 0
C759 5v0_addh_sc_tile_1/downstepper_test 5v0_addh_sc_tile_2/a_382_n1095# 0.0018f
C760 5v0_addh_sc_tile_1/pti 5v0_add_q_sc_0/5v0_half_adder_selector_sc_0/m1_n239_179# 0
C761 5v0_add_q_sc_0/a_n1778_n454# 5v0_add_q_sc_0/nti 0.00142f
C762 5v0_add_q_sc_0/nti 5v0_addh_sc_tile_1/inv_nti 0
C763 VDD_3V3_1 5v0_addh_sc_tile_0/downstepper_test 0.51279f
C764 5v0_addh_sc_tile_1/ctrl_sign 5v0_nter2oter_code_sc_0/nti 0
C765 5v0_add_q_sc_1/inv_nti 5v0_addh_sc_tile_0/pti 0.00104f
C766 5v0_addh_sc_tile_1/inv_nti 5v0_addh_sc_tile_1/ctrl_sign 0.25029f
C767 5v0_addh_sc_tile_0/downstepper_test in_0_over 0.02344f
C768 5v0_addh_sc_tile_1/m1_843_n857# 5v0_add_q_sc_0/ternary_input 0.00836f
C769 5v0_addh_sc_tile_1/inv_pti 5v0_add_q_sc_0/ternary_input 0.00157f
C770 5v0_addh_sc_tile_2/5v0_half_adder_selector_sc_0/res_stage0 5v0_addh_sc_tile_2/inv_nti 0.02878f
C771 5v0_add_q_sc_0/ctrl_sign 5v0_add_q_sc_0/ctrl_over 0.02568f
C772 5v0_addh_sc_tile_1/downstepper_test 5v0_addh_sc_tile_1/ctrl_over 0.16058f
C773 VDD_1V65_4 5v0_addh_sc_tile_1/ctrl_sign 0
C774 5v0_addh_sc_tile_2/inv_nti 5v0_addh_sc_tile_1/ctrl_sign 0
C775 5v0_add_q_sc_0/ternary_input 5v0_add_q_sc_0/upstepper_test 0.02583f
C776 5v0_add_q_sc_0/ctrl_sign 5v0_addh_sc_tile_2/ctrl_over 0.2177f
C777 5v0_add_q_sc_0/ctrl_over 5v0_addh_sc_tile_2/5v0_half_adder_selector_sc_0/5v0_tgate_sel_2_sc_1/input_A 0
C778 5v0_addh_sc_tile_1/m1_843_n857# 5v0_add_q_sc_0/pti 0.00111f
C779 5v0_addh_sc_tile_1/5v0_half_adder_selector_sc_0/res_stage0 5v0_add_q_sc_1/ctrl_over 0
C780 5v0_addh_sc_tile_2/5v0_half_adder_selector_sc_0/res_stage0 5v0_addh_sc_tile_2/ctrl_sign 0.25152f
C781 5v0_nter2oter_code_sc_0/in 5v0_addh_sc_tile_2/ctrl_over 1.76395f
C782 5v0_add_q_sc_1/ctrl_over 5v0_addh_sc_tile_1/5v0_half_adder_selector_sc_0/5v0_tgate_sel_2_sc_1/input_A 0
C783 5v0_addh_sc_tile_1/a_382_n1095# 5v0_add_q_sc_0/ctrl_over 0
C784 5v0_addh_sc_tile_0/carry_0_probe 5v0_addh_sc_tile_0/nti 0
C785 5v0_add_q_sc_0/downstepper_test VDD_3V3_0 0.55841f
C786 5v0_addh_sc_tile_2/ctrl_sign 5v0_addh_sc_tile_1/ctrl_sign 0.036f
C787 5v0_addh_sc_tile_2/5v0_half_adder_selector_sc_0/5v0_tgate_sel_2_sc_1/input_A 5v0_addh_sc_tile_2/ctrl_over 0.04656f
C788 5v0_add_q_sc_0/pti 5v0_add_q_sc_0/upstepper_test 0
C789 5v0_addh_sc_tile_2/5v0_half_adder_selector_sc_0/res_stage0 5v0_addh_sc_tile_2/downstepper_test 0.24494f
C790 5v0_addh_sc_tile_0/upstepper_test 5v0_addh_sc_tile_0/m1_103_293# 0.07773f
C791 5v0_add_q_sc_0/ctrl_over 5v0_add_q_sc_0/5v0_half_adder_selector_sc_0/res_stage0 0.09159f
C792 m1_n2844_n810# 5v0_add_q_sc_1/ctrl_sign 0.00441f
C793 5v0_add_q_sc_1/nti 5v0_addh_sc_tile_1/ctrl_sign 0.00138f
C794 5v0_addh_sc_tile_1/ctrl_sign VDD_1V65_0 0
C795 VDD_3V3_0 5v0_nter2oter_code_sc_1/gf180mcu_fd_sc_mcu7t5v0__nor2_1_0/a_224_472# 0.01644f
C796 VDD_1V65_3 VDD_3V3_0 0.04264f
C797 5v0_addh_sc_tile_0/a_382_n1095# 5v0_addh_sc_tile_0/m1_103_293# 0.07764f
C798 in_2 5v0_addh_sc_tile_1/ctrl_over 0.01618f
C799 5v0_add_q_sc_0/5v0_half_adder_selector_sc_0/res_stage0 5v0_addh_sc_tile_2/ctrl_over 0.00474f
C800 5v0_addh_sc_tile_0/inv_pti 5v0_addh_sc_tile_0/a_n1373_n454# 0.00135f
C801 5v0_add_q_sc_0/a_n1205_n937# 5v0_add_q_sc_0/ternary_input 0
C802 5v0_addh_sc_tile_0/carry_0_probe 5v0_addh_sc_tile_0/5v0_half_adder_selector_sc_0/5v0_tgate_sel_2_sc_1/input_A 0
C803 5v0_addh_sc_tile_1/inv_pti 5v0_add_q_sc_1/downstepper_test 0.00756f
C804 5v0_addh_sc_tile_2/m1_103_293# in_3 0
C805 5v0_add_q_sc_0/a_n1778_n454# 5v0_add_q_sc_0/ternary_input 0.00116f
C806 in_3 5v0_nter2oter_code_sc_0/pti 0.00219f
C807 5v0_add_q_sc_0/ternary_input 5v0_addh_sc_tile_1/inv_nti 0.0263f
C808 5v0_addh_sc_tile_2/inv_pti 5v0_addh_sc_tile_2/ctrl_over 0.0554f
C809 5v0_addh_sc_tile_0/inv_pti in_0_sign 0.23041f
C810 in_1 5v0_addh_sc_tile_0/carry_0_probe 0.00136f
C811 5v0_add_q_sc_0/5v0_half_adder_selector_sc_0/m1_n244_n517# 5v0_addh_sc_tile_2/pti 0
C812 5v0_addh_sc_tile_2/m1_103_293# 5v0_addh_sc_tile_2/a_382_n1095# 0.07764f
C813 5v0_addh_sc_tile_0/upstepper_test 5v0_addh_sc_tile_0/nti 0.11981f
C814 5v0_add_q_sc_0/a_n1778_n454# 5v0_add_q_sc_0/pti 0.00135f
C815 5v0_add_q_sc_0/ctrl_sign VDD_3V3_0 0.8077f
C816 5v0_addh_sc_tile_2/inv_nti 5v0_add_q_sc_0/ternary_input 0
C817 5v0_nter2oter_code_sc_0/in VDD_3V3_0 2.39715f
C818 5v0_addh_sc_tile_0/a_382_n1095# 5v0_addh_sc_tile_0/nti 0
C819 5v0_nter2oter_code_sc_1/nti 5v0_addh_sc_tile_1/nti 0.20212f
C820 res_0 5v0_addh_sc_tile_2/nti 0
C821 5v0_addh_sc_tile_2/5v0_half_adder_selector_sc_0/5v0_tgate_sel_2_sc_1/input_A VDD_3V3_0 0.02871f
C822 5v0_add_q_sc_0/ternary_input 5v0_addh_sc_tile_2/ctrl_sign 0
C823 5v0_nter2oter_code_sc_1/nti 5v0_addh_sc_tile_1/ternary_input 0.01204f
C824 5v0_addh_sc_tile_2/m1_103_293# 5v0_addh_sc_tile_1/ctrl_over 0
C825 5v0_addh_sc_tile_1/a_382_n1095# VDD_3V3_0 0.61115f
C826 5v0_add_q_sc_1/nti 5v0_add_q_sc_0/ternary_input 0
C827 5v0_addh_sc_tile_1/ctrl_over 5v0_nter2oter_code_sc_0/pti 0.00235f
C828 5v0_addh_sc_tile_2/a_n1205_n937# 5v0_addh_sc_tile_2/ctrl_over 0
C829 5v0_addh_sc_tile_0/carry_0_probe 5v0_addh_sc_tile_0/pti 0.14486f
C830 5v0_add_q_sc_0/5v0_half_adder_selector_sc_0/res_stage0 VDD_3V3_0 0.16909f
C831 5v0_addh_sc_tile_0/upstepper_test 5v0_addh_sc_tile_0/5v0_half_adder_selector_sc_0/5v0_tgate_sel_2_sc_1/input_A 0
C832 5v0_addh_sc_tile_1/m1_843_n857# 5v0_add_q_sc_1/ctrl_sign 0.0069f
C833 5v0_addh_sc_tile_1/inv_pti 5v0_add_q_sc_1/ctrl_sign 0.12531f
C834 5v0_addh_sc_tile_0/a_382_n1095# 5v0_addh_sc_tile_0/5v0_half_adder_selector_sc_0/5v0_tgate_sel_2_sc_1/input_A 0.02928f
C835 in_1 5v0_addh_sc_tile_0/upstepper_test 0.01604f
C836 5v0_addh_sc_tile_2/m1_843_n857# 5v0_addh_sc_tile_2/pti 0.11666f
C837 5v0_addh_sc_tile_0/inv_pti 5v0_addh_sc_tile_0/m1_843_n857# 0
C838 5v0_addh_sc_tile_1/inv_nti 5v0_add_q_sc_1/downstepper_test 0.00441f
C839 VDD_3V3_1 5v0_addh_sc_tile_1/nti 0.14047f
C840 5v0_nter2oter_code_sc_1/pti 5v0_addh_sc_tile_2/nti 0
C841 5v0_addh_sc_tile_2/inv_pti VDD_3V3_0 1.08715f
C842 in_1 5v0_addh_sc_tile_0/a_382_n1095# 0.09307f
C843 in_0_over 5v0_addh_sc_tile_1/nti 0.00205f
C844 in_0_sign 5v0_add_q_sc_1/ternary_input 0
C845 5v0_addh_sc_tile_2/upstepper_test 5v0_addh_sc_tile_2/5v0_half_adder_selector_sc_0/res_stage0 0.27475f
C846 VDD_3V3_1 5v0_addh_sc_tile_1/ternary_input 1.22329f
C847 5v0_addh_sc_tile_1/nti 5v0_addh_sc_tile_2/pti 0
C848 in_0_over 5v0_addh_sc_tile_1/ternary_input 0.21152f
C849 5v0_addh_sc_tile_1/downstepper_test 5v0_addh_sc_tile_0/m1_843_n857# 0
C850 5v0_add_q_sc_0/inv_nti VDD_3V3_0 0.56502f
C851 5v0_addh_sc_tile_1/a_382_n1095# 5v0_addh_sc_tile_0/carry_0_probe 0
C852 5v0_addh_sc_tile_1/m1_103_293# 5v0_add_q_sc_0/downstepper_test 0
C853 5v0_add_q_sc_1/ctrl_over 5v0_addh_sc_tile_1/ctrl_over 0.12383f
C854 5v0_addh_sc_tile_0/upstepper_test 5v0_addh_sc_tile_0/pti 0.02426f
C855 5v0_add_q_sc_1/ternary_input 5v0_add_q_sc_1/VDD_1V65 0.03394f
C856 5v0_addh_sc_tile_0/carry_0_probe VDD_1V65_2 0.03841f
C857 VDD_1V65_3 5v0_addh_sc_tile_1/upstepper_test 0.16859f
C858 5v0_add_q_sc_1/nti 5v0_add_q_sc_1/downstepper_test 0.06596f
C859 5v0_addh_sc_tile_0/a_382_n1095# 5v0_addh_sc_tile_0/pti 0.12627f
C860 5v0_add_q_sc_0/downstepper_test 5v0_add_q_sc_0/5v0_half_adder_selector_sc_0/m1_n239_179# 0.09961f
C861 VDD_3V3_0 5v0_addh_sc_tile_2/a_n1205_n937# 0.00891f
C862 5v0_addh_sc_tile_0/5v0_half_adder_selector_sc_0/res_stage0 5v0_addh_sc_tile_1/ctrl_over 0
C863 5v0_addh_sc_tile_1/pti 5v0_addh_sc_tile_0/inv_nti 0
C864 5v0_addh_sc_tile_0/5v0_half_adder_selector_sc_0/res_stage0 5v0_addh_sc_tile_0/a_n1205_n937# 0
C865 5v0_add_q_sc_1/5v0_half_adder_selector_sc_0/m1_n239_179# 5v0_add_q_sc_1/downstepper_test 0.09961f
C866 5v0_addh_sc_tile_1/inv_nti 5v0_add_q_sc_1/ctrl_sign 0.05407f
C867 5v0_addh_sc_tile_1/downstepper_test 5v0_addh_sc_tile_2/ctrl_over 0.01399f
C868 5v0_nter2oter_code_sc_0/in 5v0_addh_sc_tile_1/upstepper_test 0.00268f
C869 VDD_3V3_1 m1_n2844_n810# 0.14975f
C870 5v0_add_q_sc_1/nti 5v0_add_q_sc_1/ctrl_sign 0.2845f
C871 5v0_add_q_sc_0/ctrl_sign 5v0_add_q_sc_0/5v0_half_adder_selector_sc_0/m1_n239_179# 0.307f
C872 in_0_over m1_n2844_n810# 0.00329f
C873 5v0_addh_sc_tile_1/a_n1205_n937# VDD_3V3_0 0.00891f
C874 5v0_add_q_sc_0/a_n1373_n454# VDD_3V3_0 0.00122f
C875 5v0_addh_sc_tile_0/downstepper_test 5v0_addh_sc_tile_1/ctrl_over 0
C876 5v0_addh_sc_tile_1/5v0_half_adder_selector_sc_0/res_stage0 5v0_addh_sc_tile_1/nti 0.00372f
C877 5v0_addh_sc_tile_1/m1_103_293# 5v0_addh_sc_tile_1/a_382_n1095# 0.07764f
C878 in_2 5v0_addh_sc_tile_2/ctrl_over 0
C879 5v0_addh_sc_tile_1/inv_pti 5v0_add_q_sc_1/pti 0
C880 5v0_addh_sc_tile_0/downstepper_test 5v0_addh_sc_tile_0/a_n1205_n937# 0.00453f
C881 5v0_addh_sc_tile_1/5v0_half_adder_selector_sc_0/res_stage0 5v0_addh_sc_tile_1/ternary_input 0.26626f
C882 5v0_add_q_sc_1/5v0_half_adder_selector_sc_0/m1_n239_179# 5v0_add_q_sc_1/ctrl_sign 0.30422f
C883 5v0_addh_sc_tile_1/m1_103_293# VDD_1V65_2 0
C884 5v0_addh_sc_tile_1/a_382_n1095# 5v0_add_q_sc_0/5v0_half_adder_selector_sc_0/m1_n239_179# 0.0035f
C885 5v0_add_q_sc_0/inv_pti 5v0_addh_sc_tile_1/ctrl_over 0.00152f
C886 5v0_addh_sc_tile_2/nti 5v0_nter2oter_code_sc_0/in 0.00515f
C887 5v0_add_q_sc_1/inv_nti 5v0_add_q_sc_1/ternary_input 0.02537f
C888 5v0_add_q_sc_0/5v0_half_adder_selector_sc_0/m1_n239_179# 5v0_add_q_sc_0/5v0_half_adder_selector_sc_0/res_stage0 0.18379f
C889 in_0_sign 5v0_addh_sc_tile_0/5v0_half_adder_selector_sc_0/res_stage0 0.22359f
C890 5v0_add_q_sc_1/ctrl_over 5v0_add_q_sc_1/VDD_1V65 0.04751f
C891 5v0_addh_sc_tile_1/downstepper_test VDD_3V3_0 0.41827f
C892 5v0_addh_sc_tile_1/m1_843_n857# 5v0_add_q_sc_1/inv_pti 0
C893 5v0_addh_sc_tile_0/m1_103_293# 5v0_addh_sc_tile_0/inv_nti 0.35313f
C894 5v0_add_q_sc_0/nti 5v0_addh_sc_tile_1/ctrl_sign 0
C895 5v0_add_q_sc_0/5v0_half_adder_selector_sc_0/m1_n239_179# 5v0_addh_sc_tile_2/inv_pti 0.00128f
C896 5v0_addh_sc_tile_1/a_n1373_n454# VDD_3V3_0 0.00122f
C897 5v0_add_q_sc_0/5v0_half_adder_selector_sc_0/m1_n244_n517# 5v0_addh_sc_tile_2/a_382_n1095# 0
C898 5v0_add_q_sc_0/ctrl_over 5v0_addh_sc_tile_2/m1_103_293# 0.01398f
C899 5v0_addh_sc_tile_0/downstepper_test 5v0_addh_sc_tile_0/a_n1373_n454# 0.00442f
C900 5v0_addh_sc_tile_0/inv_pti 5v0_addh_sc_tile_0/carry_0_probe 0.01451f
C901 5v0_addh_sc_tile_2/nti 5v0_addh_sc_tile_2/inv_pti 0.24025f
C902 5v0_addh_sc_tile_2/m1_103_293# 5v0_addh_sc_tile_2/ctrl_over 0.05856f
C903 in_2 VDD_3V3_0 0.0135f
C904 5v0_add_q_sc_1/pti 5v0_addh_sc_tile_1/inv_nti 0
C905 5v0_nter2oter_code_sc_0/pti 5v0_addh_sc_tile_2/ctrl_over 0.00125f
C906 5v0_nter2oter_code_sc_1/pti 5v0_addh_sc_tile_0/inv_nti 0.00491f
C907 VDD_3V3_1 5v0_addh_sc_tile_1/m1_843_n857# 0.00388f
C908 VDD_3V3_1 5v0_addh_sc_tile_1/inv_pti 0.81122f
C909 5v0_addh_sc_tile_1/pti 5v0_addh_sc_tile_0/m1_103_293# 0.00135f
C910 5v0_addh_sc_tile_1/downstepper_test 5v0_addh_sc_tile_0/carry_0_probe 0.01317f
C911 5v0_addh_sc_tile_1/inv_pti in_0_over 0.00926f
C912 5v0_add_q_sc_1/nti 5v0_add_q_sc_1/5v0_half_adder_selector_sc_0/res_stage0 0.00372f
C913 in_0_sign 5v0_addh_sc_tile_0/downstepper_test 0.14463f
C914 VDD_3V3_1 5v0_add_q_sc_0/upstepper_test 0
C915 in_3 5v0_addh_sc_tile_2/m1_843_n857# 0
C916 5v0_addh_sc_tile_0/nti 5v0_addh_sc_tile_0/inv_nti 0.22786f
C917 5v0_addh_sc_tile_1/inv_pti 5v0_addh_sc_tile_2/pti 0
C918 VDD_1V65_4 5v0_addh_sc_tile_2/a_n1373_n454# 0.00232f
C919 5v0_addh_sc_tile_2/inv_nti 5v0_addh_sc_tile_2/a_n1373_n454# 0
C920 5v0_addh_sc_tile_2/pti 5v0_add_q_sc_0/upstepper_test 0
C921 5v0_addh_sc_tile_2/a_382_n1095# 5v0_addh_sc_tile_2/m1_843_n857# 0.05013f
C922 5v0_add_q_sc_1/5v0_half_adder_selector_sc_0/res_stage0 5v0_add_q_sc_1/5v0_half_adder_selector_sc_0/m1_n239_179# 0.18379f
C923 5v0_nter2oter_code_sc_1/nti 5v0_addh_sc_tile_1/inv_nti 0.00264f
C924 5v0_add_q_sc_1/nti 5v0_add_q_sc_1/pti 0.15563f
C925 5v0_addh_sc_tile_2/nti 5v0_addh_sc_tile_2/a_n1205_n937# 0
C926 5v0_add_q_sc_0/nti 5v0_add_q_sc_0/ternary_input 0.62238f
C927 5v0_addh_sc_tile_2/a_382_n1095# 5v0_addh_sc_tile_1/nti 0
C928 5v0_addh_sc_tile_0/inv_pti 5v0_addh_sc_tile_0/upstepper_test 0.07282f
C929 5v0_add_q_sc_0/ternary_input 5v0_addh_sc_tile_1/ctrl_sign 0
C930 5v0_addh_sc_tile_2/a_382_n1095# 5v0_addh_sc_tile_1/ternary_input 0
C931 5v0_addh_sc_tile_1/a_n1205_n937# 5v0_addh_sc_tile_1/upstepper_test 0.00334f
C932 5v0_add_q_sc_1/ctrl_over 5v0_add_q_sc_1/inv_nti 0.00311f
C933 5v0_addh_sc_tile_2/downstepper_test 5v0_addh_sc_tile_2/a_n1373_n454# 0.00442f
C934 5v0_addh_sc_tile_0/a_382_n1095# 5v0_addh_sc_tile_0/inv_pti 0.00129f
C935 5v0_add_q_sc_0/nti 5v0_add_q_sc_0/pti 0.1782f
C936 5v0_addh_sc_tile_0/carry_0_probe 5v0_add_q_sc_1/ternary_input 0.23005f
C937 5v0_addh_sc_tile_2/m1_103_293# VDD_3V3_0 0.75958f
C938 5v0_nter2oter_code_sc_1/nti 5v0_addh_sc_tile_2/ctrl_sign 0.01527f
C939 in_1 5v0_addh_sc_tile_0/inv_nti 0.28245f
C940 5v0_nter2oter_code_sc_0/pti VDD_3V3_0 0.17187f
C941 5v0_addh_sc_tile_1/ctrl_over 5v0_addh_sc_tile_1/nti 0.0773f
C942 5v0_nter2oter_code_sc_1/nti VDD_1V65_0 0
C943 5v0_add_q_sc_1/nti 5v0_add_q_sc_1/inv_pti 0.21255f
C944 VDD_3V3_1 5v0_nter2oter_code_sc_0/nti 0.09208f
C945 VDD_3V3_1 5v0_addh_sc_tile_1/inv_nti 0.11496f
C946 in_0_over 5v0_addh_sc_tile_1/inv_nti 0
C947 VDD_1V65_4 5v0_addh_sc_tile_2/a_n1778_n454# 0
C948 5v0_addh_sc_tile_1/ctrl_over 5v0_addh_sc_tile_1/ternary_input 0.25947f
C949 5v0_addh_sc_tile_2/inv_nti 5v0_addh_sc_tile_2/a_n1778_n454# 0.00226f
C950 5v0_addh_sc_tile_1/inv_nti 5v0_addh_sc_tile_2/pti 0
C951 5v0_add_q_sc_1/5v0_half_adder_selector_sc_0/m1_n239_179# 5v0_add_q_sc_1/inv_pti 0
C952 5v0_addh_sc_tile_1/m1_103_293# 5v0_addh_sc_tile_1/downstepper_test 0.10533f
C953 5v0_addh_sc_tile_1/downstepper_test 5v0_addh_sc_tile_1/upstepper_test 0.38867f
C954 5v0_addh_sc_tile_0/carry_sign_probe 5v0_add_q_sc_1/ctrl_sign 0.00205f
C955 VDD_1V65_4 5v0_addh_sc_tile_2/pti 0.00234f
C956 5v0_add_q_sc_0/nti res_c 0
C957 in_2 5v0_addh_sc_tile_0/upstepper_test 0
C958 5v0_addh_sc_tile_2/inv_nti 5v0_addh_sc_tile_2/pti 0.42143f
C959 5v0_addh_sc_tile_0/pti 5v0_addh_sc_tile_0/inv_nti 0.4209f
C960 VDD_3V3_1 5v0_addh_sc_tile_2/ctrl_sign 0.00526f
C961 5v0_addh_sc_tile_1/a_n1373_n454# 5v0_addh_sc_tile_1/upstepper_test 0
C962 5v0_addh_sc_tile_1/5v0_half_adder_selector_sc_0/res_stage0 5v0_addh_sc_tile_1/inv_pti 0.01365f
C963 5v0_addh_sc_tile_2/downstepper_test 5v0_addh_sc_tile_2/a_n1778_n454# 0.0031f
C964 VDD_3V3_1 VDD_1V65_0 0.04264f
C965 VDD_3V3_1 5v0_add_q_sc_1/nti 0.5318f
C966 5v0_add_q_sc_1/nti in_0_over 0.00117f
C967 5v0_add_q_sc_0/downstepper_test VDD_1V65_5 0.13024f
C968 5v0_add_q_sc_1/downstepper_test 5v0_addh_sc_tile_1/ctrl_sign 0.00227f
C969 in_0_over VDD_1V65_0 0.00145f
C970 5v0_addh_sc_tile_2/ctrl_sign 5v0_addh_sc_tile_2/pti 0.28211f
C971 5v0_add_q_sc_1/ctrl_over VDD_3V3_0 0.33124f
C972 5v0_addh_sc_tile_1/pti VDD_1V65_3 0.00234f
C973 5v0_nter2oter_code_sc_0/in 5v0_addh_sc_tile_0/inv_nti 0.00631f
C974 5v0_addh_sc_tile_2/downstepper_test 5v0_addh_sc_tile_2/pti 0.20149f
C975 5v0_add_q_sc_1/nti 5v0_add_q_sc_1/5v0_half_adder_selector_sc_0/m1_n244_n517# 0
C976 VDD_3V3_1 5v0_add_q_sc_1/5v0_half_adder_selector_sc_0/m1_n239_179# 0.29031f
C977 5v0_add_q_sc_0/inv_pti 5v0_add_q_sc_0/ctrl_over 0
C978 5v0_add_q_sc_0/ternary_input 5v0_add_q_sc_0/pti 0.6113f
C979 5v0_addh_sc_tile_1/m1_103_293# 5v0_add_q_sc_1/ternary_input 0
C980 5v0_add_q_sc_1/nti 5v0_add_q_sc_1/a_n1373_n454# 0
C981 5v0_addh_sc_tile_1/pti 5v0_addh_sc_tile_0/pti 0
C982 5v0_add_q_sc_1/5v0_half_adder_selector_sc_0/m1_n239_179# 5v0_add_q_sc_1/5v0_half_adder_selector_sc_0/m1_n244_n517# 0.00585f
C983 5v0_add_q_sc_0/inv_pti 5v0_addh_sc_tile_2/ctrl_over 0
C984 in_0_sign 5v0_addh_sc_tile_1/nti 0
C985 5v0_addh_sc_tile_2/upstepper_test 5v0_addh_sc_tile_2/a_n1373_n454# 0
C986 in_0_sign 5v0_addh_sc_tile_1/ternary_input 0
C987 5v0_addh_sc_tile_1/pti 5v0_add_q_sc_0/ctrl_sign 0
C988 5v0_add_q_sc_1/ctrl_over 5v0_addh_sc_tile_0/carry_0_probe 0
C989 5v0_addh_sc_tile_1/pti 5v0_nter2oter_code_sc_0/in 0
C990 5v0_add_q_sc_1/ctrl_sign 5v0_addh_sc_tile_1/ctrl_sign 0.24986f
C991 5v0_addh_sc_tile_1/5v0_half_adder_selector_sc_0/res_stage0 5v0_addh_sc_tile_1/inv_nti 0.02399f
C992 res_c 5v0_add_q_sc_0/ternary_input 0.167f
C993 5v0_addh_sc_tile_2/upstepper_test 5v0_nter2oter_code_sc_1/nti 0
C994 5v0_nter2oter_code_sc_1/pti 5v0_addh_sc_tile_0/nti 0
C995 5v0_addh_sc_tile_1/a_382_n1095# 5v0_addh_sc_tile_1/pti 0.12627f
C996 5v0_add_q_sc_0/ternary_input 5v0_add_q_sc_1/downstepper_test 0.00477f
C997 5v0_add_q_sc_0/5v0_half_adder_selector_sc_0/m1_n244_n517# 5v0_add_q_sc_0/ctrl_over 0.35346f
C998 5v0_addh_sc_tile_0/downstepper_test VDD_3V3_0 0
C999 in_1 5v0_addh_sc_tile_0/m1_103_293# 0
C1000 5v0_nter2oter_code_sc_0/gf180mcu_fd_sc_mcu7t5v0__nor2_1_0/a_224_472# 5v0_nter2oter_code_sc_0/nti 0.00842f
C1001 5v0_add_q_sc_0/5v0_half_adder_selector_sc_0/m1_n244_n517# 5v0_addh_sc_tile_2/ctrl_over 0.00443f
C1002 5v0_add_q_sc_0/inv_pti VDD_3V3_0 0.40694f
C1003 5v0_addh_sc_tile_1/pti 5v0_addh_sc_tile_2/inv_pti 0
C1004 5v0_addh_sc_tile_1/nti 5v0_addh_sc_tile_0/m1_843_n857# 0
C1005 5v0_addh_sc_tile_0/carry_sign_probe 5v0_add_q_sc_1/pti 0
C1006 5v0_addh_sc_tile_2/upstepper_test 5v0_addh_sc_tile_2/a_n1778_n454# 0
C1007 5v0_addh_sc_tile_1/inv_pti 5v0_addh_sc_tile_2/a_382_n1095# 0
C1008 5v0_addh_sc_tile_1/ternary_input 5v0_addh_sc_tile_0/m1_843_n857# 0
C1009 5v0_addh_sc_tile_0/m1_103_293# 5v0_addh_sc_tile_0/pti 0.10002f
C1010 5v0_addh_sc_tile_2/a_382_n1095# 5v0_add_q_sc_0/upstepper_test 0
C1011 5v0_addh_sc_tile_2/ctrl_sign 5v0_nter2oter_code_sc_0/gf180mcu_fd_sc_mcu7t5v0__nor2_1_0/a_224_472# 0
C1012 5v0_addh_sc_tile_2/nti 5v0_nter2oter_code_sc_0/pti 0
C1013 5v0_addh_sc_tile_2/upstepper_test 5v0_addh_sc_tile_2/pti 0.02426f
C1014 5v0_add_q_sc_0/inv_nti VDD_1V65_5 0.01114f
C1015 5v0_add_q_sc_0/ctrl_over 5v0_addh_sc_tile_2/m1_843_n857# 0.17868f
C1016 5v0_addh_sc_tile_0/upstepper_test 5v0_addh_sc_tile_0/5v0_half_adder_selector_sc_0/res_stage0 0.27475f
C1017 5v0_add_q_sc_0/ternary_input 5v0_add_q_sc_1/ctrl_sign 0.00413f
C1018 in_0_sign m1_n2844_n810# 0.0018f
C1019 5v0_addh_sc_tile_1/m1_103_293# 5v0_add_q_sc_1/ctrl_over 0.01922f
C1020 in_1 5v0_addh_sc_tile_0/nti 0.52138f
C1021 5v0_addh_sc_tile_1/inv_pti 5v0_addh_sc_tile_1/ctrl_over 0.0052f
C1022 5v0_addh_sc_tile_1/m1_843_n857# 5v0_addh_sc_tile_1/ctrl_over 0.10251f
C1023 5v0_addh_sc_tile_0/a_382_n1095# 5v0_addh_sc_tile_0/5v0_half_adder_selector_sc_0/res_stage0 0.08951f
C1024 5v0_addh_sc_tile_2/m1_843_n857# 5v0_addh_sc_tile_2/ctrl_over 0.10619f
C1025 5v0_add_q_sc_1/nti 5v0_add_q_sc_1/a_n1778_n454# 0
C1026 5v0_addh_sc_tile_1/ctrl_over 5v0_add_q_sc_0/upstepper_test 0.00229f
C1027 5v0_add_q_sc_0/ctrl_over 5v0_addh_sc_tile_1/ternary_input 0
C1028 5v0_add_q_sc_0/5v0_half_adder_selector_sc_0/m1_n244_n517# VDD_3V3_0 0.29978f
C1029 5v0_addh_sc_tile_1/nti 5v0_addh_sc_tile_2/ctrl_over 0.00207f
C1030 5v0_nter2oter_code_sc_1/pti 5v0_addh_sc_tile_0/pti 0
C1031 in_3 5v0_nter2oter_code_sc_0/nti 0.00248f
C1032 5v0_addh_sc_tile_1/ternary_input 5v0_addh_sc_tile_2/ctrl_over 0.00181f
C1033 5v0_addh_sc_tile_0/pti 5v0_addh_sc_tile_0/nti 0.24563f
C1034 5v0_add_q_sc_1/pti 5v0_addh_sc_tile_1/ctrl_sign 0
C1035 VDD_1V65_4 in_3 0.01451f
C1036 5v0_addh_sc_tile_0/inv_pti 5v0_addh_sc_tile_0/inv_nti 0.25737f
C1037 VDD_3V3_1 5v0_addh_sc_tile_0/carry_sign_probe 0.17781f
C1038 5v0_addh_sc_tile_2/inv_nti in_3 0.28245f
C1039 5v0_nter2oter_code_sc_1/pti 5v0_nter2oter_code_sc_0/in 0.00485f
C1040 5v0_addh_sc_tile_0/carry_sign_probe in_0_over 0.00413f
C1041 5v0_addh_sc_tile_0/upstepper_test 5v0_addh_sc_tile_0/downstepper_test 0.38867f
C1042 m1_n2844_n810# 5v0_addh_sc_tile_0/m1_843_n857# 0.00191f
C1043 5v0_addh_sc_tile_2/inv_nti 5v0_addh_sc_tile_2/a_382_n1095# 0.28654f
C1044 5v0_addh_sc_tile_0/nti 5v0_nter2oter_code_sc_0/in 0.0033f
C1045 5v0_addh_sc_tile_0/a_382_n1095# 5v0_addh_sc_tile_0/downstepper_test 0.00679f
C1046 5v0_add_q_sc_1/ctrl_sign 5v0_add_q_sc_1/downstepper_test 0.25694f
C1047 in_3 5v0_addh_sc_tile_2/ctrl_sign 0.0062f
C1048 5v0_add_q_sc_0/a_n1373_n454# VDD_1V65_5 0.00232f
C1049 5v0_addh_sc_tile_1/ctrl_over 5v0_nter2oter_code_sc_0/nti 0
C1050 5v0_addh_sc_tile_1/ctrl_over 5v0_addh_sc_tile_1/inv_nti 0.47006f
C1051 5v0_addh_sc_tile_2/m1_843_n857# VDD_3V3_0 0.17677f
C1052 in_3 5v0_addh_sc_tile_2/downstepper_test 0.18203f
C1053 5v0_addh_sc_tile_2/a_382_n1095# 5v0_addh_sc_tile_2/ctrl_sign 0.07412f
C1054 5v0_nter2oter_code_sc_1/nti 5v0_addh_sc_tile_1/ctrl_sign 0.13214f
C1055 in_1 5v0_addh_sc_tile_0/pti 0.66373f
C1056 5v0_addh_sc_tile_2/inv_nti 5v0_addh_sc_tile_1/ctrl_over 0
C1057 in_0_sign 5v0_addh_sc_tile_1/inv_pti 0.00171f
C1058 5v0_addh_sc_tile_2/a_382_n1095# 5v0_addh_sc_tile_2/downstepper_test 0.00679f
C1059 VDD_3V3_0 5v0_addh_sc_tile_1/nti 0.44319f
C1060 5v0_add_q_sc_1/5v0_half_adder_selector_sc_0/res_stage0 5v0_add_q_sc_0/ternary_input 0.17113f
C1061 in_2 5v0_addh_sc_tile_0/inv_nti 0.0153f
C1062 5v0_addh_sc_tile_1/ternary_input VDD_3V3_0 0.0901f
C1063 5v0_addh_sc_tile_1/ctrl_over 5v0_addh_sc_tile_2/ctrl_sign 0.019f
C1064 5v0_addh_sc_tile_1/pti 5v0_addh_sc_tile_1/downstepper_test 0.19626f
C1065 5v0_add_q_sc_0/ctrl_sign 5v0_add_q_sc_0/downstepper_test 0.14564f
C1066 5v0_add_q_sc_1/nti 5v0_addh_sc_tile_1/ctrl_over 0
C1067 in_1 5v0_nter2oter_code_sc_0/in 0.00145f
C1068 5v0_addh_sc_tile_1/a_n1778_n454# 5v0_addh_sc_tile_1/upstepper_test 0
C1069 5v0_addh_sc_tile_1/ctrl_over VDD_1V65_0 0
C1070 5v0_add_q_sc_1/ternary_input 5v0_addh_sc_tile_0/inv_nti 0.001f
C1071 5v0_add_q_sc_0/inv_pti 5v0_add_q_sc_0/5v0_half_adder_selector_sc_0/m1_n239_179# 0
C1072 5v0_addh_sc_tile_0/a_n1205_n937# VDD_1V65_0 0.00354f
C1073 VDD_3V3_1 5v0_addh_sc_tile_1/ctrl_sign 0.87932f
C1074 5v0_nter2oter_code_sc_0/in 5v0_nter2oter_code_sc_1/gf180mcu_fd_sc_mcu7t5v0__nor2_1_0/a_224_472# 0
C1075 5v0_add_q_sc_1/inv_nti m1_n2844_n810# 0.00427f
C1076 5v0_addh_sc_tile_1/pti 5v0_addh_sc_tile_1/a_n1373_n454# 0
C1077 in_0_over 5v0_addh_sc_tile_1/ctrl_sign 0.03467f
C1078 5v0_addh_sc_tile_2/5v0_half_adder_selector_sc_0/res_stage0 5v0_addh_sc_tile_2/pti 0.00979f
C1079 5v0_addh_sc_tile_1/ctrl_sign 5v0_addh_sc_tile_2/pti 0.00148f
C1080 5v0_addh_sc_tile_1/a_382_n1095# 5v0_add_q_sc_0/downstepper_test 0.00203f
C1081 5v0_add_q_sc_0/downstepper_test 5v0_add_q_sc_0/5v0_half_adder_selector_sc_0/res_stage0 0.25483f
C1082 5v0_addh_sc_tile_0/carry_0_probe 5v0_addh_sc_tile_1/nti 0.013f
C1083 5v0_addh_sc_tile_0/carry_0_probe 5v0_addh_sc_tile_1/ternary_input 0.00236f
C1084 5v0_addh_sc_tile_1/inv_pti 5v0_addh_sc_tile_0/m1_843_n857# 0.00739f
C1085 5v0_add_q_sc_1/5v0_half_adder_selector_sc_0/res_stage0 5v0_add_q_sc_1/downstepper_test 0.25483f
C1086 5v0_add_q_sc_0/ctrl_sign 5v0_nter2oter_code_sc_0/in 0.01026f
C1087 5v0_addh_sc_tile_0/inv_nti 5v0_nter2oter_code_sc_0/pti 0.00589f
C1088 5v0_add_q_sc_1/a_n1205_n937# 5v0_add_q_sc_1/ternary_input 0
C1089 5v0_addh_sc_tile_2/inv_pti 5v0_nter2oter_code_sc_1/gf180mcu_fd_sc_mcu7t5v0__nor2_1_0/a_224_472# 0
C1090 5v0_add_q_sc_0/5v0_half_adder_selector_sc_0/m1_n244_n517# 5v0_add_q_sc_0/5v0_half_adder_selector_sc_0/m1_n239_179# 0.00585f
C1091 5v0_addh_sc_tile_0/a_n1373_n454# VDD_1V65_0 0.00232f
C1092 5v0_addh_sc_tile_0/inv_pti 5v0_addh_sc_tile_0/m1_103_293# 0.17653f
C1093 5v0_add_q_sc_0/downstepper_test 5v0_add_q_sc_0/inv_nti 0.1819f
C1094 5v0_addh_sc_tile_0/pti VDD_1V65_2 0
C1095 5v0_add_q_sc_1/pti 5v0_add_q_sc_1/downstepper_test 0.08084f
C1096 5v0_addh_sc_tile_1/a_382_n1095# 5v0_add_q_sc_0/ctrl_sign 0.0169f
C1097 5v0_addh_sc_tile_2/upstepper_test in_3 0.01604f
C1098 VDD_3V3_1 5v0_add_q_sc_0/ternary_input 0.20806f
C1099 5v0_addh_sc_tile_1/a_382_n1095# 5v0_nter2oter_code_sc_0/in 0.16245f
C1100 5v0_add_q_sc_0/ctrl_sign 5v0_add_q_sc_0/5v0_half_adder_selector_sc_0/res_stage0 0.22359f
C1101 in_0_sign 5v0_add_q_sc_1/nti 0
C1102 5v0_add_q_sc_0/ternary_input 5v0_addh_sc_tile_2/pti 0.00188f
C1103 5v0_add_q_sc_0/ctrl_over 5v0_add_q_sc_0/upstepper_test 0.00167f
C1104 5v0_addh_sc_tile_1/inv_pti 5v0_addh_sc_tile_2/ctrl_over 0
C1105 5v0_addh_sc_tile_0/a_382_n1095# 5v0_addh_sc_tile_1/nti 0.01157f
C1106 5v0_addh_sc_tile_1/pti 5v0_addh_sc_tile_2/m1_103_293# 0
C1107 5v0_addh_sc_tile_1/inv_pti 5v0_add_q_sc_1/inv_nti 0.00455f
C1108 5v0_add_q_sc_0/ternary_input 5v0_add_q_sc_1/5v0_half_adder_selector_sc_0/m1_n244_n517# 0.16119f
C1109 5v0_addh_sc_tile_0/a_382_n1095# 5v0_addh_sc_tile_1/ternary_input 0.17536f
C1110 5v0_add_q_sc_1/5v0_half_adder_selector_sc_0/res_stage0 5v0_add_q_sc_1/ctrl_sign 0.22434f
C1111 5v0_addh_sc_tile_1/a_382_n1095# 5v0_add_q_sc_0/5v0_half_adder_selector_sc_0/res_stage0 0.00175f
C1112 5v0_add_q_sc_0/ctrl_sign 5v0_addh_sc_tile_2/inv_pti 0.10221f
C1113 5v0_addh_sc_tile_2/ctrl_over 5v0_add_q_sc_0/upstepper_test 0.00252f
C1114 5v0_addh_sc_tile_0/inv_pti 5v0_nter2oter_code_sc_1/pti 0
C1115 5v0_add_q_sc_1/inv_pti 5v0_add_q_sc_1/downstepper_test 0.07669f
C1116 5v0_addh_sc_tile_2/inv_pti 5v0_nter2oter_code_sc_0/in 0.00498f
C1117 5v0_addh_sc_tile_1/5v0_half_adder_selector_sc_0/res_stage0 5v0_addh_sc_tile_1/ctrl_sign 0.22639f
C1118 5v0_add_q_sc_1/nti 5v0_add_q_sc_1/VDD_1V65 0.21326f
C1119 5v0_addh_sc_tile_1/nti 5v0_addh_sc_tile_1/upstepper_test 0.11981f
C1120 5v0_addh_sc_tile_2/upstepper_test 5v0_addh_sc_tile_1/ctrl_over 0
C1121 5v0_addh_sc_tile_1/ctrl_sign 5v0_addh_sc_tile_1/5v0_half_adder_selector_sc_0/5v0_tgate_sel_2_sc_1/input_A 0
C1122 5v0_addh_sc_tile_0/inv_pti 5v0_addh_sc_tile_0/nti 0.24025f
C1123 5v0_addh_sc_tile_1/m1_103_293# 5v0_addh_sc_tile_1/ternary_input 0
C1124 5v0_addh_sc_tile_1/ternary_input 5v0_addh_sc_tile_1/upstepper_test 0.01604f
C1125 5v0_addh_sc_tile_0/carry_0_probe m1_n2844_n810# 0.42968f
C1126 5v0_add_q_sc_1/pti 5v0_add_q_sc_1/ctrl_sign 0.15254f
C1127 5v0_addh_sc_tile_0/5v0_half_adder_selector_sc_0/res_stage0 5v0_addh_sc_tile_0/inv_nti 0.02878f
C1128 5v0_add_q_sc_0/5v0_half_adder_selector_sc_0/m1_n239_179# 5v0_addh_sc_tile_1/ternary_input 0
C1129 5v0_addh_sc_tile_0/m1_103_293# 5v0_add_q_sc_1/ternary_input 0
C1130 VDD_3V3_1 5v0_add_q_sc_1/downstepper_test 0.52531f
C1131 5v0_add_q_sc_0/downstepper_test 5v0_add_q_sc_0/a_n1373_n454# 0.00442f
C1132 res_c 5v0_addh_sc_tile_2/pti 0
C1133 in_0_over 5v0_add_q_sc_1/downstepper_test 0
C1134 5v0_addh_sc_tile_1/pti 5v0_add_q_sc_1/ctrl_over 0.16959f
C1135 5v0_addh_sc_tile_1/a_n1205_n937# VDD_1V65_3 0.00354f
C1136 in_2 5v0_nter2oter_code_sc_1/pti 0.46231f
C1137 5v0_addh_sc_tile_1/inv_pti VDD_3V3_0 0.1766f
C1138 5v0_addh_sc_tile_1/m1_843_n857# VDD_3V3_0 0.20528f
C1139 5v0_addh_sc_tile_2/ctrl_over 5v0_nter2oter_code_sc_0/nti 0.22761f
C1140 5v0_addh_sc_tile_1/inv_nti 5v0_addh_sc_tile_2/ctrl_over 0.00155f
C1141 5v0_add_q_sc_1/ctrl_over 5v0_add_q_sc_1/a_n1205_n937# 0
C1142 5v0_addh_sc_tile_2/inv_nti 5v0_add_q_sc_0/ctrl_over 0.01791f
C1143 5v0_add_q_sc_1/inv_pti 5v0_add_q_sc_1/ctrl_sign 0.05919f
C1144 5v0_add_q_sc_1/5v0_half_adder_selector_sc_0/m1_n244_n517# 5v0_add_q_sc_1/downstepper_test 0.00507f
C1145 5v0_add_q_sc_1/inv_nti 5v0_addh_sc_tile_1/inv_nti 0
C1146 in_1 5v0_addh_sc_tile_0/inv_pti 0.05631f
C1147 in_2 5v0_addh_sc_tile_0/nti 0.0018f
C1148 VDD_3V3_0 5v0_add_q_sc_0/upstepper_test 0.55779f
C1149 VDD_1V65_4 5v0_addh_sc_tile_2/ctrl_over 0.00145f
C1150 5v0_add_q_sc_1/a_n1373_n454# 5v0_add_q_sc_1/downstepper_test 0.00442f
C1151 5v0_addh_sc_tile_2/inv_nti 5v0_addh_sc_tile_2/ctrl_over 0.26006f
C1152 5v0_add_q_sc_0/ctrl_over 5v0_addh_sc_tile_2/ctrl_sign 0.00758f
C1153 5v0_addh_sc_tile_0/a_382_n1095# m1_n2844_n810# 0.04011f
C1154 5v0_addh_sc_tile_0/downstepper_test 5v0_addh_sc_tile_0/inv_nti 0.29989f
C1155 5v0_addh_sc_tile_2/ctrl_sign 5v0_addh_sc_tile_2/ctrl_over 0.63344f
C1156 5v0_addh_sc_tile_1/downstepper_test 5v0_nter2oter_code_sc_1/gf180mcu_fd_sc_mcu7t5v0__nor2_1_0/a_224_472# 0
C1157 5v0_addh_sc_tile_1/downstepper_test VDD_1V65_3 0.13024f
C1158 VDD_3V3_1 5v0_add_q_sc_1/ctrl_sign 1.0828f
C1159 5v0_addh_sc_tile_1/m1_103_293# m1_n2844_n810# 0
C1160 5v0_addh_sc_tile_0/inv_pti 5v0_addh_sc_tile_0/pti 0.44081f
C1161 5v0_add_q_sc_1/nti 5v0_add_q_sc_1/inv_nti 0.20056f
C1162 in_0_over 5v0_add_q_sc_1/ctrl_sign 0.00327f
C1163 m1_n2844_n810# 5v0_addh_sc_tile_1/upstepper_test 0.00447f
C1164 5v0_addh_sc_tile_2/5v0_half_adder_selector_sc_0/res_stage0 in_3 0.26626f
C1165 5v0_addh_sc_tile_2/downstepper_test 5v0_addh_sc_tile_2/ctrl_over 0.02378f
C1166 5v0_addh_sc_tile_1/inv_pti 5v0_addh_sc_tile_0/carry_0_probe 0.01474f
C1167 5v0_add_q_sc_0/a_n1205_n937# VDD_3V3_0 0.00891f
C1168 VDD_1V65_2 VSS_3 0.07318f
C1169 5v0_addh_sc_tile_2/pti VSS_3 1.17571f
C1170 VDD_1V65_4 VSS_3 0.09068f
C1171 5v0_addh_sc_tile_2/inv_nti VSS_3 1.3751f
C1172 5v0_addh_sc_tile_2/m1_843_n857# VSS_3 0.16265f ; **FLOATING
C1173 5v0_addh_sc_tile_2/ctrl_sign VSS_3 1.27243f
C1174 5v0_addh_sc_tile_2/a_n1205_n937# VSS_3 0 ; **FLOATING
C1175 5v0_addh_sc_tile_2/a_n1373_n454# VSS_3 0.00335f ; **FLOATING
C1176 5v0_addh_sc_tile_2/a_n1778_n454# VSS_3 0.00573f ; **FLOATING
C1177 5v0_addh_sc_tile_2/inv_pti VSS_3 0.92511f
C1178 5v0_addh_sc_tile_2/5v0_half_adder_selector_sc_0/5v0_tgate_sel_2_sc_1/input_A VSS_3 0
C1179 5v0_addh_sc_tile_2/a_382_n1095# VSS_3 0.83941f ; **FLOATING
C1180 in_3 VSS_3 1.64882f
C1181 res_0 VSS_3 0.02768f
C1182 5v0_addh_sc_tile_2/ctrl_over VSS_3 0.80165f
C1183 5v0_addh_sc_tile_2/m1_103_293# VSS_3 0.74864f ; **FLOATING
C1184 5v0_addh_sc_tile_2/5v0_half_adder_selector_sc_0/res_stage0 VSS_3 0.50069f
C1185 5v0_addh_sc_tile_2/downstepper_test VSS_3 0.58281f
C1186 5v0_addh_sc_tile_2/upstepper_test VSS_3 0.53687f
C1187 5v0_addh_sc_tile_2/nti VSS_3 1.2554f
C1188 5v0_addh_sc_tile_1/pti VSS_3 1.17421f
C1189 VDD_1V65_3 VSS_3 0.09068f
C1190 5v0_addh_sc_tile_1/inv_nti VSS_3 1.35629f
C1191 5v0_addh_sc_tile_1/m1_843_n857# VSS_3 0.15965f ; **FLOATING
C1192 5v0_addh_sc_tile_1/ctrl_sign VSS_3 1.30778f
C1193 5v0_addh_sc_tile_1/a_n1205_n937# VSS_3 0 ; **FLOATING
C1194 5v0_addh_sc_tile_1/a_n1373_n454# VSS_3 0.00335f ; **FLOATING
C1195 5v0_addh_sc_tile_1/a_n1778_n454# VSS_3 0.00573f ; **FLOATING
C1196 5v0_addh_sc_tile_1/inv_pti VSS_3 0.92626f
C1197 VDD_3V3_1 VSS_3 39.17125f
C1198 5v0_addh_sc_tile_1/5v0_half_adder_selector_sc_0/5v0_tgate_sel_2_sc_1/input_A VSS_3 0
C1199 5v0_addh_sc_tile_1/a_382_n1095# VSS_3 0.81445f ; **FLOATING
C1200 5v0_addh_sc_tile_1/ternary_input VSS_3 1.54805f
C1201 5v0_nter2oter_code_sc_0/in VSS_3 1.10181f
C1202 5v0_addh_sc_tile_1/ctrl_over VSS_3 0.79116f
C1203 5v0_addh_sc_tile_1/m1_103_293# VSS_3 0.74864f ; **FLOATING
C1204 5v0_addh_sc_tile_1/5v0_half_adder_selector_sc_0/res_stage0 VSS_3 0.50069f
C1205 5v0_addh_sc_tile_1/downstepper_test VSS_3 0.58281f
C1206 5v0_addh_sc_tile_1/upstepper_test VSS_3 0.53687f
C1207 5v0_addh_sc_tile_1/nti VSS_3 1.26884f
C1208 5v0_addh_sc_tile_0/pti VSS_3 1.1792f
C1209 VDD_1V65_0 VSS_3 0.09068f
C1210 5v0_addh_sc_tile_0/inv_nti VSS_3 1.36049f
C1211 5v0_addh_sc_tile_0/m1_843_n857# VSS_3 0.15969f ; **FLOATING
C1212 in_0_sign VSS_3 0.8701f
C1213 5v0_addh_sc_tile_0/a_n1205_n937# VSS_3 0 ; **FLOATING
C1214 5v0_addh_sc_tile_0/a_n1373_n454# VSS_3 0.00335f ; **FLOATING
C1215 5v0_addh_sc_tile_0/a_n1778_n454# VSS_3 0.00573f ; **FLOATING
C1216 5v0_addh_sc_tile_0/inv_pti VSS_3 0.92409f
C1217 5v0_addh_sc_tile_0/carry_sign_probe VSS_3 0.24862f
C1218 5v0_addh_sc_tile_0/carry_0_probe VSS_3 0.59349f
C1219 5v0_addh_sc_tile_0/5v0_half_adder_selector_sc_0/5v0_tgate_sel_2_sc_1/input_A VSS_3 0
C1220 5v0_addh_sc_tile_0/a_382_n1095# VSS_3 0.81488f ; **FLOATING
C1221 in_1 VSS_3 1.70172f
C1222 in_0_over VSS_3 0.49348f
C1223 5v0_addh_sc_tile_0/m1_103_293# VSS_3 0.74828f ; **FLOATING
C1224 5v0_addh_sc_tile_0/5v0_half_adder_selector_sc_0/res_stage0 VSS_3 0.50069f
C1225 5v0_addh_sc_tile_0/downstepper_test VSS_3 0.58464f
C1226 5v0_addh_sc_tile_0/upstepper_test VSS_3 0.53687f
C1227 5v0_addh_sc_tile_0/nti VSS_3 1.25562f
C1228 in_2 VSS_3 0.95085f
C1229 5v0_nter2oter_code_sc_1/pti VSS_3 0.62525f
C1230 5v0_nter2oter_code_sc_1/nti VSS_3 0.65963f
C1231 5v0_nter2oter_code_sc_1/gf180mcu_fd_sc_mcu7t5v0__nor2_1_0/a_224_472# VSS_3 0 ; **FLOATING
C1232 5v0_add_q_sc_1/pti VSS_3 0.59914f
C1233 5v0_add_q_sc_1/VDD_1V65 VSS_3 0.25926f
C1234 5v0_add_q_sc_1/inv_nti VSS_3 0.53672f
C1235 5v0_add_q_sc_1/inv_pti VSS_3 0.64307f
C1236 5v0_add_q_sc_1/a_n1205_n937# VSS_3 0.0038f ; **FLOATING
C1237 5v0_add_q_sc_1/a_n1373_n454# VSS_3 0.00345f ; **FLOATING
C1238 5v0_add_q_sc_1/a_n1778_n454# VSS_3 0.00577f ; **FLOATING
C1239 5v0_add_q_sc_1/5v0_half_adder_selector_sc_0/5v0_tgate_sel_2_sc_1/input_A VSS_3 0
C1240 5v0_add_q_sc_1/5v0_half_adder_selector_sc_0/m1_n244_n517# VSS_3 0.29628f ; **FLOATING
C1241 5v0_add_q_sc_1/ternary_input VSS_3 1.9522f
C1242 5v0_add_q_sc_1/ctrl_over VSS_3 0.98262f
C1243 5v0_add_q_sc_1/5v0_half_adder_selector_sc_0/m1_n239_179# VSS_3 0.37403f ; **FLOATING
C1244 5v0_add_q_sc_1/5v0_half_adder_selector_sc_0/res_stage0 VSS_3 0.78312f
C1245 5v0_add_q_sc_1/downstepper_test VSS_3 1.03196f
C1246 5v0_add_q_sc_1/ctrl_sign VSS_3 1.15654f
C1247 5v0_add_q_sc_1/nti VSS_3 1.38585f
C1248 5v0_nter2oter_code_sc_0/pti VSS_3 0.61125f
C1249 5v0_nter2oter_code_sc_0/nti VSS_3 0.66288f
C1250 5v0_nter2oter_code_sc_0/gf180mcu_fd_sc_mcu7t5v0__nor2_1_0/a_224_472# VSS_3 0 ; **FLOATING
C1251 5v0_add_q_sc_0/pti VSS_3 0.59945f
C1252 VDD_1V65_5 VSS_3 0.09068f
C1253 5v0_add_q_sc_0/inv_nti VSS_3 0.53562f
C1254 5v0_add_q_sc_0/inv_pti VSS_3 0.59603f
C1255 5v0_add_q_sc_0/a_n1205_n937# VSS_3 0 ; **FLOATING
C1256 5v0_add_q_sc_0/a_n1373_n454# VSS_3 0.00335f ; **FLOATING
C1257 5v0_add_q_sc_0/a_n1778_n454# VSS_3 0.00573f ; **FLOATING
C1258 5v0_add_q_sc_0/5v0_half_adder_selector_sc_0/5v0_tgate_sel_2_sc_1/input_A VSS_3 0
C1259 5v0_add_q_sc_0/5v0_half_adder_selector_sc_0/m1_n244_n517# VSS_3 0.29628f ; **FLOATING
C1260 5v0_add_q_sc_0/ternary_input VSS_3 2.49693f
C1261 res_c VSS_3 0.0293f
C1262 5v0_add_q_sc_0/ctrl_over VSS_3 0.76005f
C1263 5v0_add_q_sc_0/5v0_half_adder_selector_sc_0/m1_n239_179# VSS_3 0.29907f ; **FLOATING
C1264 5v0_add_q_sc_0/5v0_half_adder_selector_sc_0/res_stage0 VSS_3 0.50905f
C1265 5v0_add_q_sc_0/downstepper_test VSS_3 0.64239f
C1266 5v0_add_q_sc_0/ctrl_sign VSS_3 0.4943f
C1267 VDD_3V3_0 VSS_3 47.3242f
C1268 5v0_add_q_sc_0/upstepper_test VSS_3 0.54953f
C1269 5v0_add_q_sc_0/nti VSS_3 1.27003f
C1270 m1_n2844_n810# VSS_3 0.41232f ; **FLOATING
