* NGSPICE file created from 5v0_nti.ext - technology: gf180mcuD

.option scale=5n

X0 Y A VDD_1V65 VSS nfet_06v0 ad=14.432n pd=0.504m as=14.432n ps=0.504m w=164 l=120
X1 Z A w_n591_352# w_n591_352# pfet_06v0 ad=21.472n pd=0.664m as=21.472n ps=0.664m w=244 l=100
C0 A Y 0.05107f
C1 Z VDD_1V65 0
C2 w_n591_352# VDD_1V65 0.07528f
C3 w_n591_352# Z 0.23725f
C4 Y VDD_1V65 0.11574f
C5 A VDD_1V65 0.05369f
C6 Z Y 0.0191f
C7 w_n591_352# Y 0.00112f
C8 A Z 0.0499f
C9 A w_n591_352# 0.21437f
C10 Y VSS 0.02579f
C11 VDD_1V65 VSS 0.65422f
C12 Z VSS 0.00447f
C13 A VSS 0.21846f
C14 w_n591_352# VSS 2.55334f ; **FLOATING
