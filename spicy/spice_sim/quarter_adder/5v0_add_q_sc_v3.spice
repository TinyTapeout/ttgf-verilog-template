* NGSPICE file created from 5v0_add_q_sc.ext - technology: gf180mcuD

.option scale=5n

X0 m1_n1654_59# ternary_input VSS VSS nfet_06v0 ad=6.336n pd=0.32m as=6.336n ps=0.32m w=72 l=578
X1 VDD_3V3_uq0 ternary_input m1_n1654_59# VDD_3V3_uq0 pfet_06v0 ad=12.81n pd=0.349m as=12.688n ps=0.348m w=244 l=100
X2 m1_n1654_59# ternary_input VDD_3V3_uq0 VDD_3V3_uq0 pfet_06v0 ad=12.688n pd=0.348m as=21.472n ps=0.664m w=244 l=100
X3 m1_n1654_59# ternary_input VDD_3V3_uq0 VDD_3V3_uq0 pfet_06v0 ad=27.328n pd=0.712m as=12.81n ps=0.349m w=244 l=100
X4 5v0_nti_sc_f_0/ternary_output ternary_input VSS VSS nfet_06v0 ad=12.7n pd=0.454m as=11.303n ps=0.432m w=127 l=120
X5 5v0_nti_sc_f_0/ternary_output ternary_input VDD_3V3_uq0 VDD_3V3_uq0 pfet_06v0 ad=9.696n pd=0.394m as=8.928n ps=0.378m w=96 l=150
X6 5v0_half_adder_selector_sc_0/m1_n9_n292# 5v0_half_adder_selector_sc_0/m1_n239_179# downstepper_test VSS nfet_06v0 ad=14.432n pd=0.504m as=14.432n ps=0.504m w=164 l=120
X7 5v0_half_adder_selector_sc_0/m1_n9_n292# 5v0_half_adder_selector_sc_0/m1_n239_179# upstepper_test VDD_3V3_uq0 pfet_06v0 ad=21.472n pd=0.664m as=21.472n ps=0.664m w=244 l=100
X8 5v0_half_adder_selector_sc_0/m1_n239_179# ctrl_sign VSS VSS nfet_06v0 ad=14.432n pd=0.504m as=14.432n ps=0.504m w=164 l=120
X9 5v0_half_adder_selector_sc_0/m1_n239_179# ctrl_sign VDD_3V3_uq0 VDD_3V3_uq0 pfet_06v0 ad=21.472n pd=0.664m as=21.472n ps=0.664m w=244 l=100
X10 5v0_half_adder_selector_sc_0/m1_n9_n292# ctrl_sign upstepper_test VSS nfet_06v0 ad=31.489n pd=1.041m as=43.711n ps=1.504m w=164 l=120
X11 5v0_half_adder_selector_sc_0/m1_n9_n292# ctrl_sign downstepper_test VDD_3V3_uq0 pfet_06v0 ad=46.849n pd=1.361m as=42.856n ps=1.326m w=244 l=100
X12 ternary_output 5v0_half_adder_selector_sc_0/m1_n437_n664# 5v0_half_adder_selector_sc_0/m1_n9_n292# VSS nfet_06v0 ad=17.057n pd=0.537m as=0 ps=0 w=164 l=120
X13 ternary_output 5v0_half_adder_selector_sc_0/m1_n437_n664# 5v0_half_adder_selector_sc_0/m1_n10_n948# VDD_3V3 pfet_06v0 ad=25.377n pd=0.697m as=21.472n ps=0.664m w=244 l=100
X14 5v0_half_adder_selector_sc_0/m1_n244_n517# 5v0_half_adder_selector_sc_0/m1_n437_n664# VSS VSS nfet_06v0 ad=14.432n pd=0.504m as=0.10465u ps=3.768m w=164 l=120
X15 5v0_half_adder_selector_sc_0/m1_n244_n517# 5v0_half_adder_selector_sc_0/m1_n437_n664# VDD_3V3 VDD_3V3 pfet_06v0 ad=21.472n pd=0.664m as=85.71201n ps=2.652m w=244 l=100
X16 ternary_output 5v0_half_adder_selector_sc_0/m1_n244_n517# 5v0_half_adder_selector_sc_0/m1_n10_n948# VSS nfet_06v0 ad=0 pd=0 as=14.432n ps=0.504m w=164 l=120
X17 ternary_output 5v0_half_adder_selector_sc_0/m1_n244_n517# 5v0_half_adder_selector_sc_0/m1_n9_n292# VDD_3V3 pfet_06v0 ad=0 pd=0 as=0 ps=0 w=244 l=100
X18 a_n1325_n547# m1_n1654_59# VSS VSS nfet_06v0 ad=14.432n pd=0.504m as=14.432n ps=0.504m w=164 l=120
X19 a_n1325_n547# m1_n1654_59# VDD_3V3_uq0 VDD_3V3_uq0 pfet_06v0 ad=21.472n pd=0.664m as=21.472n ps=0.664m w=244 l=100
X20 a_n1898_n981# 5v0_nti_sc_f_0/ternary_output VSS VSS nfet_06v0 ad=14.432n pd=0.504m as=0 ps=0 w=164 l=120
X21 a_n1898_n981# 5v0_nti_sc_f_0/ternary_output VDD_3V3 VDD_3V3 pfet_06v0 ad=21.472n pd=0.664m as=0 ps=0 w=244 l=100
X22 a_n1373_n454# a_n1898_n981# downstepper_test VSS nfet_06v0 ad=3.528n pd=0.195m as=8.599n ps=0.264m w=147 l=120
X23 upstepper_test 5v0_nti_sc_f_0/ternary_output a_n1205_n937# VDD_3V3 pfet_06v0 ad=21.384n pd=0.662m as=5.832n ps=0.291m w=243 l=100
X24 upstepper_test 5v0_nti_sc_f_0/ternary_output VDD_1V65 VSS nfet_06v0 ad=14.847n pd=0.496m as=10.51n ps=0.29m w=147 l=120
X25 a_n1205_n937# a_n1325_n547# VDD_3V3 VDD_3V3 pfet_06v0 ad=5.832n pd=0.291m as=21.384n ps=0.662m w=243 l=100
X26 downstepper_test m1_n1654_59# a_n1778_n454# VSS nfet_06v0 ad=8.599n pd=0.264m as=3.528n ps=0.195m w=147 l=120
X27 a_n1778_n454# a_n1898_n981# VSS VSS nfet_06v0 ad=3.528n pd=0.195m as=14.847n ps=0.496m w=147 l=120
X28 upstepper_test a_n1325_n547# VSS VSS nfet_06v0 ad=14.432n pd=0.504m as=14.432n ps=0.504m w=164 l=120
X29 VDD_1V65 a_n1325_n547# a_n1373_n454# VSS nfet_06v0 ad=10.51n pd=0.29m as=3.528n ps=0.195m w=147 l=120
X30 downstepper_test a_n1898_n981# VDD_3V3 VDD_3V3 pfet_06v0 ad=21.384n pd=0.662m as=21.384n ps=0.662m w=243 l=100
C0 VDD_3V3_uq0 VDD_3V3 0
C1 m1_n1654_59# upstepper_test 0
C2 m1_n1654_59# 5v0_half_adder_selector_sc_0/m1_n244_n517# 0
C3 ternary_input VDD_3V3 0.15502f
C4 5v0_half_adder_selector_sc_0/m1_n437_n664# VDD_3V3_uq0 0.0015f
C5 downstepper_test m1_n1654_59# 0.08313f
C6 upstepper_test VDD_3V3 0.13834f
C7 5v0_half_adder_selector_sc_0/m1_n244_n517# VDD_3V3 0.27028f
C8 5v0_half_adder_selector_sc_0/m1_n437_n664# ternary_input 0.02233f
C9 VDD_3V3_uq0 ctrl_sign 0.38402f
C10 5v0_half_adder_selector_sc_0/m1_n10_n948# 5v0_half_adder_selector_sc_0/m1_n9_n292# 0.25895f
C11 downstepper_test VDD_3V3 0.41098f
C12 a_n1898_n981# VDD_3V3_uq0 0.00196f
C13 VDD_3V3_uq0 5v0_nti_sc_f_0/ternary_output 0.16211f
C14 ternary_input ctrl_sign 0.0028f
C15 5v0_half_adder_selector_sc_0/m1_n437_n664# 5v0_half_adder_selector_sc_0/m1_n244_n517# 0.37702f
C16 a_n1205_n937# VDD_1V65 0.00354f
C17 a_n1898_n981# ternary_input 0.02714f
C18 ternary_input 5v0_nti_sc_f_0/ternary_output 0.60908f
C19 downstepper_test 5v0_half_adder_selector_sc_0/m1_n437_n664# 0.00206f
C20 upstepper_test ctrl_sign 0.08746f
C21 5v0_half_adder_selector_sc_0/m1_n244_n517# ctrl_sign 0.0109f
C22 a_n1898_n981# upstepper_test 0
C23 upstepper_test 5v0_nti_sc_f_0/ternary_output 0.11981f
C24 5v0_half_adder_selector_sc_0/m1_n244_n517# 5v0_nti_sc_f_0/ternary_output 0.00226f
C25 a_n1325_n547# 5v0_half_adder_selector_sc_0/m1_n9_n292# 0
C26 downstepper_test ctrl_sign 0.14523f
C27 downstepper_test 5v0_nti_sc_f_0/ternary_output 0.07077f
C28 a_n1898_n981# downstepper_test 0.18136f
C29 VDD_3V3_uq0 VDD_1V65 0
C30 m1_n1654_59# a_n1778_n454# 0.00135f
C31 ternary_input a_n1373_n454# 0.00136f
C32 5v0_half_adder_selector_sc_0/m1_n10_n948# upstepper_test 0.00165f
C33 5v0_half_adder_selector_sc_0/m1_n10_n948# 5v0_half_adder_selector_sc_0/m1_n244_n517# 0.11606f
C34 ternary_input VDD_1V65 0.03394f
C35 VDD_3V3_uq0 a_n1325_n547# 0.23112f
C36 upstepper_test a_n1373_n454# 0
C37 downstepper_test 5v0_half_adder_selector_sc_0/m1_n10_n948# 0.00615f
C38 ternary_output VDD_3V3 0.15496f
C39 upstepper_test VDD_1V65 0.16859f
C40 ternary_input a_n1325_n547# 0.08497f
C41 5v0_half_adder_selector_sc_0/m1_n9_n292# a_n1205_n937# 0
C42 5v0_half_adder_selector_sc_0/m1_n244_n517# VDD_1V65 0
C43 downstepper_test a_n1373_n454# 0.00442f
C44 downstepper_test VDD_1V65 0.13024f
C45 upstepper_test a_n1325_n547# 0.0467f
C46 5v0_half_adder_selector_sc_0/m1_n437_n664# ternary_output 0.18581f
C47 5v0_half_adder_selector_sc_0/m1_n244_n517# a_n1325_n547# 0
C48 5v0_half_adder_selector_sc_0/m1_n239_179# VDD_3V3 0.00154f
C49 downstepper_test a_n1325_n547# 0.07797f
C50 5v0_nti_sc_f_0/ternary_output a_n1778_n454# 0.00123f
C51 a_n1898_n981# a_n1778_n454# 0.00212f
C52 5v0_half_adder_selector_sc_0/m1_n437_n664# 5v0_half_adder_selector_sc_0/m1_n239_179# 0.00486f
C53 ternary_output 5v0_nti_sc_f_0/ternary_output 0
C54 5v0_half_adder_selector_sc_0/m1_n239_179# ctrl_sign 0.30291f
C55 m1_n1654_59# VDD_3V3 0.02893f
C56 VDD_3V3_uq0 5v0_half_adder_selector_sc_0/m1_n9_n292# 0.02483f
C57 ternary_input a_n1205_n937# 0
C58 ternary_input 5v0_half_adder_selector_sc_0/m1_n9_n292# 0.02636f
C59 upstepper_test a_n1205_n937# 0.00334f
C60 5v0_half_adder_selector_sc_0/m1_n10_n948# ternary_output 0.05319f
C61 upstepper_test 5v0_half_adder_selector_sc_0/m1_n9_n292# 0.27475f
C62 m1_n1654_59# ctrl_sign 0
C63 5v0_half_adder_selector_sc_0/m1_n244_n517# 5v0_half_adder_selector_sc_0/m1_n9_n292# 0.14284f
C64 downstepper_test a_n1205_n937# 0.00453f
C65 5v0_half_adder_selector_sc_0/m1_n437_n664# VDD_3V3 0.40911f
C66 a_n1898_n981# m1_n1654_59# 0.10928f
C67 m1_n1654_59# 5v0_nti_sc_f_0/ternary_output 0.17279f
C68 downstepper_test 5v0_half_adder_selector_sc_0/m1_n9_n292# 0.25302f
C69 a_n1778_n454# VDD_1V65 0
C70 5v0_half_adder_selector_sc_0/m1_n10_n948# 5v0_half_adder_selector_sc_0/m1_n239_179# 0
C71 VDD_3V3 ctrl_sign 0
C72 a_n1898_n981# VDD_3V3 0.59815f
C73 VDD_3V3 5v0_nti_sc_f_0/ternary_output 0.40684f
C74 ternary_input VDD_3V3_uq0 0.96005f
C75 5v0_half_adder_selector_sc_0/m1_n437_n664# ctrl_sign 0.01302f
C76 upstepper_test VDD_3V3_uq0 0.33323f
C77 VDD_3V3_uq0 5v0_half_adder_selector_sc_0/m1_n244_n517# 0
C78 5v0_half_adder_selector_sc_0/m1_n239_179# a_n1325_n547# 0
C79 downstepper_test VDD_3V3_uq0 0.10943f
C80 upstepper_test ternary_input 0.02397f
C81 ternary_input 5v0_half_adder_selector_sc_0/m1_n244_n517# 0.09044f
C82 ctrl_sign 5v0_nti_sc_f_0/ternary_output 0
C83 m1_n1654_59# a_n1373_n454# 0
C84 downstepper_test ternary_input 0.16132f
C85 a_n1898_n981# 5v0_nti_sc_f_0/ternary_output 0.20745f
C86 5v0_half_adder_selector_sc_0/m1_n10_n948# VDD_3V3 0.0303f
C87 m1_n1654_59# VDD_1V65 0.00115f
C88 upstepper_test 5v0_half_adder_selector_sc_0/m1_n244_n517# 0.00167f
C89 downstepper_test upstepper_test 0.38867f
C90 VDD_3V3 a_n1373_n454# 0.00122f
C91 m1_n1654_59# a_n1325_n547# 0.19351f
C92 downstepper_test 5v0_half_adder_selector_sc_0/m1_n244_n517# 0.02897f
C93 5v0_half_adder_selector_sc_0/m1_n10_n948# 5v0_half_adder_selector_sc_0/m1_n437_n664# 0.06982f
C94 VDD_3V3 VDD_1V65 0.04713f
C95 ternary_output 5v0_half_adder_selector_sc_0/m1_n9_n292# 0.11993f
C96 a_n1325_n547# VDD_3V3 0.16742f
C97 5v0_half_adder_selector_sc_0/m1_n239_179# 5v0_half_adder_selector_sc_0/m1_n9_n292# 0.18379f
C98 5v0_nti_sc_f_0/ternary_output a_n1373_n454# 0
C99 a_n1898_n981# a_n1373_n454# 0
C100 5v0_nti_sc_f_0/ternary_output VDD_1V65 0.21326f
C101 a_n1898_n981# VDD_1V65 0.01095f
C102 a_n1325_n547# ctrl_sign 0.00263f
C103 ternary_output VDD_3V3_uq0 0
C104 a_n1898_n981# a_n1325_n547# 0.08248f
C105 a_n1325_n547# 5v0_nti_sc_f_0/ternary_output 0.21872f
C106 ternary_input a_n1778_n454# 0.00116f
C107 ternary_output ternary_input 0.09966f
C108 5v0_half_adder_selector_sc_0/m1_n239_179# VDD_3V3_uq0 0.28989f
C109 VDD_3V3 a_n1205_n937# 0.00891f
C110 upstepper_test a_n1778_n454# 0
C111 upstepper_test ternary_output 0
C112 5v0_half_adder_selector_sc_0/m1_n9_n292# VDD_3V3 0.13661f
C113 ternary_output 5v0_half_adder_selector_sc_0/m1_n244_n517# 0.23201f
C114 5v0_half_adder_selector_sc_0/m1_n239_179# ternary_input 0.00189f
C115 downstepper_test a_n1778_n454# 0.0031f
C116 downstepper_test ternary_output 0.00248f
C117 a_n1373_n454# VDD_1V65 0.00232f
C118 5v0_half_adder_selector_sc_0/m1_n437_n664# 5v0_half_adder_selector_sc_0/m1_n9_n292# 0.04907f
C119 upstepper_test 5v0_half_adder_selector_sc_0/m1_n239_179# 0.07502f
C120 5v0_half_adder_selector_sc_0/m1_n239_179# 5v0_half_adder_selector_sc_0/m1_n244_n517# 0.00395f
C121 a_n1325_n547# a_n1373_n454# 0.00135f
C122 m1_n1654_59# VDD_3V3_uq0 0.551f
C123 5v0_half_adder_selector_sc_0/m1_n9_n292# ctrl_sign 0.22345f
C124 downstepper_test 5v0_half_adder_selector_sc_0/m1_n239_179# 0.09961f
C125 5v0_nti_sc_f_0/ternary_output a_n1205_n937# 0
C126 a_n1898_n981# a_n1205_n937# 0
C127 a_n1325_n547# VDD_1V65 0.14775f
C128 m1_n1654_59# ternary_input 0.5313f
C129 5v0_half_adder_selector_sc_0/m1_n9_n292# 5v0_nti_sc_f_0/ternary_output 0.00372f
C130 VDD_1V65 VSS 0.09232f
C131 a_n1205_n937# VSS 0 ; **FLOATING
C132 a_n1373_n454# VSS 0.00335f ; **FLOATING
C133 a_n1778_n454# VSS 0.00573f ; **FLOATING
C134 a_n1898_n981# VSS 0.56173f ; **FLOATING
C135 a_n1325_n547# VSS 0.6002f ; **FLOATING
C136 5v0_nti_sc_f_0/ternary_output VSS 1.36077f
C137 m1_n1654_59# VSS 0.62941f ; **FLOATING
C138 VDD_3V3_uq0 VSS 6.3874f
C139 5v0_half_adder_selector_sc_0/m1_n437_n664# VSS 0.571f ; **FLOATING
C140 5v0_half_adder_selector_sc_0/m1_n10_n948# VSS 0.55254f ; **FLOATING
C141 ternary_output VSS 0.30264f
C142 5v0_half_adder_selector_sc_0/m1_n244_n517# VSS 0.39366f ; **FLOATING
C143 VDD_3V3 VSS 6.28664f
C144 5v0_half_adder_selector_sc_0/m1_n239_179# VSS 0.30065f ; **FLOATING
C145 5v0_half_adder_selector_sc_0/m1_n9_n292# VSS 0.50953f ; **FLOATING
C146 downstepper_test VSS 0.64154f
C147 ctrl_sign VSS 0.56557f
C148 upstepper_test VSS 0.54918f
C149 ternary_input VSS 1.48124f
