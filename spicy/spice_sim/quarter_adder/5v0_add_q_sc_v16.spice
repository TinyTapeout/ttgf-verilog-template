* NGSPICE file created from 5v0_add_q_sc.ext - technology: gf180mcuD

.option scale=5n

X0 pti ternary_input VSS VSS nfet_06v0 ad=6.336n pd=0.32m as=6.336n ps=0.32m w=72 l=578
X1 VDD_3V3 ternary_input pti VDD_3V3 pfet_06v0 ad=12.81n pd=0.349m as=12.688n ps=0.348m w=244 l=100
X2 pti ternary_input VDD_3V3 VDD_3V3 pfet_06v0 ad=12.688n pd=0.348m as=21.472n ps=0.664m w=244 l=100
X3 pti ternary_input VDD_3V3 VDD_3V3 pfet_06v0 ad=27.328n pd=0.712m as=12.81n ps=0.349m w=244 l=100
X4 nti ternary_input VSS VSS nfet_06v0 ad=12.7n pd=0.454m as=11.303n ps=0.432m w=127 l=120
X5 nti ternary_input VDD_3V3 VDD_3V3 pfet_06v0 ad=9.696n pd=0.394m as=8.928n ps=0.378m w=96 l=150
X6 5v0_half_adder_selector_sc_0/res_stage0 5v0_half_adder_selector_sc_0/m1_n239_179# downstepper_test VSS nfet_06v0 ad=14.432n pd=0.504m as=14.432n ps=0.504m w=164 l=120
X7 5v0_half_adder_selector_sc_0/res_stage0 5v0_half_adder_selector_sc_0/m1_n239_179# upstepper_test VDD_3V3 pfet_06v0 ad=21.472n pd=0.664m as=21.472n ps=0.664m w=244 l=100
X8 5v0_half_adder_selector_sc_0/m1_n239_179# ctrl_sign VSS VSS nfet_06v0 ad=14.432n pd=0.504m as=14.432n ps=0.504m w=164 l=120
X9 5v0_half_adder_selector_sc_0/m1_n239_179# ctrl_sign VDD_3V3 VDD_3V3 pfet_06v0 ad=21.472n pd=0.664m as=21.472n ps=0.664m w=244 l=100
X10 5v0_half_adder_selector_sc_0/res_stage0 ctrl_sign upstepper_test VSS nfet_06v0 ad=31.489n pd=1.041m as=43.711n ps=1.504m w=164 l=120
X11 5v0_half_adder_selector_sc_0/res_stage0 ctrl_sign downstepper_test VDD_3V3 pfet_06v0 ad=46.849n pd=1.361m as=42.856n ps=1.326m w=244 l=100
X12 ternary_output ctrl_over 5v0_half_adder_selector_sc_0/res_stage0 VSS nfet_06v0 ad=17.057n pd=0.537m as=0 ps=0 w=164 l=120
X13 ternary_output ctrl_over ternary_input VDD_3V3_uq0 pfet_06v0 ad=25.377n pd=0.697m as=21.472n ps=0.664m w=244 l=100
X14 5v0_half_adder_selector_sc_0/m1_n244_n517# ctrl_over VSS VSS nfet_06v0 ad=14.432n pd=0.504m as=0.10465u ps=3.768m w=164 l=120
X15 5v0_half_adder_selector_sc_0/m1_n244_n517# ctrl_over VDD_3V3_uq0 VDD_3V3_uq0 pfet_06v0 ad=21.472n pd=0.664m as=85.71201n ps=2.652m w=244 l=100
X16 ternary_output 5v0_half_adder_selector_sc_0/m1_n244_n517# ternary_input VSS nfet_06v0 ad=0 pd=0 as=14.432n ps=0.504m w=164 l=120
X17 ternary_output 5v0_half_adder_selector_sc_0/m1_n244_n517# 5v0_half_adder_selector_sc_0/res_stage0 VDD_3V3_uq0 pfet_06v0 ad=0 pd=0 as=0 ps=0 w=244 l=100
X18 inv_pti pti VSS VSS nfet_06v0 ad=14.432n pd=0.504m as=14.432n ps=0.504m w=164 l=120
X19 inv_pti pti VDD_3V3 VDD_3V3 pfet_06v0 ad=21.472n pd=0.664m as=21.472n ps=0.664m w=244 l=100
X20 inv_nti nti VSS VSS nfet_06v0 ad=14.432n pd=0.504m as=0 ps=0 w=164 l=120
X21 inv_nti nti VDD_3V3_uq0 VDD_3V3_uq0 pfet_06v0 ad=21.472n pd=0.664m as=0 ps=0 w=244 l=100
X22 a_n1373_n454# inv_nti downstepper_test VSS nfet_06v0 ad=3.528n pd=0.195m as=8.599n ps=0.264m w=147 l=120
X23 upstepper_test nti a_n1205_n937# VDD_3V3_uq0 pfet_06v0 ad=21.384n pd=0.662m as=5.832n ps=0.291m w=243 l=100
X24 upstepper_test nti VDD_1V65 VSS nfet_06v0 ad=14.847n pd=0.496m as=10.51n ps=0.29m w=147 l=120
X25 a_n1205_n937# inv_pti VDD_3V3_uq0 VDD_3V3_uq0 pfet_06v0 ad=5.832n pd=0.291m as=21.384n ps=0.662m w=243 l=100
X26 downstepper_test pti a_n1778_n454# VSS nfet_06v0 ad=8.599n pd=0.264m as=3.528n ps=0.195m w=147 l=120
X27 a_n1778_n454# inv_nti VSS VSS nfet_06v0 ad=3.528n pd=0.195m as=14.847n ps=0.496m w=147 l=120
X28 upstepper_test inv_pti VSS VSS nfet_06v0 ad=14.432n pd=0.504m as=14.432n ps=0.504m w=164 l=120
X29 VDD_1V65 inv_pti a_n1373_n454# VSS nfet_06v0 ad=10.51n pd=0.29m as=3.528n ps=0.195m w=147 l=120
X30 downstepper_test inv_nti VDD_3V3_uq0 VDD_3V3_uq0 pfet_06v0 ad=21.384n pd=0.662m as=21.384n ps=0.662m w=243 l=100
C0 VDD_3V3_uq0 pti 0.02893f
C1 nti downstepper_test 0.07077f
C2 upstepper_test ctrl_sign 0.08746f
C3 VDD_3V3 VDD_1V65 0
C4 5v0_half_adder_selector_sc_0/m1_n244_n517# ctrl_over 0.37702f
C5 VDD_3V3 ternary_input 0.96008f
C6 downstepper_test a_n1205_n937# 0.00453f
C7 VDD_3V3_uq0 ctrl_sign 0
C8 inv_pti 5v0_half_adder_selector_sc_0/m1_n239_179# 0
C9 pti downstepper_test 0.08313f
C10 VDD_3V3 upstepper_test 0.33479f
C11 upstepper_test 5v0_half_adder_selector_sc_0/5v0_tgate_sel_2_sc_1/input_A 0
C12 ternary_output 5v0_half_adder_selector_sc_0/res_stage0 0.11993f
C13 downstepper_test ctrl_sign 0.14523f
C14 VDD_3V3 VDD_3V3_uq0 0
C15 VDD_3V3_uq0 5v0_half_adder_selector_sc_0/5v0_tgate_sel_2_sc_1/input_A 0.03098f
C16 inv_pti a_n1373_n454# 0.00135f
C17 nti inv_pti 0.21872f
C18 nti a_n1778_n454# 0.00123f
C19 5v0_half_adder_selector_sc_0/m1_n244_n517# 5v0_half_adder_selector_sc_0/res_stage0 0.14284f
C20 VDD_3V3 downstepper_test 0.10966f
C21 5v0_half_adder_selector_sc_0/5v0_tgate_sel_2_sc_1/input_A downstepper_test 0
C22 nti a_n1373_n454# 0
C23 inv_pti pti 0.19351f
C24 ctrl_sign 5v0_half_adder_selector_sc_0/m1_n239_179# 0.30291f
C25 a_n1778_n454# pti 0.00135f
C26 ternary_input ternary_output 0.19159f
C27 nti a_n1205_n937# 0
C28 pti a_n1373_n454# 0
C29 inv_pti ctrl_sign 0.00263f
C30 ctrl_over 5v0_half_adder_selector_sc_0/res_stage0 0.04907f
C31 5v0_half_adder_selector_sc_0/m1_n244_n517# VDD_1V65 0
C32 nti pti 0.17279f
C33 VDD_3V3 5v0_half_adder_selector_sc_0/m1_n239_179# 0.28989f
C34 upstepper_test ternary_output 0
C35 5v0_half_adder_selector_sc_0/m1_n244_n517# ternary_input 0.13297f
C36 VDD_3V3_uq0 ternary_output 0.15496f
C37 VDD_3V3 inv_pti 0.23387f
C38 nti ctrl_sign 0
C39 upstepper_test 5v0_half_adder_selector_sc_0/m1_n244_n517# 0.00167f
C40 VDD_3V3_uq0 5v0_half_adder_selector_sc_0/m1_n244_n517# 0.27028f
C41 pti ctrl_sign 0
C42 ternary_output downstepper_test 0.00248f
C43 VDD_3V3 nti 0.16206f
C44 ctrl_over ternary_input 0.0727f
C45 5v0_half_adder_selector_sc_0/m1_n244_n517# downstepper_test 0.02897f
C46 VDD_3V3 pti 0.55208f
C47 upstepper_test ctrl_over 0
C48 VDD_3V3_uq0 ctrl_over 0.40911f
C49 VDD_3V3 ctrl_sign 0.3841f
C50 5v0_half_adder_selector_sc_0/5v0_tgate_sel_2_sc_1/input_A ctrl_sign 0
C51 inv_nti VDD_1V65 0.01095f
C52 ternary_input inv_nti 0.02714f
C53 ternary_input 5v0_half_adder_selector_sc_0/res_stage0 0.28146f
C54 5v0_half_adder_selector_sc_0/m1_n244_n517# 5v0_half_adder_selector_sc_0/m1_n239_179# 0.00395f
C55 ctrl_over downstepper_test 0.00206f
C56 upstepper_test inv_nti 0
C57 5v0_half_adder_selector_sc_0/m1_n244_n517# inv_pti 0
C58 upstepper_test 5v0_half_adder_selector_sc_0/res_stage0 0.27475f
C59 nti ternary_output 0
C60 VDD_3V3_uq0 inv_nti 0.59815f
C61 VDD_3V3_uq0 5v0_half_adder_selector_sc_0/res_stage0 0.13661f
C62 ternary_input VDD_1V65 0.03394f
C63 5v0_half_adder_selector_sc_0/m1_n244_n517# nti 0.00226f
C64 ctrl_over 5v0_half_adder_selector_sc_0/m1_n239_179# 0.00486f
C65 inv_nti downstepper_test 0.18136f
C66 5v0_half_adder_selector_sc_0/res_stage0 downstepper_test 0.25302f
C67 ternary_output ctrl_sign 0
C68 upstepper_test VDD_1V65 0.16859f
C69 5v0_half_adder_selector_sc_0/m1_n244_n517# pti 0
C70 upstepper_test ternary_input 0.02545f
C71 VDD_3V3_uq0 VDD_1V65 0.04713f
C72 VDD_3V3_uq0 ternary_input 0.15434f
C73 5v0_half_adder_selector_sc_0/m1_n244_n517# ctrl_sign 0.0109f
C74 5v0_half_adder_selector_sc_0/res_stage0 5v0_half_adder_selector_sc_0/m1_n239_179# 0.18379f
C75 VDD_3V3_uq0 upstepper_test 0.13834f
C76 VDD_1V65 downstepper_test 0.13024f
C77 ternary_input downstepper_test 0.16661f
C78 VDD_3V3 5v0_half_adder_selector_sc_0/m1_n244_n517# 0
C79 inv_nti inv_pti 0.08248f
C80 a_n1778_n454# inv_nti 0.00212f
C81 inv_pti 5v0_half_adder_selector_sc_0/res_stage0 0
C82 5v0_half_adder_selector_sc_0/m1_n244_n517# 5v0_half_adder_selector_sc_0/5v0_tgate_sel_2_sc_1/input_A 0.07353f
C83 ctrl_over ctrl_sign 0.01302f
C84 inv_nti a_n1373_n454# 0
C85 upstepper_test downstepper_test 0.38867f
C86 nti inv_nti 0.20745f
C87 nti 5v0_half_adder_selector_sc_0/res_stage0 0.00372f
C88 VDD_3V3_uq0 downstepper_test 0.41098f
C89 inv_nti a_n1205_n937# 0
C90 ternary_input 5v0_half_adder_selector_sc_0/m1_n239_179# 0.00191f
C91 VDD_3V3 ctrl_over 0.0015f
C92 5v0_half_adder_selector_sc_0/res_stage0 a_n1205_n937# 0
C93 inv_nti pti 0.10928f
C94 5v0_half_adder_selector_sc_0/5v0_tgate_sel_2_sc_1/input_A ctrl_over 0.01944f
C95 inv_pti VDD_1V65 0.14775f
C96 a_n1778_n454# VDD_1V65 0
C97 ternary_input inv_pti 0.08497f
C98 a_n1778_n454# ternary_input 0.00116f
C99 upstepper_test 5v0_half_adder_selector_sc_0/m1_n239_179# 0.07502f
C100 VDD_1V65 a_n1373_n454# 0.00232f
C101 ternary_input a_n1373_n454# 0.00136f
C102 5v0_half_adder_selector_sc_0/res_stage0 ctrl_sign 0.22345f
C103 VDD_3V3_uq0 5v0_half_adder_selector_sc_0/m1_n239_179# 0.00154f
C104 upstepper_test inv_pti 0.04606f
C105 nti VDD_1V65 0.21326f
C106 upstepper_test a_n1778_n454# 0
C107 5v0_half_adder_selector_sc_0/m1_n244_n517# ternary_output 0.23201f
C108 nti ternary_input 0.60908f
C109 VDD_1V65 a_n1205_n937# 0.00354f
C110 VDD_3V3_uq0 inv_pti 0.16742f
C111 ternary_input a_n1205_n937# 0
C112 VDD_3V3 inv_nti 0.00196f
C113 upstepper_test a_n1373_n454# 0
C114 VDD_3V3 5v0_half_adder_selector_sc_0/res_stage0 0.02483f
C115 VDD_1V65 pti 0.00115f
C116 downstepper_test 5v0_half_adder_selector_sc_0/m1_n239_179# 0.09961f
C117 ternary_input pti 0.5313f
C118 upstepper_test nti 0.11981f
C119 5v0_half_adder_selector_sc_0/5v0_tgate_sel_2_sc_1/input_A 5v0_half_adder_selector_sc_0/res_stage0 0.00385f
C120 VDD_3V3_uq0 a_n1373_n454# 0.00122f
C121 upstepper_test a_n1205_n937# 0.00334f
C122 inv_pti downstepper_test 0.07797f
C123 VDD_3V3_uq0 nti 0.40684f
C124 a_n1778_n454# downstepper_test 0.0031f
C125 ternary_input ctrl_sign 0.00264f
C126 upstepper_test pti 0
C127 ctrl_over ternary_output 0.18581f
C128 VDD_3V3_uq0 a_n1205_n937# 0.00891f
C129 downstepper_test a_n1373_n454# 0.00442f
C130 pti VSS 0.62941f
C131 VDD_1V65 VSS 0.09232f
C132 inv_nti VSS 0.56173f
C133 inv_pti VSS 0.59892f
C134 a_n1205_n937# VSS 0 ; **FLOATING
C135 a_n1373_n454# VSS 0.00335f ; **FLOATING
C136 a_n1778_n454# VSS 0.00573f ; **FLOATING
C137 nti VSS 1.36077f
C138 VDD_3V3 VSS 6.27502f
C139 5v0_half_adder_selector_sc_0/5v0_tgate_sel_2_sc_1/input_A VSS 0
C140 ctrl_over VSS 0.55135f
C141 ternary_input VSS 2.00726f
C142 ternary_output VSS 0.28152f
C143 5v0_half_adder_selector_sc_0/m1_n244_n517# VSS 0.39366f ; **FLOATING
C144 VDD_3V3_uq0 VSS 6.2849f
C145 5v0_half_adder_selector_sc_0/m1_n239_179# VSS 0.30065f ; **FLOATING
C146 5v0_half_adder_selector_sc_0/res_stage0 VSS 0.50953f
C147 downstepper_test VSS 0.64154f
C148 ctrl_sign VSS 0.56557f
C149 upstepper_test VSS 0.54869f
