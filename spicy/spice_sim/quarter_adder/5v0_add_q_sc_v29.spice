* NGSPICE file created from 5v0_add_q_sc.ext - technology: gf180mcuD

.option scale=5n

X0 pti ternary_input VSS VSS nfet_06v0 ad=6.336n pd=0.32m as=6.478n ps=0.255m w=72 l=578
X1 VDD_3V3 ternary_input pti VDD_3V3 pfet_06v0 ad=12.81n pd=0.349m as=12.688n ps=0.348m w=244 l=100
X2 VDD_3V3 ternary_input nti VDD_3V3 pfet_06v0 ad=13.616n pd=0.392m as=9.696n ps=0.394m w=96 l=150
X3 VSS ternary_input nti VSS nfet_06v0 ad=6.478n pd=0.255m as=12.7n ps=0.454m w=127 l=120
X4 pti ternary_input VDD_3V3 VDD_3V3 pfet_06v0 ad=12.688n pd=0.348m as=13.616n ps=0.392m w=244 l=100
X5 pti ternary_input VDD_3V3 VDD_3V3 pfet_06v0 ad=27.328n pd=0.712m as=12.81n ps=0.349m w=244 l=100
X6 5v0_half_adder_selector_sc_0/res_stage0 5v0_half_adder_selector_sc_0/m1_n239_179# downstepper_test VSS nfet_06v0 ad=14.432n pd=0.504m as=14.432n ps=0.504m w=164 l=120
X7 5v0_half_adder_selector_sc_0/res_stage0 5v0_half_adder_selector_sc_0/m1_n239_179# upstepper_test VDD_3V3 pfet_06v0 ad=21.472n pd=0.664m as=21.472n ps=0.664m w=244 l=100
X8 5v0_half_adder_selector_sc_0/m1_n239_179# ctrl_sign VSS VSS nfet_06v0 ad=14.432n pd=0.504m as=14.432n ps=0.504m w=164 l=120
X9 5v0_half_adder_selector_sc_0/m1_n239_179# ctrl_sign VDD_3V3 VDD_3V3 pfet_06v0 ad=21.472n pd=0.664m as=21.472n ps=0.664m w=244 l=100
X10 5v0_half_adder_selector_sc_0/res_stage0 ctrl_sign upstepper_test VSS nfet_06v0 ad=31.489n pd=1.041m as=43.711n ps=1.504m w=164 l=120
X11 5v0_half_adder_selector_sc_0/res_stage0 ctrl_sign downstepper_test VDD_3V3 pfet_06v0 ad=46.849n pd=1.361m as=42.856n ps=1.326m w=244 l=100
X12 ternary_output ctrl_over 5v0_half_adder_selector_sc_0/res_stage0 VSS nfet_06v0 ad=17.057n pd=0.537m as=0 ps=0 w=164 l=120
X13 ternary_output ctrl_over ternary_input VDD_3V3_uq0 pfet_06v0 ad=25.377n pd=0.697m as=21.472n ps=0.664m w=244 l=100
X14 5v0_half_adder_selector_sc_0/m1_n244_n517# ctrl_over VSS VSS nfet_06v0 ad=14.432n pd=0.504m as=99.96301n ps=3.526m w=164 l=120
X15 5v0_half_adder_selector_sc_0/m1_n244_n517# ctrl_over VDD_3V3_uq0 VDD_3V3_uq0 pfet_06v0 ad=21.472n pd=0.664m as=42.857n ps=1.327m w=244 l=100
X16 ternary_output 5v0_half_adder_selector_sc_0/m1_n244_n517# ternary_input VSS nfet_06v0 ad=0 pd=0 as=14.432n ps=0.504m w=164 l=120
X17 ternary_output 5v0_half_adder_selector_sc_0/m1_n244_n517# 5v0_half_adder_selector_sc_0/res_stage0 VDD_3V3_uq0 pfet_06v0 ad=0 pd=0 as=0 ps=0 w=244 l=100
X18 inv_pti pti VSS VSS nfet_06v0 ad=14.432n pd=0.504m as=14.432n ps=0.504m w=164 l=120
X19 inv_pti pti VDD_3V3 VDD_3V3 pfet_06v0 ad=21.472n pd=0.664m as=21.472n ps=0.664m w=244 l=100
X20 a_n1373_n454# inv_nti downstepper_test VSS nfet_06v0 ad=3.528n pd=0.195m as=8.599n ps=0.264m w=147 l=120
X21 upstepper_test nti a_n1205_n937# VDD_3V3_uq0 pfet_06v0 ad=21.384n pd=0.662m as=5.832n ps=0.291m w=243 l=100
X22 inv_nti nti VDD_3V3_uq0 VDD_3V3_uq0 pfet_06v0 ad=21.472n pd=0.664m as=21.472n ps=0.664m w=244 l=100
X23 upstepper_test nti VDD_1V65 VSS nfet_06v0 ad=14.847n pd=0.496m as=10.51n ps=0.29m w=147 l=120
X24 a_n1205_n937# inv_pti VDD_3V3_uq0 VDD_3V3_uq0 pfet_06v0 ad=5.832n pd=0.291m as=21.384n ps=0.662m w=243 l=100
X25 downstepper_test pti a_n1778_n454# VSS nfet_06v0 ad=8.599n pd=0.264m as=3.528n ps=0.195m w=147 l=120
X26 inv_nti nti VSS VSS nfet_06v0 ad=14.432n pd=0.504m as=14.432n ps=0.504m w=164 l=120
X27 a_n1778_n454# inv_nti VSS VSS nfet_06v0 ad=3.528n pd=0.195m as=14.847n ps=0.496m w=147 l=120
X28 upstepper_test inv_pti VSS VSS nfet_06v0 ad=14.432n pd=0.504m as=14.432n ps=0.504m w=164 l=120
X29 VDD_1V65 inv_pti a_n1373_n454# VSS nfet_06v0 ad=10.51n pd=0.29m as=3.528n ps=0.195m w=147 l=120
X30 downstepper_test inv_nti VDD_3V3_uq0 VDD_3V3_uq0 pfet_06v0 ad=21.384n pd=0.662m as=21.384n ps=0.662m w=243 l=100
C0 5v0_half_adder_selector_sc_0/m1_n239_179# upstepper_test 0.07502f
C1 inv_nti a_n1778_n454# 0.00214f
C2 ctrl_sign VDD_3V3_uq0 0
C3 nti inv_pti 0.21873f
C4 downstepper_test ternary_input 0.16659f
C5 5v0_half_adder_selector_sc_0/m1_n239_179# VDD_3V3_uq0 0.00154f
C6 inv_pti ctrl_sign 0.00263f
C7 ctrl_over ctrl_sign 0.01302f
C8 VDD_1V65 ternary_input 0.03394f
C9 5v0_half_adder_selector_sc_0/m1_n239_179# inv_pti 0
C10 5v0_half_adder_selector_sc_0/res_stage0 downstepper_test 0.25302f
C11 5v0_half_adder_selector_sc_0/m1_n239_179# ctrl_over 0.00486f
C12 nti a_n1205_n937# 0
C13 upstepper_test ternary_output 0
C14 5v0_half_adder_selector_sc_0/m1_n244_n517# downstepper_test 0.02897f
C15 downstepper_test pti 0.08313f
C16 downstepper_test VDD_3V3 0.10944f
C17 upstepper_test 5v0_half_adder_selector_sc_0/5v0_tgate_sel_2_sc_1/input_A 0
C18 VDD_1V65 5v0_half_adder_selector_sc_0/m1_n244_n517# 0
C19 ternary_output VDD_3V3_uq0 0.15496f
C20 VDD_1V65 pti 0.00115f
C21 VDD_1V65 VDD_3V3 0
C22 inv_nti upstepper_test 0.0011f
C23 VDD_3V3_uq0 5v0_half_adder_selector_sc_0/5v0_tgate_sel_2_sc_1/input_A 0.03098f
C24 ctrl_over ternary_output 0.18581f
C25 upstepper_test VDD_3V3_uq0 0.13823f
C26 a_n1373_n454# upstepper_test 0
C27 inv_nti VDD_3V3_uq0 0.55403f
C28 inv_nti a_n1373_n454# 0
C29 ctrl_over 5v0_half_adder_selector_sc_0/5v0_tgate_sel_2_sc_1/input_A 0.01944f
C30 upstepper_test inv_pti 0.0467f
C31 nti downstepper_test 0.07205f
C32 ctrl_over upstepper_test 0
C33 a_n1373_n454# VDD_3V3_uq0 0.00122f
C34 inv_nti inv_pti 0.08256f
C35 downstepper_test ctrl_sign 0.14523f
C36 nti VDD_1V65 0.21326f
C37 5v0_half_adder_selector_sc_0/res_stage0 ternary_input 0.28146f
C38 inv_pti VDD_3V3_uq0 0.1674f
C39 a_n1373_n454# inv_pti 0.00135f
C40 downstepper_test a_n1778_n454# 0.0031f
C41 ctrl_over VDD_3V3_uq0 0.40911f
C42 5v0_half_adder_selector_sc_0/m1_n239_179# downstepper_test 0.09961f
C43 5v0_half_adder_selector_sc_0/m1_n244_n517# ternary_input 0.13297f
C44 upstepper_test a_n1205_n937# 0.00334f
C45 ternary_input pti 0.54978f
C46 VDD_3V3 ternary_input 0.93054f
C47 inv_nti a_n1205_n937# 0
C48 VDD_1V65 a_n1778_n454# 0
C49 5v0_half_adder_selector_sc_0/res_stage0 5v0_half_adder_selector_sc_0/m1_n244_n517# 0.14284f
C50 a_n1205_n937# VDD_3V3_uq0 0.00891f
C51 5v0_half_adder_selector_sc_0/res_stage0 VDD_3V3 0.02483f
C52 5v0_half_adder_selector_sc_0/m1_n244_n517# pti 0
C53 5v0_half_adder_selector_sc_0/m1_n244_n517# VDD_3V3 0
C54 VDD_3V3 pti 0.54151f
C55 downstepper_test ternary_output 0.00248f
C56 nti ternary_input 0.61523f
C57 downstepper_test 5v0_half_adder_selector_sc_0/5v0_tgate_sel_2_sc_1/input_A 0
C58 ctrl_sign ternary_input 0.00264f
C59 upstepper_test downstepper_test 0.38867f
C60 inv_nti downstepper_test 0.1819f
C61 nti 5v0_half_adder_selector_sc_0/res_stage0 0.00372f
C62 a_n1778_n454# ternary_input 0.00116f
C63 VDD_1V65 upstepper_test 0.16859f
C64 5v0_half_adder_selector_sc_0/m1_n239_179# ternary_input 0.00191f
C65 inv_nti VDD_1V65 0.01114f
C66 5v0_half_adder_selector_sc_0/res_stage0 ctrl_sign 0.22345f
C67 downstepper_test VDD_3V3_uq0 0.41008f
C68 nti 5v0_half_adder_selector_sc_0/m1_n244_n517# 0.00226f
C69 a_n1373_n454# downstepper_test 0.00442f
C70 nti pti 0.1782f
C71 nti VDD_3V3 0.16194f
C72 5v0_half_adder_selector_sc_0/m1_n244_n517# ctrl_sign 0.0109f
C73 VDD_1V65 VDD_3V3_uq0 0.04703f
C74 a_n1373_n454# VDD_1V65 0.00232f
C75 5v0_half_adder_selector_sc_0/m1_n239_179# 5v0_half_adder_selector_sc_0/res_stage0 0.18379f
C76 ctrl_sign pti 0
C77 VDD_3V3 ctrl_sign 0.38411f
C78 downstepper_test inv_pti 0.07797f
C79 ctrl_over downstepper_test 0.00206f
C80 5v0_half_adder_selector_sc_0/m1_n239_179# 5v0_half_adder_selector_sc_0/m1_n244_n517# 0.00395f
C81 a_n1778_n454# pti 0.00135f
C82 VDD_1V65 inv_pti 0.14775f
C83 5v0_half_adder_selector_sc_0/m1_n239_179# VDD_3V3 0.28989f
C84 ternary_output ternary_input 0.19159f
C85 downstepper_test a_n1205_n937# 0.00453f
C86 upstepper_test ternary_input 0.02545f
C87 5v0_half_adder_selector_sc_0/res_stage0 ternary_output 0.11993f
C88 VDD_1V65 a_n1205_n937# 0.00354f
C89 inv_nti ternary_input 0.02537f
C90 nti ctrl_sign 0
C91 5v0_half_adder_selector_sc_0/m1_n244_n517# ternary_output 0.23201f
C92 5v0_half_adder_selector_sc_0/res_stage0 5v0_half_adder_selector_sc_0/5v0_tgate_sel_2_sc_1/input_A 0.00385f
C93 nti a_n1778_n454# 0.00142f
C94 5v0_half_adder_selector_sc_0/res_stage0 upstepper_test 0.27475f
C95 VDD_3V3_uq0 ternary_input 0.15325f
C96 a_n1373_n454# ternary_input 0.00136f
C97 5v0_half_adder_selector_sc_0/m1_n244_n517# 5v0_half_adder_selector_sc_0/5v0_tgate_sel_2_sc_1/input_A 0.07353f
C98 5v0_half_adder_selector_sc_0/m1_n239_179# ctrl_sign 0.30291f
C99 upstepper_test 5v0_half_adder_selector_sc_0/m1_n244_n517# 0.00167f
C100 upstepper_test pti 0
C101 upstepper_test VDD_3V3 0.33526f
C102 inv_pti ternary_input 0.08498f
C103 inv_nti pti 0.11055f
C104 inv_nti VDD_3V3 0.00196f
C105 ctrl_over ternary_input 0.0727f
C106 5v0_half_adder_selector_sc_0/res_stage0 VDD_3V3_uq0 0.13661f
C107 5v0_half_adder_selector_sc_0/m1_n244_n517# VDD_3V3_uq0 0.27028f
C108 VDD_3V3_uq0 pti 0.02893f
C109 a_n1373_n454# pti 0
C110 VDD_3V3 VDD_3V3_uq0 0
C111 5v0_half_adder_selector_sc_0/res_stage0 inv_pti 0
C112 VDD_1V65 downstepper_test 0.13024f
C113 5v0_half_adder_selector_sc_0/res_stage0 ctrl_over 0.04907f
C114 nti ternary_output 0
C115 a_n1205_n937# ternary_input 0
C116 5v0_half_adder_selector_sc_0/m1_n244_n517# inv_pti 0
C117 ctrl_sign ternary_output 0
C118 ctrl_over 5v0_half_adder_selector_sc_0/m1_n244_n517# 0.37702f
C119 inv_pti pti 0.19351f
C120 VDD_3V3 inv_pti 0.2319f
C121 ctrl_over VDD_3V3 0.0015f
C122 nti upstepper_test 0.11981f
C123 ctrl_sign 5v0_half_adder_selector_sc_0/5v0_tgate_sel_2_sc_1/input_A 0
C124 5v0_half_adder_selector_sc_0/res_stage0 a_n1205_n937# 0
C125 nti inv_nti 0.20874f
C126 upstepper_test ctrl_sign 0.08746f
C127 nti VDD_3V3_uq0 0.41493f
C128 nti a_n1373_n454# 0
C129 upstepper_test a_n1778_n454# 0
C130 pti VSS 0.62139f
C131 VDD_1V65 VSS 0.09068f
C132 inv_nti VSS 0.5358f
C133 inv_pti VSS 0.59892f
C134 a_n1205_n937# VSS 0 ; **FLOATING
C135 a_n1373_n454# VSS 0.00335f ; **FLOATING
C136 a_n1778_n454# VSS 0.00573f ; **FLOATING
C137 5v0_half_adder_selector_sc_0/5v0_tgate_sel_2_sc_1/input_A VSS 0
C138 ctrl_over VSS 0.55135f
C139 ternary_input VSS 1.93066f
C140 ternary_output VSS 0.28152f
C141 5v0_half_adder_selector_sc_0/m1_n244_n517# VSS 0.39366f ; **FLOATING
C142 VDD_3V3_uq0 VSS 4.05558f
C143 5v0_half_adder_selector_sc_0/m1_n239_179# VSS 0.30065f ; **FLOATING
C144 5v0_half_adder_selector_sc_0/res_stage0 VSS 0.50953f
C145 downstepper_test VSS 0.64132f
C146 ctrl_sign VSS 0.56557f
C147 VDD_3V3 VSS 6.26508f
C148 upstepper_test VSS 0.54603f
C149 nti VSS 1.27643f
