* NGSPICE file created from 5v0_add_q_sc.ext - technology: gf180mcuD

.option scale=5n

X0 pti ternary_input VSS VSS nfet_06v0 ad=6.336n pd=0.32m as=6.478n ps=0.255m w=72 l=578
X1 VDD_3V3 ternary_input pti VDD_3V3 pfet_06v0 ad=12.81n pd=0.349m as=12.688n ps=0.348m w=244 l=100
X2 VDD_3V3 ternary_input nti VDD_3V3 pfet_06v0 ad=13.616n pd=0.392m as=9.696n ps=0.394m w=96 l=150
X3 VSS ternary_input nti VSS nfet_06v0 ad=6.478n pd=0.255m as=12.7n ps=0.454m w=127 l=120
X4 pti ternary_input VDD_3V3 VDD_3V3 pfet_06v0 ad=12.688n pd=0.348m as=13.616n ps=0.392m w=244 l=100
X5 pti ternary_input VDD_3V3 VDD_3V3 pfet_06v0 ad=27.328n pd=0.712m as=12.81n ps=0.349m w=244 l=100
X6 5v0_half_adder_selector_sc_0/res_stage0 5v0_half_adder_selector_sc_0/m1_n239_179# downstepper_test VSS nfet_06v0 ad=14.432n pd=0.504m as=14.432n ps=0.504m w=164 l=120
X7 5v0_half_adder_selector_sc_0/res_stage0 5v0_half_adder_selector_sc_0/m1_n239_179# upstepper_test VDD_3V3 pfet_06v0 ad=21.472n pd=0.664m as=21.472n ps=0.664m w=244 l=100
X8 5v0_half_adder_selector_sc_0/m1_n239_179# ctrl_sign VSS VSS nfet_06v0 ad=14.432n pd=0.504m as=14.432n ps=0.504m w=164 l=120
X9 5v0_half_adder_selector_sc_0/m1_n239_179# ctrl_sign VDD_3V3 VDD_3V3 pfet_06v0 ad=21.472n pd=0.664m as=21.472n ps=0.664m w=244 l=100
X10 5v0_half_adder_selector_sc_0/res_stage0 ctrl_sign upstepper_test VSS nfet_06v0 ad=31.489n pd=1.041m as=43.711n ps=1.504m w=164 l=120
X11 5v0_half_adder_selector_sc_0/res_stage0 ctrl_sign downstepper_test VDD_3V3 pfet_06v0 ad=46.849n pd=1.361m as=42.856n ps=1.326m w=244 l=100
X12 ternary_output ctrl_over 5v0_half_adder_selector_sc_0/res_stage0 VSS nfet_06v0 ad=17.057n pd=0.537m as=0 ps=0 w=164 l=120
X13 ternary_output ctrl_over ternary_input VSS_3V3 pfet_06v0 ad=25.377n pd=0.697m as=21.472n ps=0.664m w=244 l=100
X14 5v0_half_adder_selector_sc_0/m1_n244_n517# ctrl_over VSS VSS nfet_06v0 ad=14.432n pd=0.504m as=99.96301n ps=3.526m w=164 l=120
X15 5v0_half_adder_selector_sc_0/m1_n244_n517# ctrl_over VSS_3V3 VSS_3V3 pfet_06v0 ad=21.472n pd=0.664m as=42.857n ps=1.327m w=244 l=100
X16 ternary_output 5v0_half_adder_selector_sc_0/m1_n244_n517# ternary_input VSS nfet_06v0 ad=0 pd=0 as=14.432n ps=0.504m w=164 l=120
X17 ternary_output 5v0_half_adder_selector_sc_0/m1_n244_n517# 5v0_half_adder_selector_sc_0/res_stage0 VSS_3V3 pfet_06v0 ad=0 pd=0 as=0 ps=0 w=244 l=100
X18 inv_pti pti VSS VSS nfet_06v0 ad=14.432n pd=0.504m as=14.432n ps=0.504m w=164 l=120
X19 inv_pti pti VDD_3V3 VDD_3V3 pfet_06v0 ad=21.472n pd=0.664m as=21.472n ps=0.664m w=244 l=100
X20 a_n1373_n454# inv_nti downstepper_test VSS nfet_06v0 ad=3.528n pd=0.195m as=8.599n ps=0.264m w=147 l=120
X21 upstepper_test nti a_n1205_n937# VSS_3V3 pfet_06v0 ad=21.384n pd=0.662m as=5.832n ps=0.291m w=243 l=100
X22 inv_nti nti VSS_3V3 VSS_3V3 pfet_06v0 ad=21.472n pd=0.664m as=21.472n ps=0.664m w=244 l=100
X23 upstepper_test nti VDD_1V65 VSS nfet_06v0 ad=14.847n pd=0.496m as=10.51n ps=0.29m w=147 l=120
X24 a_n1205_n937# inv_pti VSS_3V3 VSS_3V3 pfet_06v0 ad=5.832n pd=0.291m as=21.384n ps=0.662m w=243 l=100
X25 downstepper_test pti a_n1778_n454# VSS nfet_06v0 ad=8.599n pd=0.264m as=3.528n ps=0.195m w=147 l=120
X26 inv_nti nti VSS VSS nfet_06v0 ad=14.432n pd=0.504m as=14.432n ps=0.504m w=164 l=120
X27 a_n1778_n454# inv_nti VSS VSS nfet_06v0 ad=3.528n pd=0.195m as=14.847n ps=0.496m w=147 l=120
X28 upstepper_test inv_pti VSS VSS nfet_06v0 ad=14.432n pd=0.504m as=14.432n ps=0.504m w=164 l=120
X29 VDD_1V65 inv_pti a_n1373_n454# VSS nfet_06v0 ad=10.51n pd=0.29m as=3.528n ps=0.195m w=147 l=120
X30 downstepper_test inv_nti VSS_3V3 VSS_3V3 pfet_06v0 ad=21.384n pd=0.662m as=21.384n ps=0.662m w=243 l=100
C0 a_n1373_n454# inv_nti 0
C1 ternary_output upstepper_test 0
C2 downstepper_test ctrl_over 0.00206f
C3 ternary_output nti 0
C4 ternary_input a_n1205_n937# 0
C5 ternary_input 5v0_half_adder_selector_sc_0/m1_n239_179# 0.00191f
C6 inv_pti 5v0_half_adder_selector_sc_0/res_stage0 0
C7 inv_pti ctrl_sign 0.00263f
C8 VDD_1V65 inv_pti 0.14775f
C9 5v0_half_adder_selector_sc_0/res_stage0 VDD_3V3 0.02483f
C10 ternary_input pti 0.54978f
C11 ctrl_sign VDD_3V3 0.38402f
C12 VDD_1V65 VDD_3V3 0
C13 ternary_output ctrl_over 0.18581f
C14 inv_pti VDD_3V3 0.23112f
C15 5v0_half_adder_selector_sc_0/m1_n244_n517# 5v0_half_adder_selector_sc_0/res_stage0 0.14284f
C16 5v0_half_adder_selector_sc_0/m1_n244_n517# ctrl_sign 0.0109f
C17 VDD_1V65 5v0_half_adder_selector_sc_0/m1_n244_n517# 0
C18 ternary_input downstepper_test 0.16659f
C19 downstepper_test 5v0_half_adder_selector_sc_0/5v0_tgate_sel_2_sc_1/input_A 0
C20 a_n1778_n454# upstepper_test 0
C21 a_n1373_n454# ternary_input 0.00136f
C22 a_n1778_n454# nti 0.00142f
C23 a_n1778_n454# inv_nti 0.00214f
C24 5v0_half_adder_selector_sc_0/m1_n244_n517# inv_pti 0
C25 ternary_input ternary_output 0.19159f
C26 5v0_half_adder_selector_sc_0/m1_n244_n517# VDD_3V3 0
C27 downstepper_test a_n1205_n937# 0.00453f
C28 5v0_half_adder_selector_sc_0/m1_n239_179# downstepper_test 0.09961f
C29 VSS_3V3 5v0_half_adder_selector_sc_0/res_stage0 0.13661f
C30 VSS_3V3 ctrl_sign 0
C31 pti downstepper_test 0.08313f
C32 VDD_1V65 VSS_3V3 0.04703f
C33 upstepper_test 5v0_half_adder_selector_sc_0/res_stage0 0.27475f
C34 upstepper_test ctrl_sign 0.08746f
C35 VDD_1V65 upstepper_test 0.16859f
C36 a_n1373_n454# pti 0
C37 nti 5v0_half_adder_selector_sc_0/res_stage0 0.00372f
C38 nti ctrl_sign 0
C39 VDD_1V65 nti 0.21326f
C40 VDD_1V65 inv_nti 0.01114f
C41 ctrl_over 5v0_half_adder_selector_sc_0/res_stage0 0.04907f
C42 inv_pti VSS_3V3 0.1674f
C43 ctrl_sign ctrl_over 0.01302f
C44 VSS_3V3 VDD_3V3 0
C45 inv_pti upstepper_test 0.0467f
C46 upstepper_test VDD_3V3 0.33323f
C47 inv_pti nti 0.21873f
C48 nti VDD_3V3 0.16194f
C49 inv_pti inv_nti 0.08256f
C50 inv_nti VDD_3V3 0.00196f
C51 ctrl_over VDD_3V3 0.0015f
C52 a_n1373_n454# downstepper_test 0.00442f
C53 ternary_input a_n1778_n454# 0.00116f
C54 ternary_output downstepper_test 0.00248f
C55 5v0_half_adder_selector_sc_0/m1_n244_n517# VSS_3V3 0.27028f
C56 5v0_half_adder_selector_sc_0/m1_n244_n517# upstepper_test 0.00167f
C57 5v0_half_adder_selector_sc_0/m1_n244_n517# nti 0.00226f
C58 ternary_input 5v0_half_adder_selector_sc_0/res_stage0 0.28146f
C59 pti a_n1778_n454# 0.00135f
C60 ternary_input ctrl_sign 0.00264f
C61 5v0_half_adder_selector_sc_0/5v0_tgate_sel_2_sc_1/input_A 5v0_half_adder_selector_sc_0/res_stage0 0.00385f
C62 VDD_1V65 ternary_input 0.03394f
C63 5v0_half_adder_selector_sc_0/5v0_tgate_sel_2_sc_1/input_A ctrl_sign 0
C64 5v0_half_adder_selector_sc_0/m1_n244_n517# ctrl_over 0.37702f
C65 a_n1205_n937# 5v0_half_adder_selector_sc_0/res_stage0 0
C66 5v0_half_adder_selector_sc_0/m1_n239_179# 5v0_half_adder_selector_sc_0/res_stage0 0.18379f
C67 VDD_1V65 a_n1205_n937# 0.00354f
C68 VSS_3V3 upstepper_test 0.13823f
C69 5v0_half_adder_selector_sc_0/m1_n239_179# ctrl_sign 0.30291f
C70 ternary_input inv_pti 0.08498f
C71 VSS_3V3 nti 0.41493f
C72 ternary_input VDD_3V3 0.93054f
C73 pti ctrl_sign 0
C74 VDD_1V65 pti 0.00115f
C75 VSS_3V3 inv_nti 0.55403f
C76 nti upstepper_test 0.11981f
C77 inv_nti upstepper_test 0.0011f
C78 VSS_3V3 ctrl_over 0.40911f
C79 nti inv_nti 0.20874f
C80 inv_pti 5v0_half_adder_selector_sc_0/m1_n239_179# 0
C81 upstepper_test ctrl_over 0
C82 a_n1778_n454# downstepper_test 0.0031f
C83 5v0_half_adder_selector_sc_0/m1_n239_179# VDD_3V3 0.28989f
C84 inv_pti pti 0.19351f
C85 pti VDD_3V3 0.54139f
C86 5v0_half_adder_selector_sc_0/m1_n244_n517# ternary_input 0.13297f
C87 5v0_half_adder_selector_sc_0/m1_n244_n517# 5v0_half_adder_selector_sc_0/5v0_tgate_sel_2_sc_1/input_A 0.07353f
C88 downstepper_test 5v0_half_adder_selector_sc_0/res_stage0 0.25302f
C89 downstepper_test ctrl_sign 0.14523f
C90 VDD_1V65 downstepper_test 0.13024f
C91 VDD_1V65 a_n1373_n454# 0.00232f
C92 5v0_half_adder_selector_sc_0/m1_n244_n517# 5v0_half_adder_selector_sc_0/m1_n239_179# 0.00395f
C93 ternary_output 5v0_half_adder_selector_sc_0/res_stage0 0.11993f
C94 ternary_output ctrl_sign 0
C95 5v0_half_adder_selector_sc_0/m1_n244_n517# pti 0
C96 inv_pti downstepper_test 0.07797f
C97 ternary_input VSS_3V3 0.15325f
C98 VSS_3V3 5v0_half_adder_selector_sc_0/5v0_tgate_sel_2_sc_1/input_A 0.03098f
C99 downstepper_test VDD_3V3 0.10943f
C100 a_n1373_n454# inv_pti 0.00135f
C101 ternary_input upstepper_test 0.02545f
C102 5v0_half_adder_selector_sc_0/5v0_tgate_sel_2_sc_1/input_A upstepper_test 0
C103 ternary_input nti 0.61523f
C104 ternary_input inv_nti 0.02537f
C105 ternary_output VDD_3V3 0
C106 VSS_3V3 a_n1205_n937# 0.00891f
C107 VSS_3V3 5v0_half_adder_selector_sc_0/m1_n239_179# 0.00154f
C108 ternary_input ctrl_over 0.0727f
C109 5v0_half_adder_selector_sc_0/5v0_tgate_sel_2_sc_1/input_A ctrl_over 0.01944f
C110 a_n1205_n937# upstepper_test 0.00334f
C111 5v0_half_adder_selector_sc_0/m1_n239_179# upstepper_test 0.07502f
C112 pti VSS_3V3 0.02893f
C113 a_n1205_n937# nti 0
C114 pti upstepper_test 0
C115 a_n1205_n937# inv_nti 0
C116 pti nti 0.1782f
C117 5v0_half_adder_selector_sc_0/m1_n244_n517# downstepper_test 0.02897f
C118 pti inv_nti 0.11055f
C119 5v0_half_adder_selector_sc_0/m1_n239_179# ctrl_over 0.00486f
C120 5v0_half_adder_selector_sc_0/m1_n244_n517# ternary_output 0.23201f
C121 VDD_1V65 a_n1778_n454# 0
C122 VSS_3V3 downstepper_test 0.41008f
C123 downstepper_test upstepper_test 0.38867f
C124 a_n1373_n454# VSS_3V3 0.00122f
C125 ctrl_sign 5v0_half_adder_selector_sc_0/res_stage0 0.22345f
C126 downstepper_test nti 0.07205f
C127 a_n1373_n454# upstepper_test 0
C128 downstepper_test inv_nti 0.1819f
C129 a_n1373_n454# nti 0
C130 ternary_output VSS_3V3 0.15496f
C131 pti VSS 0.62139f
C132 VDD_1V65 VSS 0.09068f
C133 inv_nti VSS 0.5358f
C134 inv_pti VSS 0.6002f
C135 a_n1205_n937# VSS 0 ; **FLOATING
C136 a_n1373_n454# VSS 0.00335f ; **FLOATING
C137 a_n1778_n454# VSS 0.00573f ; **FLOATING
C138 5v0_half_adder_selector_sc_0/5v0_tgate_sel_2_sc_1/input_A VSS 0
C139 ctrl_over VSS 0.55135f
C140 ternary_input VSS 1.93066f
C141 ternary_output VSS 0.28152f
C142 5v0_half_adder_selector_sc_0/m1_n244_n517# VSS 0.39366f ; **FLOATING
C143 VSS_3V3 VSS 4.05558f
C144 5v0_half_adder_selector_sc_0/m1_n239_179# VSS 0.30065f ; **FLOATING
C145 5v0_half_adder_selector_sc_0/res_stage0 VSS 0.50953f
C146 downstepper_test VSS 0.64132f
C147 ctrl_sign VSS 0.56557f
C148 VDD_3V3 VSS 6.35626f
C149 upstepper_test VSS 0.54838f
C150 nti VSS 1.27643f
