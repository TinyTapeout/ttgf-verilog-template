* NGSPICE file created from 5v0_add_q_sc.ext - technology: gf180mcuD

.option scale=5n

X0 pti ternary_input VSS VSS nfet_06v0 ad=6.336n pd=0.32m as=6.336n ps=0.32m w=72 l=578
X1 5v0_nti_sc_f_0/VDD_3V3 ternary_input pti 5v0_nti_sc_f_0/VDD_3V3 pfet_06v0 ad=12.81n pd=0.349m as=12.688n ps=0.348m w=244 l=100
X2 pti ternary_input 5v0_nti_sc_f_0/VDD_3V3 5v0_nti_sc_f_0/VDD_3V3 pfet_06v0 ad=12.688n pd=0.348m as=21.472n ps=0.664m w=244 l=100
X3 pti ternary_input 5v0_nti_sc_f_0/VDD_3V3 5v0_nti_sc_f_0/VDD_3V3 pfet_06v0 ad=27.328n pd=0.712m as=12.81n ps=0.349m w=244 l=100
X4 nti ternary_input VSS VSS nfet_06v0 ad=12.7n pd=0.454m as=11.303n ps=0.432m w=127 l=120
X5 nti ternary_input 5v0_nti_sc_f_0/VDD_3V3 5v0_nti_sc_f_0/VDD_3V3 pfet_06v0 ad=9.696n pd=0.394m as=8.928n ps=0.378m w=96 l=150
X6 5v0_half_adder_selector_sc_0/res_stage0 5v0_half_adder_selector_sc_0/m1_n239_179# downstepper_test VSS nfet_06v0 ad=14.432n pd=0.504m as=14.432n ps=0.504m w=164 l=120
X7 5v0_half_adder_selector_sc_0/res_stage0 5v0_half_adder_selector_sc_0/m1_n239_179# upstepper_test 5v0_nti_sc_f_0/VDD_3V3 pfet_06v0 ad=21.472n pd=0.664m as=21.472n ps=0.664m w=244 l=100
X8 5v0_half_adder_selector_sc_0/m1_n239_179# ctrl_sign VSS VSS nfet_06v0 ad=14.432n pd=0.504m as=14.432n ps=0.504m w=164 l=120
X9 5v0_half_adder_selector_sc_0/m1_n239_179# ctrl_sign 5v0_nti_sc_f_0/VDD_3V3 5v0_nti_sc_f_0/VDD_3V3 pfet_06v0 ad=21.472n pd=0.664m as=21.472n ps=0.664m w=244 l=100
X10 5v0_half_adder_selector_sc_0/res_stage0 ctrl_sign upstepper_test VSS nfet_06v0 ad=31.489n pd=1.041m as=43.711n ps=1.504m w=164 l=120
X11 5v0_half_adder_selector_sc_0/res_stage0 ctrl_sign downstepper_test 5v0_nti_sc_f_0/VDD_3V3 pfet_06v0 ad=46.849n pd=1.361m as=42.856n ps=1.326m w=244 l=100
X12 ternary_output ctrl_over 5v0_half_adder_selector_sc_0/res_stage0 VSS nfet_06v0 ad=17.057n pd=0.537m as=0 ps=0 w=164 l=120
X13 ternary_output ctrl_over ternary_input VDD_3V3 pfet_06v0 ad=25.377n pd=0.697m as=21.472n ps=0.664m w=244 l=100
X14 5v0_half_adder_selector_sc_0/m1_n244_n517# ctrl_over VSS VSS nfet_06v0 ad=14.432n pd=0.504m as=0.10465u ps=3.768m w=164 l=120
X15 5v0_half_adder_selector_sc_0/m1_n244_n517# ctrl_over VDD_3V3 VDD_3V3 pfet_06v0 ad=21.472n pd=0.664m as=85.71201n ps=2.652m w=244 l=100
X16 ternary_output 5v0_half_adder_selector_sc_0/m1_n244_n517# ternary_input VSS nfet_06v0 ad=0 pd=0 as=14.432n ps=0.504m w=164 l=120
X17 ternary_output 5v0_half_adder_selector_sc_0/m1_n244_n517# 5v0_half_adder_selector_sc_0/res_stage0 VDD_3V3 pfet_06v0 ad=0 pd=0 as=0 ps=0 w=244 l=100
X18 inv_pti pti VSS VSS nfet_06v0 ad=14.432n pd=0.504m as=14.432n ps=0.504m w=164 l=120
X19 inv_pti pti 5v0_nti_sc_f_0/VDD_3V3 5v0_nti_sc_f_0/VDD_3V3 pfet_06v0 ad=21.472n pd=0.664m as=21.472n ps=0.664m w=244 l=100
X20 inv_nti nti VSS VSS nfet_06v0 ad=14.432n pd=0.504m as=0 ps=0 w=164 l=120
X21 inv_nti nti VDD_3V3 VDD_3V3 pfet_06v0 ad=21.472n pd=0.664m as=0 ps=0 w=244 l=100
X22 a_n1373_n454# inv_nti downstepper_test VSS nfet_06v0 ad=3.528n pd=0.195m as=8.599n ps=0.264m w=147 l=120
X23 upstepper_test nti a_n1205_n937# VDD_3V3 pfet_06v0 ad=21.384n pd=0.662m as=5.832n ps=0.291m w=243 l=100
X24 upstepper_test nti VDD_1V65 VSS nfet_06v0 ad=14.847n pd=0.496m as=10.51n ps=0.29m w=147 l=120
X25 a_n1205_n937# inv_pti VDD_3V3 VDD_3V3 pfet_06v0 ad=5.832n pd=0.291m as=21.384n ps=0.662m w=243 l=100
X26 downstepper_test pti a_n1778_n454# VSS nfet_06v0 ad=8.599n pd=0.264m as=3.528n ps=0.195m w=147 l=120
X27 a_n1778_n454# inv_nti VSS VSS nfet_06v0 ad=3.528n pd=0.195m as=14.847n ps=0.496m w=147 l=120
X28 upstepper_test inv_pti VSS VSS nfet_06v0 ad=14.432n pd=0.504m as=14.432n ps=0.504m w=164 l=120
X29 VDD_1V65 inv_pti a_n1373_n454# VSS nfet_06v0 ad=10.51n pd=0.29m as=3.528n ps=0.195m w=147 l=120
X30 downstepper_test inv_nti VDD_3V3 VDD_3V3 pfet_06v0 ad=21.384n pd=0.662m as=21.384n ps=0.662m w=243 l=100
C0 upstepper_test 5v0_half_adder_selector_sc_0/5v0_tgate_sel_2_sc_1/input_A 0
C1 ctrl_sign nti 0
C2 downstepper_test inv_pti 0.07797f
C3 upstepper_test VDD_3V3 0.13834f
C4 nti pti 0.17279f
C5 a_n1373_n454# nti 0
C6 upstepper_test ctrl_over 0
C7 ctrl_sign 5v0_nti_sc_f_0/VDD_3V3 0.38402f
C8 downstepper_test 5v0_half_adder_selector_sc_0/res_stage0 0.25302f
C9 upstepper_test inv_nti 0
C10 nti a_n1205_n937# 0
C11 upstepper_test ternary_output 0
C12 5v0_nti_sc_f_0/VDD_3V3 pti 0.551f
C13 ctrl_sign ternary_input 0.00264f
C14 VDD_1V65 a_n1778_n454# 0
C15 ternary_input pti 0.5313f
C16 a_n1373_n454# ternary_input 0.00136f
C17 VDD_3V3 5v0_half_adder_selector_sc_0/5v0_tgate_sel_2_sc_1/input_A 0.03098f
C18 ternary_input a_n1205_n937# 0
C19 ctrl_over 5v0_half_adder_selector_sc_0/5v0_tgate_sel_2_sc_1/input_A 0.01944f
C20 VDD_3V3 ctrl_over 0.40911f
C21 inv_pti VDD_1V65 0.14775f
C22 5v0_half_adder_selector_sc_0/m1_n244_n517# inv_pti 0
C23 VDD_3V3 inv_nti 0.59815f
C24 VDD_3V3 ternary_output 0.15496f
C25 ctrl_sign pti 0
C26 5v0_half_adder_selector_sc_0/m1_n244_n517# 5v0_half_adder_selector_sc_0/res_stage0 0.14284f
C27 upstepper_test downstepper_test 0.38867f
C28 ctrl_over ternary_output 0.18581f
C29 a_n1373_n454# pti 0
C30 5v0_half_adder_selector_sc_0/m1_n239_179# inv_pti 0
C31 nti a_n1778_n454# 0.00123f
C32 5v0_half_adder_selector_sc_0/res_stage0 5v0_half_adder_selector_sc_0/m1_n239_179# 0.18379f
C33 downstepper_test 5v0_half_adder_selector_sc_0/5v0_tgate_sel_2_sc_1/input_A 0
C34 ternary_input a_n1778_n454# 0.00116f
C35 nti inv_pti 0.21872f
C36 VDD_3V3 downstepper_test 0.41098f
C37 5v0_half_adder_selector_sc_0/res_stage0 nti 0.00372f
C38 downstepper_test ctrl_over 0.00206f
C39 upstepper_test VDD_1V65 0.16859f
C40 5v0_half_adder_selector_sc_0/m1_n244_n517# upstepper_test 0.00167f
C41 downstepper_test inv_nti 0.18136f
C42 5v0_nti_sc_f_0/VDD_3V3 inv_pti 0.23112f
C43 downstepper_test ternary_output 0.00248f
C44 5v0_half_adder_selector_sc_0/res_stage0 5v0_nti_sc_f_0/VDD_3V3 0.02483f
C45 ternary_input inv_pti 0.08497f
C46 upstepper_test 5v0_half_adder_selector_sc_0/m1_n239_179# 0.07502f
C47 pti a_n1778_n454# 0.00135f
C48 5v0_half_adder_selector_sc_0/res_stage0 ternary_input 0.28146f
C49 5v0_half_adder_selector_sc_0/m1_n244_n517# 5v0_half_adder_selector_sc_0/5v0_tgate_sel_2_sc_1/input_A 0.07353f
C50 VDD_3V3 VDD_1V65 0.04713f
C51 ctrl_sign inv_pti 0.00263f
C52 5v0_half_adder_selector_sc_0/m1_n244_n517# VDD_3V3 0.27028f
C53 upstepper_test nti 0.11981f
C54 5v0_half_adder_selector_sc_0/m1_n244_n517# ctrl_over 0.37702f
C55 ctrl_sign 5v0_half_adder_selector_sc_0/res_stage0 0.22345f
C56 inv_nti VDD_1V65 0.01095f
C57 inv_pti pti 0.19351f
C58 a_n1373_n454# inv_pti 0.00135f
C59 5v0_half_adder_selector_sc_0/m1_n244_n517# ternary_output 0.23201f
C60 upstepper_test 5v0_nti_sc_f_0/VDD_3V3 0.33323f
C61 VDD_3V3 5v0_half_adder_selector_sc_0/m1_n239_179# 0.00154f
C62 5v0_half_adder_selector_sc_0/res_stage0 a_n1205_n937# 0
C63 5v0_half_adder_selector_sc_0/m1_n239_179# ctrl_over 0.00486f
C64 upstepper_test ternary_input 0.02545f
C65 VDD_3V3 nti 0.40684f
C66 downstepper_test VDD_1V65 0.13024f
C67 nti inv_nti 0.20745f
C68 5v0_half_adder_selector_sc_0/m1_n244_n517# downstepper_test 0.02897f
C69 upstepper_test ctrl_sign 0.08746f
C70 nti ternary_output 0
C71 VDD_3V3 5v0_nti_sc_f_0/VDD_3V3 0
C72 5v0_nti_sc_f_0/VDD_3V3 ctrl_over 0.0015f
C73 upstepper_test pti 0
C74 upstepper_test a_n1373_n454# 0
C75 5v0_nti_sc_f_0/VDD_3V3 inv_nti 0.00196f
C76 upstepper_test a_n1205_n937# 0.00334f
C77 VDD_3V3 ternary_input 0.15434f
C78 downstepper_test 5v0_half_adder_selector_sc_0/m1_n239_179# 0.09961f
C79 ternary_input ctrl_over 0.0727f
C80 ternary_input inv_nti 0.02714f
C81 ternary_input ternary_output 0.19159f
C82 ctrl_sign 5v0_half_adder_selector_sc_0/5v0_tgate_sel_2_sc_1/input_A 0
C83 VDD_3V3 ctrl_sign 0
C84 downstepper_test nti 0.07077f
C85 ctrl_sign ctrl_over 0.01302f
C86 5v0_half_adder_selector_sc_0/m1_n244_n517# VDD_1V65 0
C87 VDD_3V3 pti 0.02893f
C88 5v0_half_adder_selector_sc_0/res_stage0 inv_pti 0
C89 a_n1373_n454# VDD_3V3 0.00122f
C90 ctrl_sign ternary_output 0
C91 downstepper_test 5v0_nti_sc_f_0/VDD_3V3 0.10943f
C92 VDD_3V3 a_n1205_n937# 0.00891f
C93 inv_nti pti 0.10928f
C94 a_n1373_n454# inv_nti 0
C95 5v0_half_adder_selector_sc_0/m1_n244_n517# 5v0_half_adder_selector_sc_0/m1_n239_179# 0.00395f
C96 a_n1205_n937# inv_nti 0
C97 downstepper_test ternary_input 0.16661f
C98 upstepper_test a_n1778_n454# 0
C99 nti VDD_1V65 0.21326f
C100 5v0_half_adder_selector_sc_0/m1_n244_n517# nti 0.00226f
C101 ctrl_sign downstepper_test 0.14523f
C102 upstepper_test inv_pti 0.0467f
C103 5v0_nti_sc_f_0/VDD_3V3 VDD_1V65 0
C104 downstepper_test pti 0.08313f
C105 a_n1373_n454# downstepper_test 0.00442f
C106 5v0_half_adder_selector_sc_0/m1_n244_n517# 5v0_nti_sc_f_0/VDD_3V3 0
C107 upstepper_test 5v0_half_adder_selector_sc_0/res_stage0 0.27475f
C108 downstepper_test a_n1205_n937# 0.00453f
C109 ternary_input VDD_1V65 0.03394f
C110 5v0_half_adder_selector_sc_0/m1_n244_n517# ternary_input 0.13297f
C111 inv_nti a_n1778_n454# 0.00212f
C112 5v0_nti_sc_f_0/VDD_3V3 5v0_half_adder_selector_sc_0/m1_n239_179# 0.28989f
C113 5v0_half_adder_selector_sc_0/m1_n239_179# ternary_input 0.00191f
C114 VDD_3V3 inv_pti 0.16742f
C115 5v0_half_adder_selector_sc_0/res_stage0 5v0_half_adder_selector_sc_0/5v0_tgate_sel_2_sc_1/input_A 0.00385f
C116 5v0_half_adder_selector_sc_0/m1_n244_n517# ctrl_sign 0.0109f
C117 VDD_3V3 5v0_half_adder_selector_sc_0/res_stage0 0.13661f
C118 inv_pti inv_nti 0.08248f
C119 5v0_nti_sc_f_0/VDD_3V3 nti 0.16211f
C120 5v0_half_adder_selector_sc_0/res_stage0 ctrl_over 0.04907f
C121 VDD_1V65 pti 0.00115f
C122 a_n1373_n454# VDD_1V65 0.00232f
C123 5v0_half_adder_selector_sc_0/m1_n244_n517# pti 0
C124 5v0_half_adder_selector_sc_0/res_stage0 ternary_output 0.11993f
C125 a_n1205_n937# VDD_1V65 0.00354f
C126 ctrl_sign 5v0_half_adder_selector_sc_0/m1_n239_179# 0.30291f
C127 nti ternary_input 0.60908f
C128 downstepper_test a_n1778_n454# 0.0031f
C129 5v0_nti_sc_f_0/VDD_3V3 ternary_input 0.96005f
C130 pti VSS 0.62941f
C131 VDD_1V65 VSS 0.09232f
C132 inv_nti VSS 0.56173f
C133 inv_pti VSS 0.6002f
C134 a_n1205_n937# VSS 0 ; **FLOATING
C135 a_n1373_n454# VSS 0.00335f ; **FLOATING
C136 a_n1778_n454# VSS 0.00573f ; **FLOATING
C137 nti VSS 1.36077f
C138 5v0_nti_sc_f_0/VDD_3V3 VSS 6.27264f
C139 5v0_half_adder_selector_sc_0/5v0_tgate_sel_2_sc_1/input_A VSS 0
C140 ctrl_over VSS 0.55135f
C141 ternary_input VSS 2.00726f
C142 ternary_output VSS 0.28152f
C143 5v0_half_adder_selector_sc_0/m1_n244_n517# VSS 0.39366f ; **FLOATING
C144 VDD_3V3 VSS 6.2849f
C145 5v0_half_adder_selector_sc_0/m1_n239_179# VSS 0.30065f ; **FLOATING
C146 5v0_half_adder_selector_sc_0/res_stage0 VSS 0.50953f
C147 downstepper_test VSS 0.64154f
C148 ctrl_sign VSS 0.56557f
C149 upstepper_test VSS 0.54918f
