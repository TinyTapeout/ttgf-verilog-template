* NGSPICE file created from 5v0_add_q_sc.ext - technology: gf180mcuD

.option scale=5n

X0 pti ternary_input VSS VSS nfet_06v0 ad=6.336n pd=0.32m as=6.478n ps=0.255m w=72 l=578
X1 VDD_3V3_uq0 ternary_input pti VDD_3V3_uq0 pfet_06v0 ad=12.81n pd=0.349m as=12.688n ps=0.348m w=244 l=100
X2 VDD_3V3_uq0 ternary_input nti VDD_3V3_uq0 pfet_06v0 ad=13.616n pd=0.392m as=9.696n ps=0.394m w=96 l=150
X3 VSS ternary_input nti VSS nfet_06v0 ad=6.478n pd=0.255m as=12.7n ps=0.454m w=127 l=120
X4 pti ternary_input VDD_3V3_uq0 VDD_3V3_uq0 pfet_06v0 ad=12.688n pd=0.348m as=13.616n ps=0.392m w=244 l=100
X5 pti ternary_input VDD_3V3_uq0 VDD_3V3_uq0 pfet_06v0 ad=27.328n pd=0.712m as=12.81n ps=0.349m w=244 l=100
X6 5v0_half_adder_selector_sc_0/res_stage0 5v0_half_adder_selector_sc_0/m1_n239_179# downstepper_test VSS nfet_06v0 ad=14.432n pd=0.504m as=14.432n ps=0.504m w=164 l=120
X7 5v0_half_adder_selector_sc_0/res_stage0 5v0_half_adder_selector_sc_0/m1_n239_179# upstepper_test VDD_3V3_uq0 pfet_06v0 ad=21.472n pd=0.664m as=21.472n ps=0.664m w=244 l=100
X8 5v0_half_adder_selector_sc_0/m1_n239_179# ctrl_sign VSS VSS nfet_06v0 ad=14.432n pd=0.504m as=14.432n ps=0.504m w=164 l=120
X9 5v0_half_adder_selector_sc_0/m1_n239_179# ctrl_sign VDD_3V3_uq0 VDD_3V3_uq0 pfet_06v0 ad=21.472n pd=0.664m as=21.472n ps=0.664m w=244 l=100
X10 5v0_half_adder_selector_sc_0/res_stage0 ctrl_sign upstepper_test VSS nfet_06v0 ad=31.489n pd=1.041m as=43.711n ps=1.504m w=164 l=120
X11 5v0_half_adder_selector_sc_0/res_stage0 ctrl_sign downstepper_test VDD_3V3_uq0 pfet_06v0 ad=46.849n pd=1.361m as=42.856n ps=1.326m w=244 l=100
X12 ternary_output ctrl_over 5v0_half_adder_selector_sc_0/res_stage0 VSS nfet_06v0 ad=17.057n pd=0.537m as=0 ps=0 w=164 l=120
X13 ternary_output ctrl_over ternary_input VDD_3V3 pfet_06v0 ad=25.377n pd=0.697m as=21.472n ps=0.664m w=244 l=100
X14 5v0_half_adder_selector_sc_0/m1_n244_n517# ctrl_over VSS VSS nfet_06v0 ad=14.432n pd=0.504m as=99.96301n ps=3.526m w=164 l=120
X15 5v0_half_adder_selector_sc_0/m1_n244_n517# ctrl_over VDD_3V3 VDD_3V3 pfet_06v0 ad=21.472n pd=0.664m as=42.857n ps=1.327m w=244 l=100
X16 ternary_output 5v0_half_adder_selector_sc_0/m1_n244_n517# ternary_input VSS nfet_06v0 ad=0 pd=0 as=14.432n ps=0.504m w=164 l=120
X17 ternary_output 5v0_half_adder_selector_sc_0/m1_n244_n517# 5v0_half_adder_selector_sc_0/res_stage0 VDD_3V3 pfet_06v0 ad=0 pd=0 as=0 ps=0 w=244 l=100
X18 inv_pti pti VSS VSS nfet_06v0 ad=14.432n pd=0.504m as=14.432n ps=0.504m w=164 l=120
X19 inv_pti pti VDD_3V3_uq0 VDD_3V3_uq0 pfet_06v0 ad=21.472n pd=0.664m as=21.472n ps=0.664m w=244 l=100
X20 a_n1373_n454# inv_nti downstepper_test VSS nfet_06v0 ad=3.528n pd=0.195m as=8.599n ps=0.264m w=147 l=120
X21 upstepper_test nti a_n1205_n937# VDD_3V3 pfet_06v0 ad=21.384n pd=0.662m as=5.832n ps=0.291m w=243 l=100
X22 inv_nti nti VDD_3V3 VDD_3V3 pfet_06v0 ad=21.472n pd=0.664m as=21.472n ps=0.664m w=244 l=100
X23 upstepper_test nti VDD_1V65 VSS nfet_06v0 ad=14.847n pd=0.496m as=10.51n ps=0.29m w=147 l=120
X24 a_n1205_n937# inv_pti VDD_3V3 VDD_3V3 pfet_06v0 ad=5.832n pd=0.291m as=21.384n ps=0.662m w=243 l=100
X25 downstepper_test pti a_n1778_n454# VSS nfet_06v0 ad=8.599n pd=0.264m as=3.528n ps=0.195m w=147 l=120
X26 inv_nti nti VSS VSS nfet_06v0 ad=14.432n pd=0.504m as=14.432n ps=0.504m w=164 l=120
X27 a_n1778_n454# inv_nti VSS VSS nfet_06v0 ad=3.528n pd=0.195m as=14.847n ps=0.496m w=147 l=120
X28 upstepper_test inv_pti VSS VSS nfet_06v0 ad=14.432n pd=0.504m as=14.432n ps=0.504m w=164 l=120
X29 VDD_1V65 inv_pti a_n1373_n454# VSS nfet_06v0 ad=10.51n pd=0.29m as=3.528n ps=0.195m w=147 l=120
X30 downstepper_test inv_nti VDD_3V3 VDD_3V3 pfet_06v0 ad=21.384n pd=0.662m as=21.384n ps=0.662m w=243 l=100
C0 a_n1373_n454# VDD_3V3 0.00122f
C1 ternary_output 5v0_half_adder_selector_sc_0/m1_n244_n517# 0.23201f
C2 5v0_half_adder_selector_sc_0/5v0_tgate_sel_2_sc_1/input_A VDD_3V3 0.03098f
C3 ctrl_over 5v0_half_adder_selector_sc_0/res_stage0 0.04907f
C4 ternary_output VDD_3V3 0.15496f
C5 inv_nti VDD_3V3 0.55403f
C6 ternary_input 5v0_half_adder_selector_sc_0/m1_n244_n517# 0.13297f
C7 5v0_half_adder_selector_sc_0/m1_n244_n517# upstepper_test 0.00167f
C8 VDD_3V3_uq0 nti 0.16194f
C9 a_n1778_n454# nti 0.00142f
C10 a_n1373_n454# downstepper_test 0.00442f
C11 downstepper_test 5v0_half_adder_selector_sc_0/5v0_tgate_sel_2_sc_1/input_A 0
C12 a_n1205_n937# nti 0
C13 ternary_input VDD_3V3 0.15325f
C14 upstepper_test VDD_3V3 0.13823f
C15 ternary_output downstepper_test 0.00248f
C16 inv_nti downstepper_test 0.1819f
C17 ctrl_over 5v0_half_adder_selector_sc_0/m1_n239_179# 0.00486f
C18 downstepper_test ternary_input 0.16659f
C19 VDD_1V65 inv_pti 0.14775f
C20 downstepper_test upstepper_test 0.38867f
C21 inv_pti pti 0.19351f
C22 5v0_half_adder_selector_sc_0/res_stage0 nti 0.00372f
C23 ternary_output VDD_3V3_uq0 0
C24 inv_nti VDD_3V3_uq0 0.00196f
C25 a_n1778_n454# inv_nti 0.00214f
C26 a_n1205_n937# inv_nti 0
C27 ctrl_over ctrl_sign 0.01302f
C28 VDD_3V3_uq0 ternary_input 0.93054f
C29 a_n1778_n454# ternary_input 0.00116f
C30 a_n1205_n937# ternary_input 0
C31 VDD_3V3_uq0 upstepper_test 0.33323f
C32 a_n1778_n454# upstepper_test 0
C33 5v0_half_adder_selector_sc_0/m1_n244_n517# VDD_3V3 0.27028f
C34 a_n1205_n937# upstepper_test 0.00334f
C35 inv_pti nti 0.21873f
C36 5v0_half_adder_selector_sc_0/res_stage0 5v0_half_adder_selector_sc_0/5v0_tgate_sel_2_sc_1/input_A 0.00385f
C37 ctrl_sign pti 0
C38 5v0_half_adder_selector_sc_0/res_stage0 ternary_output 0.11993f
C39 downstepper_test 5v0_half_adder_selector_sc_0/m1_n244_n517# 0.02897f
C40 5v0_half_adder_selector_sc_0/res_stage0 ternary_input 0.28146f
C41 downstepper_test VDD_3V3 0.41008f
C42 5v0_half_adder_selector_sc_0/res_stage0 upstepper_test 0.27475f
C43 inv_pti a_n1373_n454# 0.00135f
C44 ctrl_sign nti 0
C45 inv_pti inv_nti 0.08256f
C46 VDD_3V3_uq0 5v0_half_adder_selector_sc_0/m1_n244_n517# 0
C47 ternary_input 5v0_half_adder_selector_sc_0/m1_n239_179# 0.00191f
C48 inv_pti ternary_input 0.08498f
C49 VDD_3V3_uq0 VDD_3V3 0
C50 upstepper_test 5v0_half_adder_selector_sc_0/m1_n239_179# 0.07502f
C51 inv_pti upstepper_test 0.0467f
C52 a_n1205_n937# VDD_3V3 0.00891f
C53 ctrl_sign 5v0_half_adder_selector_sc_0/5v0_tgate_sel_2_sc_1/input_A 0
C54 ctrl_sign ternary_output 0
C55 VDD_3V3_uq0 downstepper_test 0.10943f
C56 a_n1778_n454# downstepper_test 0.0031f
C57 VDD_1V65 pti 0.00115f
C58 5v0_half_adder_selector_sc_0/res_stage0 5v0_half_adder_selector_sc_0/m1_n244_n517# 0.14284f
C59 a_n1205_n937# downstepper_test 0.00453f
C60 ctrl_sign ternary_input 0.00264f
C61 5v0_half_adder_selector_sc_0/res_stage0 VDD_3V3 0.13661f
C62 ctrl_sign upstepper_test 0.08746f
C63 5v0_half_adder_selector_sc_0/m1_n244_n517# 5v0_half_adder_selector_sc_0/m1_n239_179# 0.00395f
C64 inv_pti 5v0_half_adder_selector_sc_0/m1_n244_n517# 0
C65 VDD_1V65 nti 0.21326f
C66 5v0_half_adder_selector_sc_0/res_stage0 downstepper_test 0.25302f
C67 pti nti 0.1782f
C68 VDD_3V3 5v0_half_adder_selector_sc_0/m1_n239_179# 0.00154f
C69 inv_pti VDD_3V3 0.1674f
C70 ctrl_over 5v0_half_adder_selector_sc_0/5v0_tgate_sel_2_sc_1/input_A 0.01944f
C71 ctrl_over ternary_output 0.18581f
C72 5v0_half_adder_selector_sc_0/res_stage0 VDD_3V3_uq0 0.02483f
C73 VDD_1V65 a_n1373_n454# 0.00232f
C74 downstepper_test 5v0_half_adder_selector_sc_0/m1_n239_179# 0.09961f
C75 inv_pti downstepper_test 0.07797f
C76 5v0_half_adder_selector_sc_0/res_stage0 a_n1205_n937# 0
C77 ctrl_sign 5v0_half_adder_selector_sc_0/m1_n244_n517# 0.0109f
C78 a_n1373_n454# pti 0
C79 VDD_1V65 inv_nti 0.01114f
C80 ctrl_sign VDD_3V3 0
C81 ctrl_over ternary_input 0.0727f
C82 pti inv_nti 0.11055f
C83 ctrl_over upstepper_test 0
C84 VDD_1V65 ternary_input 0.03394f
C85 VDD_3V3_uq0 5v0_half_adder_selector_sc_0/m1_n239_179# 0.28989f
C86 VDD_1V65 upstepper_test 0.16859f
C87 inv_pti VDD_3V3_uq0 0.23112f
C88 pti ternary_input 0.54978f
C89 pti upstepper_test 0
C90 ctrl_sign downstepper_test 0.14523f
C91 a_n1373_n454# nti 0
C92 ternary_output nti 0
C93 inv_nti nti 0.20874f
C94 ternary_input nti 0.61523f
C95 ctrl_sign VDD_3V3_uq0 0.38402f
C96 5v0_half_adder_selector_sc_0/res_stage0 5v0_half_adder_selector_sc_0/m1_n239_179# 0.18379f
C97 5v0_half_adder_selector_sc_0/res_stage0 inv_pti 0
C98 upstepper_test nti 0.11981f
C99 ctrl_over 5v0_half_adder_selector_sc_0/m1_n244_n517# 0.37702f
C100 a_n1373_n454# inv_nti 0
C101 ctrl_over VDD_3V3 0.40911f
C102 VDD_1V65 5v0_half_adder_selector_sc_0/m1_n244_n517# 0
C103 pti 5v0_half_adder_selector_sc_0/m1_n244_n517# 0
C104 a_n1373_n454# ternary_input 0.00136f
C105 VDD_1V65 VDD_3V3 0.04703f
C106 inv_pti 5v0_half_adder_selector_sc_0/m1_n239_179# 0
C107 a_n1373_n454# upstepper_test 0
C108 upstepper_test 5v0_half_adder_selector_sc_0/5v0_tgate_sel_2_sc_1/input_A 0
C109 pti VDD_3V3 0.02893f
C110 5v0_half_adder_selector_sc_0/res_stage0 ctrl_sign 0.22345f
C111 ternary_output ternary_input 0.19159f
C112 inv_nti ternary_input 0.02537f
C113 ctrl_over downstepper_test 0.00206f
C114 ternary_output upstepper_test 0
C115 inv_nti upstepper_test 0.0011f
C116 VDD_1V65 downstepper_test 0.13024f
C117 5v0_half_adder_selector_sc_0/m1_n244_n517# nti 0.00226f
C118 pti downstepper_test 0.08313f
C119 ternary_input upstepper_test 0.02545f
C120 ctrl_sign 5v0_half_adder_selector_sc_0/m1_n239_179# 0.30291f
C121 VDD_3V3 nti 0.41493f
C122 ctrl_sign inv_pti 0.00263f
C123 ctrl_over VDD_3V3_uq0 0.0015f
C124 VDD_1V65 VDD_3V3_uq0 0
C125 VDD_1V65 a_n1778_n454# 0
C126 VDD_1V65 a_n1205_n937# 0.00354f
C127 pti VDD_3V3_uq0 0.54139f
C128 a_n1778_n454# pti 0.00135f
C129 5v0_half_adder_selector_sc_0/m1_n244_n517# 5v0_half_adder_selector_sc_0/5v0_tgate_sel_2_sc_1/input_A 0.07353f
C130 downstepper_test nti 0.07205f
C131 pti VSS 0.62139f
C132 VDD_1V65 VSS 0.09068f
C133 inv_nti VSS 0.5358f
C134 inv_pti VSS 0.6002f
C135 a_n1205_n937# VSS 0 ; **FLOATING
C136 a_n1373_n454# VSS 0.00335f ; **FLOATING
C137 a_n1778_n454# VSS 0.00573f ; **FLOATING
C138 5v0_half_adder_selector_sc_0/5v0_tgate_sel_2_sc_1/input_A VSS 0
C139 ctrl_over VSS 0.55135f
C140 ternary_input VSS 1.93066f
C141 ternary_output VSS 0.28152f
C142 5v0_half_adder_selector_sc_0/m1_n244_n517# VSS 0.39366f ; **FLOATING
C143 VDD_3V3 VSS 4.05558f
C144 5v0_half_adder_selector_sc_0/m1_n239_179# VSS 0.30065f ; **FLOATING
C145 5v0_half_adder_selector_sc_0/res_stage0 VSS 0.50953f
C146 downstepper_test VSS 0.64132f
C147 ctrl_sign VSS 0.56557f
C148 VDD_3V3_uq0 VSS 6.35626f
C149 upstepper_test VSS 0.54838f
C150 nti VSS 1.27643f
