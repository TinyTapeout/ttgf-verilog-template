* NGSPICE file created from 5v0_add_q_sc.ext - technology: gf180mcuD

.option scale=5n

X0 pti ternary_input VSS VSS nfet_06v0 ad=6.336n pd=0.32m as=6.478n ps=0.255m w=72 l=578
X1 VDD_3V3_uq0 ternary_input pti VDD_3V3_uq0 pfet_06v0 ad=12.81n pd=0.349m as=12.688n ps=0.348m w=244 l=100
X2 VDD_3V3_uq0 ternary_input nti VDD_3V3_uq0 pfet_06v0 ad=13.616n pd=0.392m as=9.696n ps=0.394m w=96 l=150
X3 VSS ternary_input nti VSS nfet_06v0 ad=6.478n pd=0.255m as=12.7n ps=0.454m w=127 l=120
X4 pti ternary_input VDD_3V3_uq0 VDD_3V3_uq0 pfet_06v0 ad=12.688n pd=0.348m as=13.616n ps=0.392m w=244 l=100
X5 pti ternary_input VDD_3V3_uq0 VDD_3V3_uq0 pfet_06v0 ad=27.328n pd=0.712m as=12.81n ps=0.349m w=244 l=100
X6 5v0_half_adder_selector_sc_0/res_stage0 5v0_half_adder_selector_sc_0/m1_n239_179# downstepper_test VSS nfet_06v0 ad=14.432n pd=0.504m as=14.432n ps=0.504m w=164 l=120
X7 5v0_half_adder_selector_sc_0/res_stage0 5v0_half_adder_selector_sc_0/m1_n239_179# upstepper_test VDD_3V3_uq0 pfet_06v0 ad=21.472n pd=0.664m as=21.472n ps=0.664m w=244 l=100
X8 5v0_half_adder_selector_sc_0/m1_n239_179# ctrl_sign VSS VSS nfet_06v0 ad=14.432n pd=0.504m as=14.432n ps=0.504m w=164 l=120
X9 5v0_half_adder_selector_sc_0/m1_n239_179# ctrl_sign VDD_3V3_uq0 VDD_3V3_uq0 pfet_06v0 ad=21.472n pd=0.664m as=21.472n ps=0.664m w=244 l=100
X10 5v0_half_adder_selector_sc_0/res_stage0 ctrl_sign upstepper_test VSS nfet_06v0 ad=31.489n pd=1.041m as=43.711n ps=1.504m w=164 l=120
X11 5v0_half_adder_selector_sc_0/res_stage0 ctrl_sign downstepper_test VDD_3V3_uq0 pfet_06v0 ad=46.849n pd=1.361m as=42.856n ps=1.326m w=244 l=100
X12 ternary_output ctrl_over 5v0_half_adder_selector_sc_0/res_stage0 VSS nfet_06v0 ad=17.057n pd=0.537m as=0 ps=0 w=164 l=120
X13 ternary_output ctrl_over ternary_input VDD_3V3 pfet_06v0 ad=25.377n pd=0.697m as=21.472n ps=0.664m w=244 l=100
X14 5v0_half_adder_selector_sc_0/m1_n244_n517# ctrl_over VSS VSS nfet_06v0 ad=14.432n pd=0.504m as=99.96301n ps=3.526m w=164 l=120
X15 5v0_half_adder_selector_sc_0/m1_n244_n517# ctrl_over VDD_3V3 VDD_3V3 pfet_06v0 ad=21.472n pd=0.664m as=42.857n ps=1.327m w=244 l=100
X16 ternary_output 5v0_half_adder_selector_sc_0/m1_n244_n517# ternary_input VSS nfet_06v0 ad=0 pd=0 as=14.432n ps=0.504m w=164 l=120
X17 ternary_output 5v0_half_adder_selector_sc_0/m1_n244_n517# 5v0_half_adder_selector_sc_0/res_stage0 VDD_3V3 pfet_06v0 ad=0 pd=0 as=0 ps=0 w=244 l=100
X18 inv_pti pti VSS VSS nfet_06v0 ad=14.432n pd=0.504m as=14.432n ps=0.504m w=164 l=120
X19 inv_pti pti VDD_3V3_uq0 VDD_3V3_uq0 pfet_06v0 ad=21.472n pd=0.664m as=21.472n ps=0.664m w=244 l=100
X20 a_n1373_n454# inv_nti downstepper_test VSS nfet_06v0 ad=3.528n pd=0.195m as=8.599n ps=0.264m w=147 l=120
X21 upstepper_test nti a_n1205_n937# VDD_3V3 pfet_06v0 ad=21.384n pd=0.662m as=5.832n ps=0.291m w=243 l=100
X22 inv_nti nti VDD_3V3 VDD_3V3 pfet_06v0 ad=21.472n pd=0.664m as=21.472n ps=0.664m w=244 l=100
X23 upstepper_test nti VDD_1V65 VSS nfet_06v0 ad=14.847n pd=0.496m as=10.51n ps=0.29m w=147 l=120
X24 a_n1205_n937# inv_pti VDD_3V3 VDD_3V3 pfet_06v0 ad=5.832n pd=0.291m as=21.384n ps=0.662m w=243 l=100
X25 downstepper_test pti a_n1778_n454# VSS nfet_06v0 ad=8.599n pd=0.264m as=3.528n ps=0.195m w=147 l=120
X26 inv_nti nti VSS VSS nfet_06v0 ad=14.432n pd=0.504m as=14.432n ps=0.504m w=164 l=120
X27 a_n1778_n454# inv_nti VSS VSS nfet_06v0 ad=3.528n pd=0.195m as=14.847n ps=0.496m w=147 l=120
X28 upstepper_test inv_pti VSS VSS nfet_06v0 ad=14.432n pd=0.504m as=14.432n ps=0.504m w=164 l=120
X29 VDD_1V65 inv_pti a_n1373_n454# VSS nfet_06v0 ad=10.51n pd=0.29m as=3.528n ps=0.195m w=147 l=120
X30 downstepper_test inv_nti VDD_3V3 VDD_3V3 pfet_06v0 ad=21.384n pd=0.662m as=21.384n ps=0.662m w=243 l=100
C0 VDD_3V3_uq0 pti 0.54139f
C1 5v0_half_adder_selector_sc_0/res_stage0 a_n1205_n937# 0
C2 upstepper_test a_n1205_n937# 0.00334f
C3 5v0_half_adder_selector_sc_0/res_stage0 VDD_3V3_uq0 0.02483f
C4 a_n1373_n454# inv_nti 0
C5 VDD_3V3_uq0 upstepper_test 0.33323f
C6 a_n1373_n454# ternary_input 0.00136f
C7 inv_nti nti 0.20874f
C8 a_n1373_n454# VDD_1V65 0.00232f
C9 ternary_input nti 0.61523f
C10 inv_pti inv_nti 0.08256f
C11 VDD_1V65 nti 0.21326f
C12 5v0_half_adder_selector_sc_0/5v0_tgate_sel_2_sc_1/input_A 5v0_half_adder_selector_sc_0/m1_n244_n517# 0.07353f
C13 a_n1373_n454# VDD_3V3 0.00122f
C14 ternary_input 5v0_half_adder_selector_sc_0/m1_n244_n517# 0.13297f
C15 inv_pti ternary_input 0.08498f
C16 5v0_half_adder_selector_sc_0/m1_n244_n517# VDD_1V65 0
C17 inv_pti VDD_1V65 0.14775f
C18 VDD_3V3 nti 0.41493f
C19 ctrl_over 5v0_half_adder_selector_sc_0/m1_n244_n517# 0.37702f
C20 5v0_half_adder_selector_sc_0/m1_n244_n517# VDD_3V3 0.27028f
C21 inv_pti VDD_3V3 0.1674f
C22 ctrl_sign pti 0
C23 a_n1778_n454# pti 0.00135f
C24 5v0_half_adder_selector_sc_0/res_stage0 ctrl_sign 0.22345f
C25 ctrl_sign upstepper_test 0.08746f
C26 downstepper_test inv_nti 0.1819f
C27 a_n1778_n454# upstepper_test 0
C28 ternary_input downstepper_test 0.16659f
C29 downstepper_test 5v0_half_adder_selector_sc_0/5v0_tgate_sel_2_sc_1/input_A 0
C30 downstepper_test VDD_1V65 0.13024f
C31 pti upstepper_test 0
C32 a_n1373_n454# nti 0
C33 ctrl_over downstepper_test 0.00206f
C34 ternary_input 5v0_half_adder_selector_sc_0/m1_n239_179# 0.00191f
C35 downstepper_test VDD_3V3 0.41008f
C36 5v0_half_adder_selector_sc_0/res_stage0 upstepper_test 0.27475f
C37 a_n1373_n454# inv_pti 0.00135f
C38 5v0_half_adder_selector_sc_0/m1_n244_n517# nti 0.00226f
C39 inv_pti nti 0.21873f
C40 ctrl_over 5v0_half_adder_selector_sc_0/m1_n239_179# 0.00486f
C41 VDD_3V3 5v0_half_adder_selector_sc_0/m1_n239_179# 0.00154f
C42 ternary_output ternary_input 0.19159f
C43 inv_pti 5v0_half_adder_selector_sc_0/m1_n244_n517# 0
C44 ternary_output ctrl_over 0.18581f
C45 ternary_output VDD_3V3 0.15496f
C46 a_n1205_n937# inv_nti 0
C47 VDD_3V3_uq0 inv_nti 0.00196f
C48 ternary_input a_n1205_n937# 0
C49 VDD_1V65 a_n1205_n937# 0.00354f
C50 a_n1373_n454# downstepper_test 0.00442f
C51 ternary_input VDD_3V3_uq0 0.93054f
C52 VDD_3V3_uq0 VDD_1V65 0
C53 downstepper_test nti 0.07205f
C54 VDD_3V3 a_n1205_n937# 0.00891f
C55 downstepper_test 5v0_half_adder_selector_sc_0/m1_n244_n517# 0.02897f
C56 inv_pti downstepper_test 0.07797f
C57 ctrl_over VDD_3V3_uq0 0.0015f
C58 VDD_3V3 VDD_3V3_uq0 0
C59 5v0_half_adder_selector_sc_0/m1_n244_n517# 5v0_half_adder_selector_sc_0/m1_n239_179# 0.00395f
C60 inv_pti 5v0_half_adder_selector_sc_0/m1_n239_179# 0
C61 ternary_output nti 0
C62 ternary_output 5v0_half_adder_selector_sc_0/m1_n244_n517# 0.23201f
C63 a_n1778_n454# inv_nti 0.00214f
C64 ternary_input ctrl_sign 0.00264f
C65 ctrl_sign 5v0_half_adder_selector_sc_0/5v0_tgate_sel_2_sc_1/input_A 0
C66 a_n1778_n454# ternary_input 0.00116f
C67 a_n1778_n454# VDD_1V65 0
C68 a_n1205_n937# nti 0
C69 pti inv_nti 0.11055f
C70 VDD_3V3_uq0 nti 0.16194f
C71 ctrl_over ctrl_sign 0.01302f
C72 ctrl_sign VDD_3V3 0
C73 ternary_input pti 0.54978f
C74 downstepper_test 5v0_half_adder_selector_sc_0/m1_n239_179# 0.09961f
C75 VDD_1V65 pti 0.00115f
C76 5v0_half_adder_selector_sc_0/m1_n244_n517# VDD_3V3_uq0 0
C77 inv_pti VDD_3V3_uq0 0.23112f
C78 upstepper_test inv_nti 0.0011f
C79 5v0_half_adder_selector_sc_0/res_stage0 5v0_half_adder_selector_sc_0/5v0_tgate_sel_2_sc_1/input_A 0.00385f
C80 5v0_half_adder_selector_sc_0/res_stage0 ternary_input 0.28146f
C81 ternary_input upstepper_test 0.02545f
C82 5v0_half_adder_selector_sc_0/5v0_tgate_sel_2_sc_1/input_A upstepper_test 0
C83 VDD_3V3 pti 0.02893f
C84 VDD_1V65 upstepper_test 0.16859f
C85 ternary_output downstepper_test 0.00248f
C86 ctrl_over 5v0_half_adder_selector_sc_0/res_stage0 0.04907f
C87 5v0_half_adder_selector_sc_0/res_stage0 VDD_3V3 0.13661f
C88 ctrl_over upstepper_test 0
C89 VDD_3V3 upstepper_test 0.13823f
C90 downstepper_test a_n1205_n937# 0.00453f
C91 downstepper_test VDD_3V3_uq0 0.10943f
C92 ctrl_sign nti 0
C93 a_n1778_n454# nti 0.00142f
C94 ctrl_sign 5v0_half_adder_selector_sc_0/m1_n244_n517# 0.0109f
C95 inv_pti ctrl_sign 0.00263f
C96 a_n1373_n454# pti 0
C97 VDD_3V3_uq0 5v0_half_adder_selector_sc_0/m1_n239_179# 0.28989f
C98 pti nti 0.1782f
C99 a_n1373_n454# upstepper_test 0
C100 5v0_half_adder_selector_sc_0/m1_n244_n517# pti 0
C101 inv_pti pti 0.19351f
C102 5v0_half_adder_selector_sc_0/res_stage0 nti 0.00372f
C103 ternary_output VDD_3V3_uq0 0
C104 upstepper_test nti 0.11981f
C105 5v0_half_adder_selector_sc_0/res_stage0 5v0_half_adder_selector_sc_0/m1_n244_n517# 0.14284f
C106 inv_pti 5v0_half_adder_selector_sc_0/res_stage0 0
C107 5v0_half_adder_selector_sc_0/m1_n244_n517# upstepper_test 0.00167f
C108 inv_pti upstepper_test 0.0467f
C109 downstepper_test ctrl_sign 0.14523f
C110 a_n1778_n454# downstepper_test 0.0031f
C111 ctrl_sign 5v0_half_adder_selector_sc_0/m1_n239_179# 0.30291f
C112 downstepper_test pti 0.08313f
C113 5v0_half_adder_selector_sc_0/res_stage0 downstepper_test 0.25302f
C114 downstepper_test upstepper_test 0.38867f
C115 ternary_input inv_nti 0.02537f
C116 ternary_output ctrl_sign 0
C117 VDD_1V65 inv_nti 0.01114f
C118 ternary_input VDD_1V65 0.03394f
C119 5v0_half_adder_selector_sc_0/res_stage0 5v0_half_adder_selector_sc_0/m1_n239_179# 0.18379f
C120 5v0_half_adder_selector_sc_0/m1_n239_179# upstepper_test 0.07502f
C121 VDD_3V3 inv_nti 0.55403f
C122 ctrl_over 5v0_half_adder_selector_sc_0/5v0_tgate_sel_2_sc_1/input_A 0.01944f
C123 ctrl_over ternary_input 0.0727f
C124 5v0_half_adder_selector_sc_0/5v0_tgate_sel_2_sc_1/input_A VDD_3V3 0.03098f
C125 ternary_input VDD_3V3 0.15325f
C126 VDD_3V3 VDD_1V65 0.04703f
C127 ternary_output 5v0_half_adder_selector_sc_0/res_stage0 0.11993f
C128 ternary_output upstepper_test 0
C129 ctrl_sign VDD_3V3_uq0 0.38402f
C130 ctrl_over VDD_3V3 0.40911f
C131 pti VSS 0.62139f
C132 VDD_1V65 VSS 0.09068f
C133 inv_nti VSS 0.5358f
C134 inv_pti VSS 0.6002f
C135 a_n1205_n937# VSS 0 ; **FLOATING
C136 a_n1373_n454# VSS 0.00335f ; **FLOATING
C137 a_n1778_n454# VSS 0.00573f ; **FLOATING
C138 5v0_half_adder_selector_sc_0/5v0_tgate_sel_2_sc_1/input_A VSS 0
C139 ctrl_over VSS 0.55135f
C140 ternary_input VSS 1.93066f
C141 ternary_output VSS 0.28152f
C142 5v0_half_adder_selector_sc_0/m1_n244_n517# VSS 0.39366f ; **FLOATING
C143 VDD_3V3 VSS 4.05558f
C144 5v0_half_adder_selector_sc_0/m1_n239_179# VSS 0.30065f ; **FLOATING
C145 5v0_half_adder_selector_sc_0/res_stage0 VSS 0.50953f
C146 downstepper_test VSS 0.64132f
C147 ctrl_sign VSS 0.56557f
C148 VDD_3V3_uq0 VSS 6.35626f
C149 upstepper_test VSS 0.54838f
C150 nti VSS 1.27643f
