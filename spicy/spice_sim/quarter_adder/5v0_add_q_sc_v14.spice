* NGSPICE file created from 5v0_add_q_sc.ext - technology: gf180mcuD

.option scale=5n

X0 pti ternary_input VSS VSS nfet_06v0 ad=6.336n pd=0.32m as=6.336n ps=0.32m w=72 l=578
X1 5v0_nti_sc_f_0/VDD_3V3 ternary_input pti 5v0_nti_sc_f_0/VDD_3V3 pfet_06v0 ad=12.81n pd=0.349m as=12.688n ps=0.348m w=244 l=100
X2 pti ternary_input 5v0_nti_sc_f_0/VDD_3V3 5v0_nti_sc_f_0/VDD_3V3 pfet_06v0 ad=12.688n pd=0.348m as=21.472n ps=0.664m w=244 l=100
X3 pti ternary_input 5v0_nti_sc_f_0/VDD_3V3 5v0_nti_sc_f_0/VDD_3V3 pfet_06v0 ad=27.328n pd=0.712m as=12.81n ps=0.349m w=244 l=100
X4 nti ternary_input VSS VSS nfet_06v0 ad=12.7n pd=0.454m as=11.303n ps=0.432m w=127 l=120
X5 nti ternary_input 5v0_nti_sc_f_0/VDD_3V3 5v0_nti_sc_f_0/VDD_3V3 pfet_06v0 ad=9.696n pd=0.394m as=8.928n ps=0.378m w=96 l=150
X6 5v0_half_adder_selector_sc_0/res_stage0 5v0_half_adder_selector_sc_0/m1_n239_179# downstepper_test VSS nfet_06v0 ad=14.432n pd=0.504m as=14.432n ps=0.504m w=164 l=120
X7 5v0_half_adder_selector_sc_0/res_stage0 5v0_half_adder_selector_sc_0/m1_n239_179# upstepper_test 5v0_nti_sc_f_0/VDD_3V3 pfet_06v0 ad=21.472n pd=0.664m as=21.472n ps=0.664m w=244 l=100
X8 5v0_half_adder_selector_sc_0/m1_n239_179# ctrl_sign VSS VSS nfet_06v0 ad=14.432n pd=0.504m as=14.432n ps=0.504m w=164 l=120
X9 5v0_half_adder_selector_sc_0/m1_n239_179# ctrl_sign 5v0_nti_sc_f_0/VDD_3V3 5v0_nti_sc_f_0/VDD_3V3 pfet_06v0 ad=21.472n pd=0.664m as=21.472n ps=0.664m w=244 l=100
X10 5v0_half_adder_selector_sc_0/res_stage0 ctrl_sign upstepper_test VSS nfet_06v0 ad=31.489n pd=1.041m as=43.711n ps=1.504m w=164 l=120
X11 5v0_half_adder_selector_sc_0/res_stage0 ctrl_sign downstepper_test 5v0_nti_sc_f_0/VDD_3V3 pfet_06v0 ad=46.849n pd=1.361m as=42.856n ps=1.326m w=244 l=100
X12 ternary_output 5v0_half_adder_selector_sc_0/ctrl_over 5v0_half_adder_selector_sc_0/res_stage0 VSS nfet_06v0 ad=17.057n pd=0.537m as=0 ps=0 w=164 l=120
X13 ternary_output 5v0_half_adder_selector_sc_0/ctrl_over ternary_input VDD_3V3 pfet_06v0 ad=25.377n pd=0.697m as=21.472n ps=0.664m w=244 l=100
X14 5v0_half_adder_selector_sc_0/m1_n244_n517# 5v0_half_adder_selector_sc_0/ctrl_over VSS VSS nfet_06v0 ad=14.432n pd=0.504m as=0.10465u ps=3.768m w=164 l=120
X15 5v0_half_adder_selector_sc_0/m1_n244_n517# 5v0_half_adder_selector_sc_0/ctrl_over VDD_3V3 VDD_3V3 pfet_06v0 ad=21.472n pd=0.664m as=85.71201n ps=2.652m w=244 l=100
X16 ternary_output 5v0_half_adder_selector_sc_0/m1_n244_n517# ternary_input VSS nfet_06v0 ad=0 pd=0 as=14.432n ps=0.504m w=164 l=120
X17 ternary_output 5v0_half_adder_selector_sc_0/m1_n244_n517# 5v0_half_adder_selector_sc_0/res_stage0 VDD_3V3 pfet_06v0 ad=0 pd=0 as=0 ps=0 w=244 l=100
X18 inv_pti pti VSS VSS nfet_06v0 ad=14.432n pd=0.504m as=14.432n ps=0.504m w=164 l=120
X19 inv_pti pti 5v0_nti_sc_f_0/VDD_3V3 5v0_nti_sc_f_0/VDD_3V3 pfet_06v0 ad=21.472n pd=0.664m as=21.472n ps=0.664m w=244 l=100
X20 inv_nti nti VSS VSS nfet_06v0 ad=14.432n pd=0.504m as=0 ps=0 w=164 l=120
X21 inv_nti nti VDD_3V3 VDD_3V3 pfet_06v0 ad=21.472n pd=0.664m as=0 ps=0 w=244 l=100
X22 a_n1373_n454# inv_nti downstepper_test VSS nfet_06v0 ad=3.528n pd=0.195m as=8.599n ps=0.264m w=147 l=120
X23 upstepper_test nti a_n1205_n937# VDD_3V3 pfet_06v0 ad=21.384n pd=0.662m as=5.832n ps=0.291m w=243 l=100
X24 upstepper_test nti VDD_1V65 VSS nfet_06v0 ad=14.847n pd=0.496m as=10.51n ps=0.29m w=147 l=120
X25 a_n1205_n937# inv_pti VDD_3V3 VDD_3V3 pfet_06v0 ad=5.832n pd=0.291m as=21.384n ps=0.662m w=243 l=100
X26 downstepper_test pti a_n1778_n454# VSS nfet_06v0 ad=8.599n pd=0.264m as=3.528n ps=0.195m w=147 l=120
X27 a_n1778_n454# inv_nti VSS VSS nfet_06v0 ad=3.528n pd=0.195m as=14.847n ps=0.496m w=147 l=120
X28 upstepper_test inv_pti VSS VSS nfet_06v0 ad=14.432n pd=0.504m as=14.432n ps=0.504m w=164 l=120
X29 VDD_1V65 inv_pti a_n1373_n454# VSS nfet_06v0 ad=10.51n pd=0.29m as=3.528n ps=0.195m w=147 l=120
X30 downstepper_test inv_nti VDD_3V3 VDD_3V3 pfet_06v0 ad=21.384n pd=0.662m as=21.384n ps=0.662m w=243 l=100
C0 inv_pti pti 0.19351f
C1 a_n1778_n454# VDD_1V65 0
C2 5v0_half_adder_selector_sc_0/res_stage0 upstepper_test 0.27475f
C3 a_n1373_n454# VDD_1V65 0.00232f
C4 5v0_half_adder_selector_sc_0/res_stage0 5v0_nti_sc_f_0/VDD_3V3 0.02483f
C5 a_n1205_n937# ternary_input 0
C6 a_n1778_n454# upstepper_test 0
C7 VDD_3V3 5v0_half_adder_selector_sc_0/res_stage0 0.13661f
C8 VDD_1V65 upstepper_test 0.16859f
C9 5v0_nti_sc_f_0/VDD_3V3 VDD_1V65 0
C10 a_n1373_n454# upstepper_test 0
C11 inv_nti nti 0.20745f
C12 5v0_half_adder_selector_sc_0/res_stage0 ternary_output 0.11993f
C13 VDD_3V3 VDD_1V65 0.04713f
C14 ternary_input 5v0_half_adder_selector_sc_0/m1_n239_179# 0.00191f
C15 VDD_3V3 a_n1373_n454# 0.00122f
C16 5v0_nti_sc_f_0/VDD_3V3 upstepper_test 0.33323f
C17 5v0_half_adder_selector_sc_0/m1_n244_n517# 5v0_half_adder_selector_sc_0/m1_n239_179# 0.00395f
C18 VDD_3V3 upstepper_test 0.13834f
C19 VDD_3V3 5v0_nti_sc_f_0/VDD_3V3 0
C20 ternary_output upstepper_test 0
C21 ctrl_sign 5v0_half_adder_selector_sc_0/5v0_tgate_sel_2_sc_1/input_A 0
C22 ctrl_sign nti 0
C23 5v0_half_adder_selector_sc_0/res_stage0 ternary_input 0.28146f
C24 inv_nti downstepper_test 0.18136f
C25 VDD_3V3 ternary_output 0.15496f
C26 inv_pti 5v0_half_adder_selector_sc_0/m1_n239_179# 0
C27 nti pti 0.17279f
C28 5v0_half_adder_selector_sc_0/res_stage0 5v0_half_adder_selector_sc_0/m1_n244_n517# 0.14284f
C29 a_n1778_n454# ternary_input 0.00116f
C30 ternary_input VDD_1V65 0.03394f
C31 ternary_input a_n1373_n454# 0.00136f
C32 5v0_half_adder_selector_sc_0/m1_n244_n517# VDD_1V65 0
C33 ternary_input upstepper_test 0.02545f
C34 ternary_input 5v0_nti_sc_f_0/VDD_3V3 0.96005f
C35 5v0_half_adder_selector_sc_0/m1_n244_n517# upstepper_test 0.00167f
C36 inv_pti 5v0_half_adder_selector_sc_0/res_stage0 0
C37 ctrl_sign downstepper_test 0.14523f
C38 5v0_half_adder_selector_sc_0/m1_n244_n517# 5v0_nti_sc_f_0/VDD_3V3 0
C39 5v0_half_adder_selector_sc_0/ctrl_over ctrl_sign 0.01302f
C40 VDD_3V3 ternary_input 0.15434f
C41 downstepper_test pti 0.08313f
C42 VDD_3V3 5v0_half_adder_selector_sc_0/m1_n244_n517# 0.27028f
C43 inv_pti VDD_1V65 0.14775f
C44 ternary_input ternary_output 0.19159f
C45 inv_pti a_n1373_n454# 0.00135f
C46 a_n1205_n937# nti 0
C47 5v0_half_adder_selector_sc_0/m1_n244_n517# ternary_output 0.23201f
C48 inv_pti upstepper_test 0.0467f
C49 inv_pti 5v0_nti_sc_f_0/VDD_3V3 0.23112f
C50 VDD_3V3 inv_pti 0.16742f
C51 ternary_input 5v0_half_adder_selector_sc_0/m1_n244_n517# 0.13297f
C52 a_n1205_n937# downstepper_test 0.00453f
C53 5v0_half_adder_selector_sc_0/res_stage0 5v0_half_adder_selector_sc_0/5v0_tgate_sel_2_sc_1/input_A 0.00385f
C54 nti 5v0_half_adder_selector_sc_0/res_stage0 0.00372f
C55 5v0_half_adder_selector_sc_0/m1_n239_179# downstepper_test 0.09961f
C56 5v0_half_adder_selector_sc_0/ctrl_over 5v0_half_adder_selector_sc_0/m1_n239_179# 0.00486f
C57 nti a_n1778_n454# 0.00123f
C58 nti VDD_1V65 0.21326f
C59 inv_pti ternary_input 0.08497f
C60 nti a_n1373_n454# 0
C61 5v0_half_adder_selector_sc_0/5v0_tgate_sel_2_sc_1/input_A upstepper_test 0
C62 inv_pti 5v0_half_adder_selector_sc_0/m1_n244_n517# 0
C63 nti upstepper_test 0.11981f
C64 VDD_3V3 5v0_half_adder_selector_sc_0/5v0_tgate_sel_2_sc_1/input_A 0.03098f
C65 nti 5v0_nti_sc_f_0/VDD_3V3 0.16211f
C66 VDD_3V3 nti 0.40684f
C67 5v0_half_adder_selector_sc_0/res_stage0 downstepper_test 0.25302f
C68 5v0_half_adder_selector_sc_0/ctrl_over 5v0_half_adder_selector_sc_0/res_stage0 0.04907f
C69 nti ternary_output 0
C70 a_n1778_n454# downstepper_test 0.0031f
C71 downstepper_test VDD_1V65 0.13024f
C72 inv_nti pti 0.10928f
C73 a_n1373_n454# downstepper_test 0.00442f
C74 downstepper_test upstepper_test 0.38867f
C75 5v0_nti_sc_f_0/VDD_3V3 downstepper_test 0.10943f
C76 5v0_half_adder_selector_sc_0/ctrl_over 5v0_nti_sc_f_0/VDD_3V3 0.0015f
C77 VDD_3V3 downstepper_test 0.41098f
C78 5v0_half_adder_selector_sc_0/ctrl_over VDD_3V3 0.40911f
C79 nti ternary_input 0.60908f
C80 5v0_half_adder_selector_sc_0/m1_n244_n517# 5v0_half_adder_selector_sc_0/5v0_tgate_sel_2_sc_1/input_A 0.07353f
C81 downstepper_test ternary_output 0.00248f
C82 ctrl_sign pti 0
C83 5v0_half_adder_selector_sc_0/ctrl_over ternary_output 0.18581f
C84 nti 5v0_half_adder_selector_sc_0/m1_n244_n517# 0.00226f
C85 a_n1205_n937# inv_nti 0
C86 inv_pti nti 0.21872f
C87 ternary_input downstepper_test 0.16661f
C88 5v0_half_adder_selector_sc_0/ctrl_over ternary_input 0.0727f
C89 5v0_half_adder_selector_sc_0/m1_n244_n517# downstepper_test 0.02897f
C90 5v0_half_adder_selector_sc_0/ctrl_over 5v0_half_adder_selector_sc_0/m1_n244_n517# 0.37702f
C91 ctrl_sign 5v0_half_adder_selector_sc_0/m1_n239_179# 0.30291f
C92 inv_pti downstepper_test 0.07797f
C93 inv_nti a_n1778_n454# 0.00212f
C94 inv_nti VDD_1V65 0.01095f
C95 inv_nti a_n1373_n454# 0
C96 inv_nti upstepper_test 0
C97 inv_nti 5v0_nti_sc_f_0/VDD_3V3 0.00196f
C98 ctrl_sign 5v0_half_adder_selector_sc_0/res_stage0 0.22345f
C99 VDD_3V3 inv_nti 0.59815f
C100 a_n1778_n454# pti 0.00135f
C101 VDD_1V65 pti 0.00115f
C102 ctrl_sign upstepper_test 0.08746f
C103 a_n1373_n454# pti 0
C104 ctrl_sign 5v0_nti_sc_f_0/VDD_3V3 0.38402f
C105 downstepper_test 5v0_half_adder_selector_sc_0/5v0_tgate_sel_2_sc_1/input_A 0
C106 pti upstepper_test 0
C107 5v0_half_adder_selector_sc_0/ctrl_over 5v0_half_adder_selector_sc_0/5v0_tgate_sel_2_sc_1/input_A 0.01944f
C108 VDD_3V3 ctrl_sign 0
C109 5v0_nti_sc_f_0/VDD_3V3 pti 0.551f
C110 nti downstepper_test 0.07077f
C111 VDD_3V3 pti 0.02893f
C112 inv_nti ternary_input 0.02714f
C113 a_n1205_n937# 5v0_half_adder_selector_sc_0/res_stage0 0
C114 a_n1205_n937# VDD_1V65 0.00354f
C115 5v0_half_adder_selector_sc_0/res_stage0 5v0_half_adder_selector_sc_0/m1_n239_179# 0.18379f
C116 inv_pti inv_nti 0.08248f
C117 a_n1205_n937# upstepper_test 0.00334f
C118 5v0_half_adder_selector_sc_0/ctrl_over downstepper_test 0.00206f
C119 ctrl_sign ternary_input 0.00264f
C120 ctrl_sign 5v0_half_adder_selector_sc_0/m1_n244_n517# 0.0109f
C121 ternary_input pti 0.5313f
C122 a_n1205_n937# VDD_3V3 0.00891f
C123 5v0_half_adder_selector_sc_0/m1_n244_n517# pti 0
C124 5v0_half_adder_selector_sc_0/m1_n239_179# upstepper_test 0.07502f
C125 5v0_nti_sc_f_0/VDD_3V3 5v0_half_adder_selector_sc_0/m1_n239_179# 0.28989f
C126 VDD_3V3 5v0_half_adder_selector_sc_0/m1_n239_179# 0.00154f
C127 ctrl_sign inv_pti 0.00263f
C128 pti VSS 0.62941f
C129 VDD_1V65 VSS 0.09232f
C130 inv_nti VSS 0.56173f
C131 inv_pti VSS 0.6002f
C132 a_n1205_n937# VSS 0 ; **FLOATING
C133 a_n1373_n454# VSS 0.00335f ; **FLOATING
C134 a_n1778_n454# VSS 0.00573f ; **FLOATING
C135 nti VSS 1.36077f
C136 5v0_nti_sc_f_0/VDD_3V3 VSS 6.27264f
C137 5v0_half_adder_selector_sc_0/5v0_tgate_sel_2_sc_1/input_A VSS 0
C138 5v0_half_adder_selector_sc_0/ctrl_over VSS 0.571f
C139 ternary_input VSS 2.00726f
C140 ternary_output VSS 0.28152f
C141 5v0_half_adder_selector_sc_0/m1_n244_n517# VSS 0.39366f ; **FLOATING
C142 VDD_3V3 VSS 6.2849f
C143 5v0_half_adder_selector_sc_0/m1_n239_179# VSS 0.30065f ; **FLOATING
C144 5v0_half_adder_selector_sc_0/res_stage0 VSS 0.50953f
C145 downstepper_test VSS 0.64154f
C146 ctrl_sign VSS 0.56557f
C147 upstepper_test VSS 0.54918f
