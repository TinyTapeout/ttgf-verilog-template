* NGSPICE file created from 5v0_add_q_sc.ext - technology: gf180mcuD

.option scale=5n

X0 pti ternary_input VSS VSS nfet_06v0 ad=6.336n pd=0.32m as=6.336n ps=0.32m w=72 l=578
X1 VDD_3V3_uq0 ternary_input pti VDD_3V3_uq0 pfet_06v0 ad=12.81n pd=0.349m as=12.688n ps=0.348m w=244 l=100
X2 pti ternary_input VDD_3V3_uq0 VDD_3V3_uq0 pfet_06v0 ad=12.688n pd=0.348m as=21.472n ps=0.664m w=244 l=100
X3 pti ternary_input VDD_3V3_uq0 VDD_3V3_uq0 pfet_06v0 ad=27.328n pd=0.712m as=12.81n ps=0.349m w=244 l=100
X4 nti ternary_input VSS VSS nfet_06v0 ad=12.7n pd=0.454m as=11.303n ps=0.432m w=127 l=120
X5 nti ternary_input VDD_3V3_uq0 VDD_3V3_uq0 pfet_06v0 ad=9.696n pd=0.394m as=8.928n ps=0.378m w=96 l=150
X6 5v0_half_adder_selector_sc_0/res_stage0 5v0_half_adder_selector_sc_0/m1_n239_179# downstepper_test VSS nfet_06v0 ad=14.432n pd=0.504m as=14.432n ps=0.504m w=164 l=120
X7 5v0_half_adder_selector_sc_0/res_stage0 5v0_half_adder_selector_sc_0/m1_n239_179# upstepper_test VDD_3V3_uq0 pfet_06v0 ad=21.472n pd=0.664m as=21.472n ps=0.664m w=244 l=100
X8 5v0_half_adder_selector_sc_0/m1_n239_179# ctrl_sign VSS VSS nfet_06v0 ad=14.432n pd=0.504m as=14.432n ps=0.504m w=164 l=120
X9 5v0_half_adder_selector_sc_0/m1_n239_179# ctrl_sign VDD_3V3_uq0 VDD_3V3_uq0 pfet_06v0 ad=21.472n pd=0.664m as=21.472n ps=0.664m w=244 l=100
X10 5v0_half_adder_selector_sc_0/res_stage0 ctrl_sign upstepper_test VSS nfet_06v0 ad=31.489n pd=1.041m as=43.711n ps=1.504m w=164 l=120
X11 5v0_half_adder_selector_sc_0/res_stage0 ctrl_sign downstepper_test VDD_3V3_uq0 pfet_06v0 ad=46.849n pd=1.361m as=42.856n ps=1.326m w=244 l=100
X12 ternary_output 5v0_half_adder_selector_sc_0/ctrl_over 5v0_half_adder_selector_sc_0/res_stage0 VSS nfet_06v0 ad=17.057n pd=0.537m as=0 ps=0 w=164 l=120
X13 ternary_output 5v0_half_adder_selector_sc_0/ctrl_over ternary_input VDD_3V3 pfet_06v0 ad=25.377n pd=0.697m as=21.472n ps=0.664m w=244 l=100
X14 5v0_half_adder_selector_sc_0/m1_n244_n517# 5v0_half_adder_selector_sc_0/ctrl_over VSS VSS nfet_06v0 ad=14.432n pd=0.504m as=0.10465u ps=3.768m w=164 l=120
X15 5v0_half_adder_selector_sc_0/m1_n244_n517# 5v0_half_adder_selector_sc_0/ctrl_over VDD_3V3 VDD_3V3 pfet_06v0 ad=21.472n pd=0.664m as=85.71201n ps=2.652m w=244 l=100
X16 ternary_output 5v0_half_adder_selector_sc_0/m1_n244_n517# ternary_input VSS nfet_06v0 ad=0 pd=0 as=14.432n ps=0.504m w=164 l=120
X17 ternary_output 5v0_half_adder_selector_sc_0/m1_n244_n517# 5v0_half_adder_selector_sc_0/res_stage0 VDD_3V3 pfet_06v0 ad=0 pd=0 as=0 ps=0 w=244 l=100
X18 a_n1325_n547# pti VSS VSS nfet_06v0 ad=14.432n pd=0.504m as=14.432n ps=0.504m w=164 l=120
X19 a_n1325_n547# pti VDD_3V3_uq0 VDD_3V3_uq0 pfet_06v0 ad=21.472n pd=0.664m as=21.472n ps=0.664m w=244 l=100
X20 a_n1898_n981# nti VSS VSS nfet_06v0 ad=14.432n pd=0.504m as=0 ps=0 w=164 l=120
X21 a_n1898_n981# nti VDD_3V3 VDD_3V3 pfet_06v0 ad=21.472n pd=0.664m as=0 ps=0 w=244 l=100
X22 a_n1373_n454# a_n1898_n981# downstepper_test VSS nfet_06v0 ad=3.528n pd=0.195m as=8.599n ps=0.264m w=147 l=120
X23 upstepper_test nti a_n1205_n937# VDD_3V3 pfet_06v0 ad=21.384n pd=0.662m as=5.832n ps=0.291m w=243 l=100
X24 upstepper_test nti VDD_1V65 VSS nfet_06v0 ad=14.847n pd=0.496m as=10.51n ps=0.29m w=147 l=120
X25 a_n1205_n937# a_n1325_n547# VDD_3V3 VDD_3V3 pfet_06v0 ad=5.832n pd=0.291m as=21.384n ps=0.662m w=243 l=100
X26 downstepper_test pti a_n1778_n454# VSS nfet_06v0 ad=8.599n pd=0.264m as=3.528n ps=0.195m w=147 l=120
X27 a_n1778_n454# a_n1898_n981# VSS VSS nfet_06v0 ad=3.528n pd=0.195m as=14.847n ps=0.496m w=147 l=120
X28 upstepper_test a_n1325_n547# VSS VSS nfet_06v0 ad=14.432n pd=0.504m as=14.432n ps=0.504m w=164 l=120
X29 VDD_1V65 a_n1325_n547# a_n1373_n454# VSS nfet_06v0 ad=10.51n pd=0.29m as=3.528n ps=0.195m w=147 l=120
X30 downstepper_test a_n1898_n981# VDD_3V3 VDD_3V3 pfet_06v0 ad=21.384n pd=0.662m as=21.384n ps=0.662m w=243 l=100
C0 downstepper_test a_n1325_n547# 0.07797f
C1 VDD_1V65 VDD_3V3_uq0 0
C2 pti a_n1325_n547# 0.19351f
C3 ternary_input ternary_output 0.19159f
C4 a_n1373_n454# VDD_3V3 0.00122f
C5 ctrl_sign 5v0_half_adder_selector_sc_0/m1_n244_n517# 0.0109f
C6 VDD_1V65 upstepper_test 0.16859f
C7 5v0_half_adder_selector_sc_0/res_stage0 a_n1325_n547# 0
C8 nti 5v0_half_adder_selector_sc_0/m1_n244_n517# 0.00226f
C9 downstepper_test 5v0_half_adder_selector_sc_0/m1_n244_n517# 0.02897f
C10 a_n1205_n937# ternary_input 0
C11 pti 5v0_half_adder_selector_sc_0/m1_n244_n517# 0
C12 VDD_3V3 ternary_output 0.15496f
C13 5v0_half_adder_selector_sc_0/res_stage0 5v0_half_adder_selector_sc_0/m1_n244_n517# 0.14284f
C14 5v0_half_adder_selector_sc_0/ctrl_over ternary_output 0.18581f
C15 VDD_3V3 5v0_half_adder_selector_sc_0/5v0_tgate_sel_2_sc_1/input_A 0.03098f
C16 5v0_half_adder_selector_sc_0/ctrl_over 5v0_half_adder_selector_sc_0/5v0_tgate_sel_2_sc_1/input_A 0.01944f
C17 a_n1205_n937# VDD_3V3 0.00891f
C18 a_n1898_n981# VDD_1V65 0.01095f
C19 ternary_input VDD_3V3 0.15434f
C20 a_n1373_n454# upstepper_test 0
C21 5v0_half_adder_selector_sc_0/m1_n239_179# ternary_input 0.00191f
C22 VDD_1V65 a_n1778_n454# 0
C23 VDD_1V65 nti 0.21326f
C24 VDD_3V3_uq0 ternary_output 0
C25 ternary_input 5v0_half_adder_selector_sc_0/ctrl_over 0.0727f
C26 VDD_1V65 downstepper_test 0.13024f
C27 pti VDD_1V65 0.00115f
C28 5v0_half_adder_selector_sc_0/m1_n244_n517# a_n1325_n547# 0
C29 upstepper_test ternary_output 0
C30 5v0_half_adder_selector_sc_0/m1_n239_179# VDD_3V3 0.00154f
C31 upstepper_test 5v0_half_adder_selector_sc_0/5v0_tgate_sel_2_sc_1/input_A 0
C32 ternary_input VDD_3V3_uq0 0.96005f
C33 5v0_half_adder_selector_sc_0/ctrl_over VDD_3V3 0.40911f
C34 5v0_half_adder_selector_sc_0/m1_n239_179# 5v0_half_adder_selector_sc_0/ctrl_over 0.00486f
C35 a_n1205_n937# upstepper_test 0.00334f
C36 a_n1898_n981# a_n1373_n454# 0
C37 ternary_input upstepper_test 0.02545f
C38 a_n1373_n454# nti 0
C39 a_n1373_n454# downstepper_test 0.00442f
C40 VDD_3V3_uq0 VDD_3V3 0
C41 a_n1373_n454# pti 0
C42 5v0_half_adder_selector_sc_0/m1_n239_179# VDD_3V3_uq0 0.28989f
C43 VDD_1V65 a_n1325_n547# 0.14775f
C44 5v0_half_adder_selector_sc_0/ctrl_over VDD_3V3_uq0 0.0015f
C45 nti ternary_output 0
C46 downstepper_test ternary_output 0.00248f
C47 VDD_3V3 upstepper_test 0.13834f
C48 ctrl_sign 5v0_half_adder_selector_sc_0/5v0_tgate_sel_2_sc_1/input_A 0
C49 5v0_half_adder_selector_sc_0/m1_n239_179# upstepper_test 0.07502f
C50 downstepper_test 5v0_half_adder_selector_sc_0/5v0_tgate_sel_2_sc_1/input_A 0
C51 a_n1205_n937# a_n1898_n981# 0
C52 VDD_1V65 5v0_half_adder_selector_sc_0/m1_n244_n517# 0
C53 a_n1898_n981# ternary_input 0.02714f
C54 a_n1205_n937# nti 0
C55 5v0_half_adder_selector_sc_0/res_stage0 ternary_output 0.11993f
C56 a_n1205_n937# downstepper_test 0.00453f
C57 ternary_input ctrl_sign 0.00264f
C58 ternary_input a_n1778_n454# 0.00116f
C59 nti ternary_input 0.60908f
C60 ternary_input downstepper_test 0.16661f
C61 5v0_half_adder_selector_sc_0/res_stage0 5v0_half_adder_selector_sc_0/5v0_tgate_sel_2_sc_1/input_A 0.00385f
C62 pti ternary_input 0.5313f
C63 VDD_3V3_uq0 upstepper_test 0.33323f
C64 a_n1205_n937# 5v0_half_adder_selector_sc_0/res_stage0 0
C65 a_n1373_n454# a_n1325_n547# 0.00135f
C66 a_n1898_n981# VDD_3V3 0.59815f
C67 ternary_input 5v0_half_adder_selector_sc_0/res_stage0 0.28146f
C68 ctrl_sign VDD_3V3 0
C69 nti VDD_3V3 0.40684f
C70 5v0_half_adder_selector_sc_0/m1_n239_179# ctrl_sign 0.30291f
C71 VDD_3V3 downstepper_test 0.41098f
C72 5v0_half_adder_selector_sc_0/ctrl_over ctrl_sign 0.01302f
C73 5v0_half_adder_selector_sc_0/m1_n239_179# downstepper_test 0.09961f
C74 pti VDD_3V3 0.02893f
C75 5v0_half_adder_selector_sc_0/ctrl_over downstepper_test 0.00206f
C76 VDD_3V3 5v0_half_adder_selector_sc_0/res_stage0 0.13661f
C77 5v0_half_adder_selector_sc_0/m1_n239_179# 5v0_half_adder_selector_sc_0/res_stage0 0.18379f
C78 a_n1898_n981# VDD_3V3_uq0 0.00196f
C79 5v0_half_adder_selector_sc_0/ctrl_over 5v0_half_adder_selector_sc_0/res_stage0 0.04907f
C80 VDD_3V3_uq0 ctrl_sign 0.38402f
C81 5v0_half_adder_selector_sc_0/m1_n244_n517# ternary_output 0.23201f
C82 nti VDD_3V3_uq0 0.16211f
C83 ternary_input a_n1325_n547# 0.08497f
C84 VDD_3V3_uq0 downstepper_test 0.10943f
C85 5v0_half_adder_selector_sc_0/m1_n244_n517# 5v0_half_adder_selector_sc_0/5v0_tgate_sel_2_sc_1/input_A 0.07353f
C86 a_n1898_n981# upstepper_test 0
C87 pti VDD_3V3_uq0 0.551f
C88 ctrl_sign upstepper_test 0.08746f
C89 a_n1778_n454# upstepper_test 0
C90 nti upstepper_test 0.11981f
C91 downstepper_test upstepper_test 0.38867f
C92 VDD_3V3_uq0 5v0_half_adder_selector_sc_0/res_stage0 0.02483f
C93 ternary_input 5v0_half_adder_selector_sc_0/m1_n244_n517# 0.13297f
C94 pti upstepper_test 0
C95 a_n1373_n454# VDD_1V65 0.00232f
C96 VDD_3V3 a_n1325_n547# 0.16742f
C97 5v0_half_adder_selector_sc_0/m1_n239_179# a_n1325_n547# 0
C98 5v0_half_adder_selector_sc_0/res_stage0 upstepper_test 0.27475f
C99 VDD_3V3 5v0_half_adder_selector_sc_0/m1_n244_n517# 0.27028f
C100 5v0_half_adder_selector_sc_0/m1_n239_179# 5v0_half_adder_selector_sc_0/m1_n244_n517# 0.00395f
C101 a_n1898_n981# a_n1778_n454# 0.00212f
C102 a_n1898_n981# nti 0.20745f
C103 5v0_half_adder_selector_sc_0/ctrl_over 5v0_half_adder_selector_sc_0/m1_n244_n517# 0.37702f
C104 a_n1898_n981# downstepper_test 0.18136f
C105 VDD_3V3_uq0 a_n1325_n547# 0.23112f
C106 nti ctrl_sign 0
C107 nti a_n1778_n454# 0.00123f
C108 a_n1205_n937# VDD_1V65 0.00354f
C109 ctrl_sign downstepper_test 0.14523f
C110 a_n1778_n454# downstepper_test 0.0031f
C111 a_n1898_n981# pti 0.10928f
C112 nti downstepper_test 0.07077f
C113 VDD_1V65 ternary_input 0.03394f
C114 pti ctrl_sign 0
C115 pti a_n1778_n454# 0.00135f
C116 pti nti 0.17279f
C117 upstepper_test a_n1325_n547# 0.0467f
C118 pti downstepper_test 0.08313f
C119 ctrl_sign 5v0_half_adder_selector_sc_0/res_stage0 0.22345f
C120 VDD_3V3_uq0 5v0_half_adder_selector_sc_0/m1_n244_n517# 0
C121 nti 5v0_half_adder_selector_sc_0/res_stage0 0.00372f
C122 downstepper_test 5v0_half_adder_selector_sc_0/res_stage0 0.25302f
C123 VDD_1V65 VDD_3V3 0.04713f
C124 5v0_half_adder_selector_sc_0/m1_n244_n517# upstepper_test 0.00167f
C125 a_n1373_n454# ternary_input 0.00136f
C126 a_n1898_n981# a_n1325_n547# 0.08248f
C127 ctrl_sign a_n1325_n547# 0.00263f
C128 nti a_n1325_n547# 0.21872f
C129 pti VSS 0.62941f
C130 VDD_1V65 VSS 0.09232f
C131 a_n1205_n937# VSS 0 ; **FLOATING
C132 a_n1373_n454# VSS 0.00335f ; **FLOATING
C133 a_n1778_n454# VSS 0.00573f ; **FLOATING
C134 a_n1898_n981# VSS 0.56173f ; **FLOATING
C135 a_n1325_n547# VSS 0.6002f ; **FLOATING
C136 nti VSS 1.36076f
C137 5v0_half_adder_selector_sc_0/5v0_tgate_sel_2_sc_1/input_A VSS 0
C138 5v0_half_adder_selector_sc_0/ctrl_over VSS 0.571f
C139 ternary_input VSS 2.00726f
C140 ternary_output VSS 0.28152f
C141 5v0_half_adder_selector_sc_0/m1_n244_n517# VSS 0.39366f ; **FLOATING
C142 VDD_3V3 VSS 6.28492f
C143 5v0_half_adder_selector_sc_0/m1_n239_179# VSS 0.30065f ; **FLOATING
C144 5v0_half_adder_selector_sc_0/res_stage0 VSS 0.50953f
C145 downstepper_test VSS 0.64154f
C146 ctrl_sign VSS 0.56557f
C147 VDD_3V3_uq0 VSS 6.37693f
C148 upstepper_test VSS 0.54918f
