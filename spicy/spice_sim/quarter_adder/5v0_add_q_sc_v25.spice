* NGSPICE file created from 5v0_add_q_sc.ext - technology: gf180mcuD

.option scale=5n

X0 pti ternary_input VSS VSS nfet_06v0 ad=6.336n pd=0.32m as=6.478n ps=0.255m w=72 l=578
X1 VDD_3V3 ternary_input pti VDD_3V3 pfet_06v0 ad=12.81n pd=0.349m as=12.688n ps=0.348m w=244 l=100
X2 VDD_3V3 ternary_input nti VDD_3V3 pfet_06v0 ad=13.616n pd=0.392m as=9.696n ps=0.394m w=96 l=150
X3 VSS ternary_input nti VSS nfet_06v0 ad=6.478n pd=0.255m as=12.7n ps=0.454m w=127 l=120
X4 pti ternary_input VDD_3V3 VDD_3V3 pfet_06v0 ad=12.688n pd=0.348m as=13.616n ps=0.392m w=244 l=100
X5 pti ternary_input VDD_3V3 VDD_3V3 pfet_06v0 ad=27.328n pd=0.712m as=12.81n ps=0.349m w=244 l=100
X6 5v0_half_adder_selector_sc_0/res_stage0 5v0_half_adder_selector_sc_0/m1_n239_179# downstepper_test VSS nfet_06v0 ad=14.432n pd=0.504m as=14.432n ps=0.504m w=164 l=120
X7 5v0_half_adder_selector_sc_0/res_stage0 5v0_half_adder_selector_sc_0/m1_n239_179# upstepper_test VDD_3V3 pfet_06v0 ad=21.472n pd=0.664m as=21.472n ps=0.664m w=244 l=100
X8 5v0_half_adder_selector_sc_0/m1_n239_179# ctrl_sign VSS VSS nfet_06v0 ad=14.432n pd=0.504m as=14.432n ps=0.504m w=164 l=120
X9 5v0_half_adder_selector_sc_0/m1_n239_179# ctrl_sign VDD_3V3 VDD_3V3 pfet_06v0 ad=21.472n pd=0.664m as=21.472n ps=0.664m w=244 l=100
X10 5v0_half_adder_selector_sc_0/res_stage0 ctrl_sign upstepper_test VSS nfet_06v0 ad=31.489n pd=1.041m as=43.711n ps=1.504m w=164 l=120
X11 5v0_half_adder_selector_sc_0/res_stage0 ctrl_sign downstepper_test VDD_3V3 pfet_06v0 ad=46.849n pd=1.361m as=42.856n ps=1.326m w=244 l=100
X12 ternary_output ctrl_over 5v0_half_adder_selector_sc_0/res_stage0 VSS nfet_06v0 ad=17.057n pd=0.537m as=0 ps=0 w=164 l=120
X13 ternary_output ctrl_over ternary_input VSS_3V3 pfet_06v0 ad=25.377n pd=0.697m as=21.472n ps=0.664m w=244 l=100
X14 5v0_half_adder_selector_sc_0/m1_n244_n517# ctrl_over VSS VSS nfet_06v0 ad=14.432n pd=0.504m as=99.964n ps=3.527m w=164 l=120
X15 5v0_half_adder_selector_sc_0/m1_n244_n517# ctrl_over VSS_3V3 VSS_3V3 pfet_06v0 ad=21.472n pd=0.664m as=85.713n ps=2.653m w=244 l=100
X16 ternary_output 5v0_half_adder_selector_sc_0/m1_n244_n517# ternary_input VSS nfet_06v0 ad=0 pd=0 as=14.432n ps=0.504m w=164 l=120
X17 ternary_output 5v0_half_adder_selector_sc_0/m1_n244_n517# 5v0_half_adder_selector_sc_0/res_stage0 VSS_3V3 pfet_06v0 ad=0 pd=0 as=0 ps=0 w=244 l=100
X18 inv_pti pti VSS VSS nfet_06v0 ad=14.432n pd=0.504m as=14.432n ps=0.504m w=164 l=120
X19 inv_pti pti VDD_3V3 VDD_3V3 pfet_06v0 ad=21.472n pd=0.664m as=21.472n ps=0.664m w=244 l=100
X20 inv_nti nti VSS VSS nfet_06v0 ad=14.433n pd=0.505m as=0 ps=0 w=164 l=120
X21 inv_nti nti VSS_3V3 VSS_3V3 pfet_06v0 ad=21.473n pd=0.665m as=0 ps=0 w=244 l=100
X22 a_n1373_n454# inv_nti downstepper_test VSS nfet_06v0 ad=3.528n pd=0.195m as=8.599n ps=0.264m w=147 l=120
X23 upstepper_test nti a_n1205_n937# VSS_3V3 pfet_06v0 ad=21.384n pd=0.662m as=5.832n ps=0.291m w=243 l=100
X24 upstepper_test nti VDD_1V65 VSS nfet_06v0 ad=14.847n pd=0.496m as=10.51n ps=0.29m w=147 l=120
X25 a_n1205_n937# inv_pti VSS_3V3 VSS_3V3 pfet_06v0 ad=5.832n pd=0.291m as=21.384n ps=0.662m w=243 l=100
X26 downstepper_test pti a_n1778_n454# VSS nfet_06v0 ad=8.599n pd=0.264m as=3.528n ps=0.195m w=147 l=120
X27 a_n1778_n454# inv_nti VSS VSS nfet_06v0 ad=3.528n pd=0.195m as=14.847n ps=0.496m w=147 l=120
X28 upstepper_test inv_pti VSS VSS nfet_06v0 ad=14.432n pd=0.504m as=14.432n ps=0.504m w=164 l=120
X29 VDD_1V65 inv_pti a_n1373_n454# VSS nfet_06v0 ad=10.51n pd=0.29m as=3.528n ps=0.195m w=147 l=120
X30 downstepper_test inv_nti VSS_3V3 VSS_3V3 pfet_06v0 ad=21.384n pd=0.662m as=21.384n ps=0.662m w=243 l=100
C0 VDD_1V65 VSS_3V3 0.04703f
C1 VDD_3V3 VDD_1V65 0
C2 upstepper_test nti 0.11981f
C3 VDD_3V3 VSS_3V3 0
C4 ctrl_over 5v0_half_adder_selector_sc_0/res_stage0 0.04907f
C5 5v0_half_adder_selector_sc_0/m1_n244_n517# VDD_1V65 0
C6 5v0_half_adder_selector_sc_0/m1_n244_n517# VSS_3V3 0.27028f
C7 a_n1373_n454# pti 0
C8 5v0_half_adder_selector_sc_0/m1_n244_n517# VDD_3V3 0
C9 ternary_input 5v0_half_adder_selector_sc_0/m1_n239_179# 0.00191f
C10 ctrl_sign pti 0
C11 ctrl_over VSS_3V3 0.40911f
C12 a_n1205_n937# inv_nti 0
C13 a_n1778_n454# inv_nti 0.00214f
C14 ctrl_over VDD_3V3 0.0015f
C15 inv_pti pti 0.19351f
C16 upstepper_test downstepper_test 0.38867f
C17 ternary_output ctrl_sign 0
C18 inv_nti pti 0.11055f
C19 ternary_input a_n1373_n454# 0.00136f
C20 ternary_input ctrl_sign 0.00264f
C21 5v0_half_adder_selector_sc_0/m1_n244_n517# ctrl_over 0.37702f
C22 5v0_half_adder_selector_sc_0/m1_n239_179# 5v0_half_adder_selector_sc_0/res_stage0 0.18379f
C23 ternary_input inv_pti 0.08498f
C24 ternary_input inv_nti 0.02537f
C25 ctrl_sign 5v0_half_adder_selector_sc_0/res_stage0 0.22345f
C26 5v0_half_adder_selector_sc_0/m1_n239_179# VSS_3V3 0.00154f
C27 nti downstepper_test 0.07205f
C28 upstepper_test a_n1205_n937# 0.00334f
C29 upstepper_test a_n1778_n454# 0
C30 VDD_3V3 5v0_half_adder_selector_sc_0/m1_n239_179# 0.28989f
C31 upstepper_test pti 0
C32 5v0_half_adder_selector_sc_0/res_stage0 inv_pti 0
C33 5v0_half_adder_selector_sc_0/m1_n244_n517# 5v0_half_adder_selector_sc_0/m1_n239_179# 0.00395f
C34 5v0_half_adder_selector_sc_0/5v0_tgate_sel_2_sc_1/input_A 5v0_half_adder_selector_sc_0/res_stage0 0.00385f
C35 VDD_1V65 a_n1373_n454# 0.00232f
C36 a_n1373_n454# VSS_3V3 0.00122f
C37 ctrl_sign VSS_3V3 0
C38 upstepper_test ternary_output 0
C39 VDD_3V3 ctrl_sign 0.38402f
C40 upstepper_test ternary_input 0.02545f
C41 ctrl_over 5v0_half_adder_selector_sc_0/m1_n239_179# 0.00486f
C42 VDD_1V65 inv_pti 0.14775f
C43 VDD_1V65 inv_nti 0.01114f
C44 VSS_3V3 inv_pti 0.1674f
C45 inv_nti VSS_3V3 0.55402f
C46 5v0_half_adder_selector_sc_0/m1_n244_n517# ctrl_sign 0.0109f
C47 nti a_n1205_n937# 0
C48 nti a_n1778_n454# 0.00142f
C49 5v0_half_adder_selector_sc_0/5v0_tgate_sel_2_sc_1/input_A VSS_3V3 0.03098f
C50 VDD_3V3 inv_pti 0.23112f
C51 VDD_3V3 inv_nti 0.00196f
C52 nti pti 0.1782f
C53 5v0_half_adder_selector_sc_0/m1_n244_n517# inv_pti 0
C54 ctrl_over ctrl_sign 0.01302f
C55 5v0_half_adder_selector_sc_0/m1_n244_n517# 5v0_half_adder_selector_sc_0/5v0_tgate_sel_2_sc_1/input_A 0.07353f
C56 upstepper_test 5v0_half_adder_selector_sc_0/res_stage0 0.27475f
C57 nti ternary_output 0
C58 ternary_input nti 0.61523f
C59 ctrl_over 5v0_half_adder_selector_sc_0/5v0_tgate_sel_2_sc_1/input_A 0.01944f
C60 a_n1205_n937# downstepper_test 0.00453f
C61 downstepper_test a_n1778_n454# 0.0031f
C62 upstepper_test VDD_1V65 0.16859f
C63 upstepper_test VSS_3V3 0.13823f
C64 downstepper_test pti 0.08313f
C65 upstepper_test VDD_3V3 0.33323f
C66 nti 5v0_half_adder_selector_sc_0/res_stage0 0.00372f
C67 ternary_output downstepper_test 0.00248f
C68 ctrl_sign 5v0_half_adder_selector_sc_0/m1_n239_179# 0.30291f
C69 5v0_half_adder_selector_sc_0/m1_n244_n517# upstepper_test 0.00167f
C70 ternary_input downstepper_test 0.16659f
C71 5v0_half_adder_selector_sc_0/m1_n239_179# inv_pti 0
C72 upstepper_test ctrl_over 0
C73 nti VDD_1V65 0.21326f
C74 a_n1778_n454# pti 0.00135f
C75 nti VSS_3V3 0.41493f
C76 nti VDD_3V3 0.16194f
C77 a_n1373_n454# inv_pti 0.00135f
C78 downstepper_test 5v0_half_adder_selector_sc_0/res_stage0 0.25302f
C79 inv_nti a_n1373_n454# 0
C80 ctrl_sign inv_pti 0.00263f
C81 5v0_half_adder_selector_sc_0/m1_n244_n517# nti 0.00226f
C82 ctrl_sign 5v0_half_adder_selector_sc_0/5v0_tgate_sel_2_sc_1/input_A 0
C83 ternary_input a_n1205_n937# 0
C84 ternary_input a_n1778_n454# 0.00116f
C85 ternary_input pti 0.54978f
C86 inv_nti inv_pti 0.08256f
C87 VDD_1V65 downstepper_test 0.13024f
C88 downstepper_test VSS_3V3 0.41008f
C89 upstepper_test 5v0_half_adder_selector_sc_0/m1_n239_179# 0.07502f
C90 VDD_3V3 downstepper_test 0.10943f
C91 ternary_input ternary_output 0.19159f
C92 a_n1205_n937# 5v0_half_adder_selector_sc_0/res_stage0 0
C93 5v0_half_adder_selector_sc_0/m1_n244_n517# downstepper_test 0.02897f
C94 upstepper_test a_n1373_n454# 0
C95 upstepper_test ctrl_sign 0.08746f
C96 ctrl_over downstepper_test 0.00206f
C97 a_n1205_n937# VDD_1V65 0.00354f
C98 ternary_output 5v0_half_adder_selector_sc_0/res_stage0 0.11993f
C99 VDD_1V65 a_n1778_n454# 0
C100 a_n1205_n937# VSS_3V3 0.00891f
C101 upstepper_test inv_pti 0.0467f
C102 upstepper_test inv_nti 0.0011f
C103 ternary_input 5v0_half_adder_selector_sc_0/res_stage0 0.28146f
C104 upstepper_test 5v0_half_adder_selector_sc_0/5v0_tgate_sel_2_sc_1/input_A 0
C105 VDD_1V65 pti 0.00115f
C106 VSS_3V3 pti 0.02893f
C107 VDD_3V3 pti 0.54139f
C108 nti a_n1373_n454# 0
C109 ternary_output VSS_3V3 0.15496f
C110 5v0_half_adder_selector_sc_0/m1_n244_n517# pti 0
C111 nti ctrl_sign 0
C112 ternary_input VDD_1V65 0.03394f
C113 ternary_output VDD_3V3 0
C114 ternary_input VSS_3V3 0.15325f
C115 ternary_input VDD_3V3 0.93054f
C116 downstepper_test 5v0_half_adder_selector_sc_0/m1_n239_179# 0.09961f
C117 nti inv_pti 0.21873f
C118 5v0_half_adder_selector_sc_0/m1_n244_n517# ternary_output 0.23201f
C119 nti inv_nti 0.20874f
C120 5v0_half_adder_selector_sc_0/m1_n244_n517# ternary_input 0.13297f
C121 ctrl_over ternary_output 0.18581f
C122 downstepper_test a_n1373_n454# 0.00442f
C123 5v0_half_adder_selector_sc_0/res_stage0 VSS_3V3 0.13661f
C124 ternary_input ctrl_over 0.0727f
C125 ctrl_sign downstepper_test 0.14523f
C126 VDD_3V3 5v0_half_adder_selector_sc_0/res_stage0 0.02483f
C127 5v0_half_adder_selector_sc_0/m1_n244_n517# 5v0_half_adder_selector_sc_0/res_stage0 0.14284f
C128 downstepper_test inv_pti 0.07797f
C129 downstepper_test inv_nti 0.1819f
C130 downstepper_test 5v0_half_adder_selector_sc_0/5v0_tgate_sel_2_sc_1/input_A 0
C131 pti VSS 0.62139f
C132 VDD_1V65 VSS 0.09068f
C133 inv_pti VSS 0.6002f
C134 a_n1205_n937# VSS 0 ; **FLOATING
C135 a_n1373_n454# VSS 0.00335f ; **FLOATING
C136 a_n1778_n454# VSS 0.00573f ; **FLOATING
C137 inv_nti VSS 0.52092f
C138 nti VSS 1.27643f
C139 5v0_half_adder_selector_sc_0/5v0_tgate_sel_2_sc_1/input_A VSS 0
C140 ctrl_over VSS 0.55135f
C141 ternary_input VSS 1.93066f
C142 ternary_output VSS 0.28152f
C143 5v0_half_adder_selector_sc_0/m1_n244_n517# VSS 0.39366f ; **FLOATING
C144 VSS_3V3 VSS 6.29549f
C145 5v0_half_adder_selector_sc_0/m1_n239_179# VSS 0.30065f ; **FLOATING
C146 5v0_half_adder_selector_sc_0/res_stage0 VSS 0.50953f
C147 downstepper_test VSS 0.64132f
C148 ctrl_sign VSS 0.56557f
C149 VDD_3V3 VSS 6.35626f
C150 upstepper_test VSS 0.54838f
