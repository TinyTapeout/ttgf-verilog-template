* NGSPICE file created from 5v0_add_q_sc.ext - technology: gf180mcuD

.option scale=5n

X0 pti ternary_input VSS VSS nfet_06v0 ad=6.336n pd=0.32m as=6.336n ps=0.32m w=72 l=578
X1 VDD_3V3_uq0 ternary_input pti VDD_3V3_uq0 pfet_06v0 ad=12.81n pd=0.349m as=12.688n ps=0.348m w=244 l=100
X2 pti ternary_input VDD_3V3_uq0 VDD_3V3_uq0 pfet_06v0 ad=12.688n pd=0.348m as=21.472n ps=0.664m w=244 l=100
X3 pti ternary_input VDD_3V3_uq0 VDD_3V3_uq0 pfet_06v0 ad=27.328n pd=0.712m as=12.81n ps=0.349m w=244 l=100
X4 nti ternary_input VSS VSS nfet_06v0 ad=12.7n pd=0.454m as=11.303n ps=0.432m w=127 l=120
X5 nti ternary_input VDD_3V3_uq0 VDD_3V3_uq0 pfet_06v0 ad=9.696n pd=0.394m as=8.928n ps=0.378m w=96 l=150
X6 5v0_half_adder_selector_sc_0/res_stage0 5v0_half_adder_selector_sc_0/m1_n239_179# downstepper_test VSS nfet_06v0 ad=14.432n pd=0.504m as=14.432n ps=0.504m w=164 l=120
X7 5v0_half_adder_selector_sc_0/res_stage0 5v0_half_adder_selector_sc_0/m1_n239_179# upstepper_test VDD_3V3_uq0 pfet_06v0 ad=21.472n pd=0.664m as=21.472n ps=0.664m w=244 l=100
X8 5v0_half_adder_selector_sc_0/m1_n239_179# ctrl_sign VSS VSS nfet_06v0 ad=14.432n pd=0.504m as=14.432n ps=0.504m w=164 l=120
X9 5v0_half_adder_selector_sc_0/m1_n239_179# ctrl_sign VDD_3V3_uq0 VDD_3V3_uq0 pfet_06v0 ad=21.472n pd=0.664m as=21.472n ps=0.664m w=244 l=100
X10 5v0_half_adder_selector_sc_0/res_stage0 ctrl_sign upstepper_test VSS nfet_06v0 ad=31.489n pd=1.041m as=43.711n ps=1.504m w=164 l=120
X11 5v0_half_adder_selector_sc_0/res_stage0 ctrl_sign downstepper_test VDD_3V3_uq0 pfet_06v0 ad=46.849n pd=1.361m as=42.856n ps=1.326m w=244 l=100
X12 ternary_output 5v0_half_adder_selector_sc_0/ctrl_over 5v0_half_adder_selector_sc_0/res_stage0 VSS nfet_06v0 ad=17.057n pd=0.537m as=0 ps=0 w=164 l=120
X13 ternary_output 5v0_half_adder_selector_sc_0/ctrl_over ternary_input VDD_3V3 pfet_06v0 ad=25.377n pd=0.697m as=21.472n ps=0.664m w=244 l=100
X14 5v0_half_adder_selector_sc_0/m1_n244_n517# 5v0_half_adder_selector_sc_0/ctrl_over VSS VSS nfet_06v0 ad=14.432n pd=0.504m as=0.10465u ps=3.768m w=164 l=120
X15 5v0_half_adder_selector_sc_0/m1_n244_n517# 5v0_half_adder_selector_sc_0/ctrl_over VDD_3V3 VDD_3V3 pfet_06v0 ad=21.472n pd=0.664m as=85.71201n ps=2.652m w=244 l=100
X16 ternary_output 5v0_half_adder_selector_sc_0/m1_n244_n517# ternary_input VSS nfet_06v0 ad=0 pd=0 as=14.432n ps=0.504m w=164 l=120
X17 ternary_output 5v0_half_adder_selector_sc_0/m1_n244_n517# 5v0_half_adder_selector_sc_0/res_stage0 VDD_3V3 pfet_06v0 ad=0 pd=0 as=0 ps=0 w=244 l=100
X18 a_n1325_n547# pti VSS VSS nfet_06v0 ad=14.432n pd=0.504m as=14.432n ps=0.504m w=164 l=120
X19 a_n1325_n547# pti VDD_3V3_uq0 VDD_3V3_uq0 pfet_06v0 ad=21.472n pd=0.664m as=21.472n ps=0.664m w=244 l=100
X20 a_n1898_n981# nti VSS VSS nfet_06v0 ad=14.432n pd=0.504m as=0 ps=0 w=164 l=120
X21 a_n1898_n981# nti VDD_3V3 VDD_3V3 pfet_06v0 ad=21.472n pd=0.664m as=0 ps=0 w=244 l=100
X22 a_n1373_n454# a_n1898_n981# downstepper_test VSS nfet_06v0 ad=3.528n pd=0.195m as=8.599n ps=0.264m w=147 l=120
X23 upstepper_test nti a_n1205_n937# VDD_3V3 pfet_06v0 ad=21.384n pd=0.662m as=5.832n ps=0.291m w=243 l=100
X24 upstepper_test nti VDD_1V65 VSS nfet_06v0 ad=14.847n pd=0.496m as=10.51n ps=0.29m w=147 l=120
X25 a_n1205_n937# a_n1325_n547# VDD_3V3 VDD_3V3 pfet_06v0 ad=5.832n pd=0.291m as=21.384n ps=0.662m w=243 l=100
X26 downstepper_test pti a_n1778_n454# VSS nfet_06v0 ad=8.599n pd=0.264m as=3.528n ps=0.195m w=147 l=120
X27 a_n1778_n454# a_n1898_n981# VSS VSS nfet_06v0 ad=3.528n pd=0.195m as=14.847n ps=0.496m w=147 l=120
X28 upstepper_test a_n1325_n547# VSS VSS nfet_06v0 ad=14.432n pd=0.504m as=14.432n ps=0.504m w=164 l=120
X29 VDD_1V65 a_n1325_n547# a_n1373_n454# VSS nfet_06v0 ad=10.51n pd=0.29m as=3.528n ps=0.195m w=147 l=120
X30 downstepper_test a_n1898_n981# VDD_3V3 VDD_3V3 pfet_06v0 ad=21.384n pd=0.662m as=21.384n ps=0.662m w=243 l=100
C0 a_n1898_n981# pti 0.10928f
C1 5v0_half_adder_selector_sc_0/m1_n244_n517# pti 0
C2 a_n1325_n547# VDD_1V65 0.14775f
C3 VDD_3V3_uq0 ctrl_sign 0.38402f
C4 upstepper_test VDD_3V3_uq0 0.33323f
C5 downstepper_test pti 0.08313f
C6 upstepper_test a_n1778_n454# 0
C7 nti ctrl_sign 0
C8 upstepper_test nti 0.11981f
C9 5v0_half_adder_selector_sc_0/ctrl_over ternary_input 0.0727f
C10 VDD_3V3 VDD_3V3_uq0 0
C11 a_n1325_n547# pti 0.19351f
C12 ternary_input VDD_1V65 0.03394f
C13 VDD_3V3 nti 0.40684f
C14 a_n1373_n454# upstepper_test 0
C15 ternary_output upstepper_test 0
C16 upstepper_test a_n1205_n937# 0.00334f
C17 ternary_input pti 0.5313f
C18 a_n1373_n454# VDD_3V3 0.00122f
C19 ternary_output VDD_3V3 0.15496f
C20 VDD_3V3 a_n1205_n937# 0.00891f
C21 ctrl_sign 5v0_half_adder_selector_sc_0/m1_n239_179# 0.30291f
C22 upstepper_test 5v0_half_adder_selector_sc_0/m1_n239_179# 0.07502f
C23 VDD_3V3 5v0_half_adder_selector_sc_0/m1_n239_179# 0.00154f
C24 VDD_3V3_uq0 a_n1898_n981# 0.00196f
C25 5v0_half_adder_selector_sc_0/m1_n244_n517# VDD_3V3_uq0 0
C26 upstepper_test ctrl_sign 0.08746f
C27 VDD_3V3_uq0 5v0_half_adder_selector_sc_0/res_stage0 0.02483f
C28 a_n1898_n981# a_n1778_n454# 0.00212f
C29 5v0_half_adder_selector_sc_0/m1_n244_n517# nti 0.00226f
C30 nti a_n1898_n981# 0.20745f
C31 downstepper_test VDD_3V3_uq0 0.10943f
C32 VDD_3V3 ctrl_sign 0
C33 VDD_1V65 pti 0.00115f
C34 nti 5v0_half_adder_selector_sc_0/res_stage0 0.00372f
C35 VDD_3V3 upstepper_test 0.13834f
C36 downstepper_test a_n1778_n454# 0.0031f
C37 downstepper_test nti 0.07077f
C38 a_n1373_n454# a_n1898_n981# 0
C39 a_n1325_n547# VDD_3V3_uq0 0.23112f
C40 ternary_output 5v0_half_adder_selector_sc_0/m1_n244_n517# 0.23201f
C41 a_n1205_n937# a_n1898_n981# 0
C42 a_n1325_n547# nti 0.21872f
C43 ternary_output 5v0_half_adder_selector_sc_0/res_stage0 0.11993f
C44 5v0_half_adder_selector_sc_0/res_stage0 a_n1205_n937# 0
C45 downstepper_test a_n1373_n454# 0.00442f
C46 downstepper_test a_n1205_n937# 0.00453f
C47 downstepper_test ternary_output 0.00248f
C48 ternary_input VDD_3V3_uq0 0.96005f
C49 a_n1325_n547# a_n1373_n454# 0.00135f
C50 5v0_half_adder_selector_sc_0/m1_n244_n517# 5v0_half_adder_selector_sc_0/m1_n239_179# 0.00395f
C51 ternary_input a_n1778_n454# 0.00116f
C52 ternary_input nti 0.60908f
C53 5v0_half_adder_selector_sc_0/res_stage0 5v0_half_adder_selector_sc_0/m1_n239_179# 0.18379f
C54 5v0_half_adder_selector_sc_0/5v0_tgate_sel_2_sc_1/input_A ctrl_sign 0
C55 downstepper_test 5v0_half_adder_selector_sc_0/m1_n239_179# 0.09961f
C56 upstepper_test 5v0_half_adder_selector_sc_0/5v0_tgate_sel_2_sc_1/input_A 0
C57 5v0_half_adder_selector_sc_0/m1_n244_n517# ctrl_sign 0.0109f
C58 5v0_half_adder_selector_sc_0/m1_n244_n517# upstepper_test 0.00167f
C59 upstepper_test a_n1898_n981# 0
C60 a_n1373_n454# ternary_input 0.00136f
C61 5v0_half_adder_selector_sc_0/res_stage0 ctrl_sign 0.22345f
C62 ternary_output ternary_input 0.19159f
C63 ternary_input a_n1205_n937# 0
C64 upstepper_test 5v0_half_adder_selector_sc_0/res_stage0 0.27475f
C65 a_n1325_n547# 5v0_half_adder_selector_sc_0/m1_n239_179# 0
C66 VDD_3V3 5v0_half_adder_selector_sc_0/5v0_tgate_sel_2_sc_1/input_A 0.03098f
C67 downstepper_test ctrl_sign 0.14523f
C68 5v0_half_adder_selector_sc_0/m1_n244_n517# VDD_3V3 0.27028f
C69 VDD_3V3 a_n1898_n981# 0.59815f
C70 downstepper_test upstepper_test 0.38867f
C71 5v0_half_adder_selector_sc_0/ctrl_over VDD_3V3_uq0 0.0015f
C72 VDD_3V3 5v0_half_adder_selector_sc_0/res_stage0 0.13661f
C73 VDD_1V65 VDD_3V3_uq0 0
C74 a_n1325_n547# ctrl_sign 0.00263f
C75 a_n1325_n547# upstepper_test 0.0467f
C76 ternary_input 5v0_half_adder_selector_sc_0/m1_n239_179# 0.00191f
C77 downstepper_test VDD_3V3 0.41098f
C78 VDD_1V65 a_n1778_n454# 0
C79 nti VDD_1V65 0.21326f
C80 a_n1325_n547# VDD_3V3 0.16742f
C81 VDD_3V3_uq0 pti 0.551f
C82 ternary_input ctrl_sign 0.00264f
C83 ternary_input upstepper_test 0.02545f
C84 a_n1373_n454# VDD_1V65 0.00232f
C85 a_n1778_n454# pti 0.00135f
C86 ternary_output 5v0_half_adder_selector_sc_0/ctrl_over 0.18581f
C87 nti pti 0.17279f
C88 VDD_1V65 a_n1205_n937# 0.00354f
C89 VDD_3V3 ternary_input 0.15434f
C90 5v0_half_adder_selector_sc_0/m1_n244_n517# 5v0_half_adder_selector_sc_0/5v0_tgate_sel_2_sc_1/input_A 0.07353f
C91 a_n1373_n454# pti 0
C92 5v0_half_adder_selector_sc_0/ctrl_over 5v0_half_adder_selector_sc_0/m1_n239_179# 0.00486f
C93 5v0_half_adder_selector_sc_0/5v0_tgate_sel_2_sc_1/input_A 5v0_half_adder_selector_sc_0/res_stage0 0.00385f
C94 5v0_half_adder_selector_sc_0/m1_n244_n517# 5v0_half_adder_selector_sc_0/res_stage0 0.14284f
C95 downstepper_test 5v0_half_adder_selector_sc_0/5v0_tgate_sel_2_sc_1/input_A 0
C96 downstepper_test 5v0_half_adder_selector_sc_0/m1_n244_n517# 0.02897f
C97 downstepper_test a_n1898_n981# 0.18136f
C98 5v0_half_adder_selector_sc_0/ctrl_over ctrl_sign 0.01302f
C99 downstepper_test 5v0_half_adder_selector_sc_0/res_stage0 0.25302f
C100 a_n1325_n547# 5v0_half_adder_selector_sc_0/m1_n244_n517# 0
C101 a_n1325_n547# a_n1898_n981# 0.08248f
C102 upstepper_test VDD_1V65 0.16859f
C103 a_n1325_n547# 5v0_half_adder_selector_sc_0/res_stage0 0
C104 5v0_half_adder_selector_sc_0/ctrl_over VDD_3V3 0.40911f
C105 VDD_3V3 VDD_1V65 0.04713f
C106 downstepper_test a_n1325_n547# 0.07797f
C107 ctrl_sign pti 0
C108 upstepper_test pti 0
C109 5v0_half_adder_selector_sc_0/m1_n244_n517# ternary_input 0.13297f
C110 ternary_input a_n1898_n981# 0.02714f
C111 ternary_input 5v0_half_adder_selector_sc_0/res_stage0 0.28146f
C112 VDD_3V3 pti 0.02893f
C113 downstepper_test ternary_input 0.16661f
C114 nti VDD_3V3_uq0 0.16211f
C115 nti a_n1778_n454# 0.00123f
C116 a_n1325_n547# ternary_input 0.08497f
C117 ternary_output VDD_3V3_uq0 0
C118 a_n1373_n454# nti 0
C119 5v0_half_adder_selector_sc_0/ctrl_over 5v0_half_adder_selector_sc_0/5v0_tgate_sel_2_sc_1/input_A 0.01944f
C120 5v0_half_adder_selector_sc_0/m1_n244_n517# 5v0_half_adder_selector_sc_0/ctrl_over 0.37702f
C121 ternary_output nti 0
C122 nti a_n1205_n937# 0
C123 5v0_half_adder_selector_sc_0/m1_n244_n517# VDD_1V65 0
C124 VDD_1V65 a_n1898_n981# 0.01095f
C125 5v0_half_adder_selector_sc_0/ctrl_over 5v0_half_adder_selector_sc_0/res_stage0 0.04907f
C126 VDD_3V3_uq0 5v0_half_adder_selector_sc_0/m1_n239_179# 0.28989f
C127 downstepper_test 5v0_half_adder_selector_sc_0/ctrl_over 0.00206f
C128 downstepper_test VDD_1V65 0.13024f
C129 pti VSS 0.62941f
C130 VDD_1V65 VSS 0.09232f
C131 a_n1205_n937# VSS 0 ; **FLOATING
C132 a_n1373_n454# VSS 0.00335f ; **FLOATING
C133 a_n1778_n454# VSS 0.00573f ; **FLOATING
C134 a_n1898_n981# VSS 0.56173f ; **FLOATING
C135 a_n1325_n547# VSS 0.6002f ; **FLOATING
C136 nti VSS 1.36076f
C137 5v0_half_adder_selector_sc_0/5v0_tgate_sel_2_sc_1/input_A VSS 0
C138 5v0_half_adder_selector_sc_0/ctrl_over VSS 0.571f
C139 ternary_input VSS 2.00726f
C140 ternary_output VSS 0.28152f
C141 5v0_half_adder_selector_sc_0/m1_n244_n517# VSS 0.39366f ; **FLOATING
C142 VDD_3V3 VSS 6.28492f
C143 5v0_half_adder_selector_sc_0/m1_n239_179# VSS 0.30065f ; **FLOATING
C144 5v0_half_adder_selector_sc_0/res_stage0 VSS 0.50953f
C145 downstepper_test VSS 0.64154f
C146 ctrl_sign VSS 0.56557f
C147 VDD_3V3_uq0 VSS 6.37693f
C148 upstepper_test VSS 0.54918f
