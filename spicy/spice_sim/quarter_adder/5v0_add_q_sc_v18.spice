* NGSPICE file created from 5v0_add_q_sc.ext - technology: gf180mcuD

.option scale=5n

X0 pti ternary_input VSS VSS nfet_06v0 ad=6.336n pd=0.32m as=6.336n ps=0.32m w=72 l=578
X1 5v0_nti_sc_f_0/VDD_3V3 ternary_input pti 5v0_nti_sc_f_0/VDD_3V3 pfet_06v0 ad=12.81n pd=0.349m as=12.688n ps=0.348m w=244 l=100
X2 pti ternary_input 5v0_nti_sc_f_0/VDD_3V3 5v0_nti_sc_f_0/VDD_3V3 pfet_06v0 ad=12.688n pd=0.348m as=21.472n ps=0.664m w=244 l=100
X3 pti ternary_input 5v0_nti_sc_f_0/VDD_3V3 5v0_nti_sc_f_0/VDD_3V3 pfet_06v0 ad=27.328n pd=0.712m as=12.81n ps=0.349m w=244 l=100
X4 nti ternary_input VSS VSS nfet_06v0 ad=12.7n pd=0.454m as=11.303n ps=0.432m w=127 l=120
X5 nti ternary_input 5v0_nti_sc_f_0/VDD_3V3 5v0_nti_sc_f_0/VDD_3V3 pfet_06v0 ad=9.696n pd=0.394m as=8.928n ps=0.378m w=96 l=150
X6 5v0_half_adder_selector_sc_0/res_stage0 5v0_half_adder_selector_sc_0/m1_n239_179# downstepper_test VSS nfet_06v0 ad=14.432n pd=0.504m as=14.432n ps=0.504m w=164 l=120
X7 5v0_half_adder_selector_sc_0/res_stage0 5v0_half_adder_selector_sc_0/m1_n239_179# upstepper_test 5v0_nti_sc_f_0/VDD_3V3 pfet_06v0 ad=21.472n pd=0.664m as=21.472n ps=0.664m w=244 l=100
X8 5v0_half_adder_selector_sc_0/m1_n239_179# ctrl_sign VSS VSS nfet_06v0 ad=14.432n pd=0.504m as=14.432n ps=0.504m w=164 l=120
X9 5v0_half_adder_selector_sc_0/m1_n239_179# ctrl_sign 5v0_nti_sc_f_0/VDD_3V3 5v0_nti_sc_f_0/VDD_3V3 pfet_06v0 ad=21.472n pd=0.664m as=21.472n ps=0.664m w=244 l=100
X10 5v0_half_adder_selector_sc_0/res_stage0 ctrl_sign upstepper_test VSS nfet_06v0 ad=31.489n pd=1.041m as=43.711n ps=1.504m w=164 l=120
X11 5v0_half_adder_selector_sc_0/res_stage0 ctrl_sign downstepper_test 5v0_nti_sc_f_0/VDD_3V3 pfet_06v0 ad=46.849n pd=1.361m as=42.856n ps=1.326m w=244 l=100
X12 ternary_output ctrl_over 5v0_half_adder_selector_sc_0/res_stage0 VSS nfet_06v0 ad=17.057n pd=0.537m as=0 ps=0 w=164 l=120
X13 ternary_output ctrl_over ternary_input VDD_3V3 pfet_06v0 ad=25.377n pd=0.697m as=21.472n ps=0.664m w=244 l=100
X14 5v0_half_adder_selector_sc_0/m1_n244_n517# ctrl_over VSS VSS nfet_06v0 ad=14.432n pd=0.504m as=0.10465u ps=3.768m w=164 l=120
X15 5v0_half_adder_selector_sc_0/m1_n244_n517# ctrl_over VDD_3V3 VDD_3V3 pfet_06v0 ad=21.472n pd=0.664m as=85.71201n ps=2.652m w=244 l=100
X16 ternary_output 5v0_half_adder_selector_sc_0/m1_n244_n517# ternary_input VSS nfet_06v0 ad=0 pd=0 as=14.432n ps=0.504m w=164 l=120
X17 ternary_output 5v0_half_adder_selector_sc_0/m1_n244_n517# 5v0_half_adder_selector_sc_0/res_stage0 VDD_3V3 pfet_06v0 ad=0 pd=0 as=0 ps=0 w=244 l=100
X18 inv_pti pti VSS VSS nfet_06v0 ad=14.432n pd=0.504m as=14.432n ps=0.504m w=164 l=120
X19 inv_pti pti 5v0_nti_sc_f_0/VDD_3V3 5v0_nti_sc_f_0/VDD_3V3 pfet_06v0 ad=21.472n pd=0.664m as=21.472n ps=0.664m w=244 l=100
X20 inv_nti nti VSS VSS nfet_06v0 ad=14.432n pd=0.504m as=0 ps=0 w=164 l=120
X21 inv_nti nti VDD_3V3 VDD_3V3 pfet_06v0 ad=21.472n pd=0.664m as=0 ps=0 w=244 l=100
X22 a_n1373_n454# inv_nti downstepper_test VSS nfet_06v0 ad=3.528n pd=0.195m as=8.599n ps=0.264m w=147 l=120
X23 upstepper_test nti a_n1205_n937# VDD_3V3 pfet_06v0 ad=21.384n pd=0.662m as=5.832n ps=0.291m w=243 l=100
X24 upstepper_test nti VDD_1V65 VSS nfet_06v0 ad=14.847n pd=0.496m as=10.51n ps=0.29m w=147 l=120
X25 a_n1205_n937# inv_pti VDD_3V3 VDD_3V3 pfet_06v0 ad=5.832n pd=0.291m as=21.384n ps=0.662m w=243 l=100
X26 downstepper_test pti a_n1778_n454# VSS nfet_06v0 ad=8.599n pd=0.264m as=3.528n ps=0.195m w=147 l=120
X27 a_n1778_n454# inv_nti VSS VSS nfet_06v0 ad=3.528n pd=0.195m as=14.847n ps=0.496m w=147 l=120
X28 upstepper_test inv_pti VSS VSS nfet_06v0 ad=14.432n pd=0.504m as=14.432n ps=0.504m w=164 l=120
X29 VDD_1V65 inv_pti a_n1373_n454# VSS nfet_06v0 ad=10.51n pd=0.29m as=3.528n ps=0.195m w=147 l=120
X30 downstepper_test inv_nti VDD_3V3 VDD_3V3 pfet_06v0 ad=21.384n pd=0.662m as=21.384n ps=0.662m w=243 l=100
C0 VDD_3V3 inv_pti 0.16742f
C1 ctrl_over 5v0_nti_sc_f_0/VDD_3V3 0.0015f
C2 5v0_half_adder_selector_sc_0/m1_n239_179# VDD_3V3 0.00154f
C3 ctrl_over ctrl_sign 0.01302f
C4 inv_pti 5v0_half_adder_selector_sc_0/m1_n244_n517# 0
C5 ternary_input VDD_3V3 0.15434f
C6 5v0_half_adder_selector_sc_0/m1_n239_179# 5v0_half_adder_selector_sc_0/m1_n244_n517# 0.00395f
C7 inv_pti inv_nti 0.08248f
C8 ternary_input 5v0_half_adder_selector_sc_0/m1_n244_n517# 0.13297f
C9 a_n1205_n937# downstepper_test 0.00453f
C10 ternary_output VDD_3V3 0.15496f
C11 ternary_input inv_nti 0.02714f
C12 ctrl_over downstepper_test 0.00206f
C13 ternary_output 5v0_half_adder_selector_sc_0/m1_n244_n517# 0.23201f
C14 5v0_half_adder_selector_sc_0/5v0_tgate_sel_2_sc_1/input_A VDD_3V3 0.03098f
C15 VDD_1V65 VDD_3V3 0.04713f
C16 a_n1373_n454# VDD_3V3 0.00122f
C17 5v0_half_adder_selector_sc_0/res_stage0 upstepper_test 0.27475f
C18 5v0_half_adder_selector_sc_0/res_stage0 nti 0.00372f
C19 a_n1778_n454# upstepper_test 0
C20 5v0_half_adder_selector_sc_0/5v0_tgate_sel_2_sc_1/input_A 5v0_half_adder_selector_sc_0/m1_n244_n517# 0.07353f
C21 nti a_n1778_n454# 0.00123f
C22 VDD_1V65 5v0_half_adder_selector_sc_0/m1_n244_n517# 0
C23 5v0_half_adder_selector_sc_0/res_stage0 5v0_nti_sc_f_0/VDD_3V3 0.02483f
C24 VDD_1V65 inv_nti 0.01095f
C25 5v0_half_adder_selector_sc_0/res_stage0 ctrl_sign 0.22345f
C26 a_n1373_n454# inv_nti 0
C27 a_n1778_n454# pti 0.00135f
C28 5v0_half_adder_selector_sc_0/res_stage0 downstepper_test 0.25302f
C29 a_n1778_n454# downstepper_test 0.0031f
C30 5v0_half_adder_selector_sc_0/res_stage0 a_n1205_n937# 0
C31 upstepper_test VDD_3V3 0.13834f
C32 nti VDD_3V3 0.40684f
C33 5v0_half_adder_selector_sc_0/res_stage0 ctrl_over 0.04907f
C34 VDD_3V3 5v0_nti_sc_f_0/VDD_3V3 0
C35 upstepper_test 5v0_half_adder_selector_sc_0/m1_n244_n517# 0.00167f
C36 nti 5v0_half_adder_selector_sc_0/m1_n244_n517# 0.00226f
C37 ctrl_sign VDD_3V3 0
C38 5v0_nti_sc_f_0/VDD_3V3 5v0_half_adder_selector_sc_0/m1_n244_n517# 0
C39 upstepper_test inv_nti 0
C40 nti inv_nti 0.20745f
C41 VDD_3V3 pti 0.02893f
C42 5v0_nti_sc_f_0/VDD_3V3 inv_nti 0.00196f
C43 ctrl_sign 5v0_half_adder_selector_sc_0/m1_n244_n517# 0.0109f
C44 pti 5v0_half_adder_selector_sc_0/m1_n244_n517# 0
C45 downstepper_test VDD_3V3 0.41098f
C46 pti inv_nti 0.10928f
C47 downstepper_test 5v0_half_adder_selector_sc_0/m1_n244_n517# 0.02897f
C48 5v0_half_adder_selector_sc_0/m1_n239_179# inv_pti 0
C49 downstepper_test inv_nti 0.18136f
C50 a_n1205_n937# VDD_3V3 0.00891f
C51 ternary_input inv_pti 0.08497f
C52 ternary_input 5v0_half_adder_selector_sc_0/m1_n239_179# 0.00191f
C53 ctrl_over VDD_3V3 0.40911f
C54 a_n1205_n937# inv_nti 0
C55 ctrl_over 5v0_half_adder_selector_sc_0/m1_n244_n517# 0.37702f
C56 ternary_output ternary_input 0.19159f
C57 VDD_1V65 inv_pti 0.14775f
C58 a_n1373_n454# inv_pti 0.00135f
C59 VDD_1V65 ternary_input 0.03394f
C60 a_n1373_n454# ternary_input 0.00136f
C61 5v0_half_adder_selector_sc_0/res_stage0 VDD_3V3 0.13661f
C62 5v0_half_adder_selector_sc_0/res_stage0 5v0_half_adder_selector_sc_0/m1_n244_n517# 0.14284f
C63 VDD_1V65 a_n1373_n454# 0.00232f
C64 a_n1778_n454# inv_nti 0.00212f
C65 upstepper_test inv_pti 0.0467f
C66 nti inv_pti 0.21872f
C67 5v0_half_adder_selector_sc_0/m1_n239_179# upstepper_test 0.07502f
C68 5v0_nti_sc_f_0/VDD_3V3 inv_pti 0.23112f
C69 5v0_half_adder_selector_sc_0/m1_n239_179# 5v0_nti_sc_f_0/VDD_3V3 0.28989f
C70 ternary_input upstepper_test 0.02545f
C71 ternary_input nti 0.60908f
C72 ctrl_sign inv_pti 0.00263f
C73 ctrl_sign 5v0_half_adder_selector_sc_0/m1_n239_179# 0.30291f
C74 ternary_input 5v0_nti_sc_f_0/VDD_3V3 0.96005f
C75 pti inv_pti 0.19351f
C76 ternary_output upstepper_test 0
C77 ternary_output nti 0
C78 ternary_input ctrl_sign 0.00264f
C79 ternary_input pti 0.5313f
C80 VDD_3V3 5v0_half_adder_selector_sc_0/m1_n244_n517# 0.27028f
C81 downstepper_test inv_pti 0.07797f
C82 ternary_output ctrl_sign 0
C83 5v0_half_adder_selector_sc_0/5v0_tgate_sel_2_sc_1/input_A upstepper_test 0
C84 VDD_1V65 upstepper_test 0.16859f
C85 5v0_half_adder_selector_sc_0/m1_n239_179# downstepper_test 0.09961f
C86 VDD_3V3 inv_nti 0.59815f
C87 VDD_1V65 nti 0.21326f
C88 a_n1373_n454# upstepper_test 0
C89 a_n1373_n454# nti 0
C90 VDD_1V65 5v0_nti_sc_f_0/VDD_3V3 0
C91 ternary_input downstepper_test 0.16661f
C92 ctrl_sign 5v0_half_adder_selector_sc_0/5v0_tgate_sel_2_sc_1/input_A 0
C93 ternary_output downstepper_test 0.00248f
C94 VDD_1V65 pti 0.00115f
C95 a_n1373_n454# pti 0
C96 ternary_input a_n1205_n937# 0
C97 ctrl_over 5v0_half_adder_selector_sc_0/m1_n239_179# 0.00486f
C98 5v0_half_adder_selector_sc_0/5v0_tgate_sel_2_sc_1/input_A downstepper_test 0
C99 VDD_1V65 downstepper_test 0.13024f
C100 ternary_input ctrl_over 0.0727f
C101 a_n1373_n454# downstepper_test 0.00442f
C102 ternary_output ctrl_over 0.18581f
C103 VDD_1V65 a_n1205_n937# 0.00354f
C104 ctrl_over 5v0_half_adder_selector_sc_0/5v0_tgate_sel_2_sc_1/input_A 0.01944f
C105 nti upstepper_test 0.11981f
C106 upstepper_test 5v0_nti_sc_f_0/VDD_3V3 0.33323f
C107 nti 5v0_nti_sc_f_0/VDD_3V3 0.16211f
C108 5v0_half_adder_selector_sc_0/res_stage0 inv_pti 0
C109 5v0_half_adder_selector_sc_0/res_stage0 5v0_half_adder_selector_sc_0/m1_n239_179# 0.18379f
C110 ctrl_sign upstepper_test 0.08746f
C111 ctrl_sign nti 0
C112 5v0_half_adder_selector_sc_0/res_stage0 ternary_input 0.28146f
C113 ctrl_sign 5v0_nti_sc_f_0/VDD_3V3 0.38402f
C114 upstepper_test pti 0
C115 nti pti 0.17279f
C116 ternary_input a_n1778_n454# 0.00116f
C117 5v0_nti_sc_f_0/VDD_3V3 pti 0.551f
C118 ternary_output 5v0_half_adder_selector_sc_0/res_stage0 0.11993f
C119 ctrl_sign pti 0
C120 downstepper_test upstepper_test 0.38867f
C121 nti downstepper_test 0.07077f
C122 downstepper_test 5v0_nti_sc_f_0/VDD_3V3 0.10943f
C123 5v0_half_adder_selector_sc_0/res_stage0 5v0_half_adder_selector_sc_0/5v0_tgate_sel_2_sc_1/input_A 0.00385f
C124 ctrl_sign downstepper_test 0.14523f
C125 VDD_1V65 a_n1778_n454# 0
C126 downstepper_test pti 0.08313f
C127 a_n1205_n937# upstepper_test 0.00334f
C128 a_n1205_n937# nti 0
C129 ctrl_over upstepper_test 0
C130 pti VSS 0.62941f
C131 VDD_1V65 VSS 0.09232f
C132 inv_nti VSS 0.56173f
C133 inv_pti VSS 0.6002f
C134 a_n1205_n937# VSS 0 ; **FLOATING
C135 a_n1373_n454# VSS 0.00335f ; **FLOATING
C136 a_n1778_n454# VSS 0.00573f ; **FLOATING
C137 nti VSS 1.36077f
C138 5v0_nti_sc_f_0/VDD_3V3 VSS 6.27264f
C139 5v0_half_adder_selector_sc_0/5v0_tgate_sel_2_sc_1/input_A VSS 0
C140 ctrl_over VSS 0.55135f
C141 ternary_input VSS 2.00726f
C142 ternary_output VSS 0.28152f
C143 5v0_half_adder_selector_sc_0/m1_n244_n517# VSS 0.39366f ; **FLOATING
C144 VDD_3V3 VSS 6.2849f
C145 5v0_half_adder_selector_sc_0/m1_n239_179# VSS 0.30065f ; **FLOATING
C146 5v0_half_adder_selector_sc_0/res_stage0 VSS 0.50953f
C147 downstepper_test VSS 0.64154f
C148 ctrl_sign VSS 0.56557f
C149 upstepper_test VSS 0.54918f
