* NGSPICE file created from 5v0_add_q_sc.ext - technology: gf180mcuD

.option scale=5n

X0 m1_n1654_59# ternary_input VSS VSS nfet_06v0 ad=6.336n pd=0.32m as=6.336n ps=0.32m w=72 l=578
X1 VDD_3V3_uq0 ternary_input m1_n1654_59# VDD_3V3_uq0 pfet_06v0 ad=12.81n pd=0.349m as=12.688n ps=0.348m w=244 l=100
X2 m1_n1654_59# ternary_input VDD_3V3_uq0 VDD_3V3_uq0 pfet_06v0 ad=12.688n pd=0.348m as=21.472n ps=0.664m w=244 l=100
X3 m1_n1654_59# ternary_input VDD_3V3_uq0 VDD_3V3_uq0 pfet_06v0 ad=27.328n pd=0.712m as=12.81n ps=0.349m w=244 l=100
X4 5v0_nti_sc_f_0/ternary_output ternary_input VSS VSS nfet_06v0 ad=12.7n pd=0.454m as=11.303n ps=0.432m w=127 l=120
X5 5v0_nti_sc_f_0/ternary_output ternary_input VDD_3V3_uq0 VDD_3V3_uq0 pfet_06v0 ad=9.696n pd=0.394m as=8.928n ps=0.378m w=96 l=150
X6 5v0_half_adder_selector_sc_0/m1_n9_n292# 5v0_half_adder_selector_sc_0/m1_n239_179# downstepper_test VSS nfet_06v0 ad=14.432n pd=0.504m as=14.432n ps=0.504m w=164 l=120
X7 5v0_half_adder_selector_sc_0/m1_n9_n292# 5v0_half_adder_selector_sc_0/m1_n239_179# m1_n698_624# VDD_3V3_uq0 pfet_06v0 ad=21.472n pd=0.664m as=21.472n ps=0.664m w=244 l=100
X8 5v0_half_adder_selector_sc_0/m1_n239_179# ctrl_sign VSS VSS nfet_06v0 ad=14.432n pd=0.504m as=14.432n ps=0.504m w=164 l=120
X9 5v0_half_adder_selector_sc_0/m1_n239_179# ctrl_sign VDD_3V3_uq0 VDD_3V3_uq0 pfet_06v0 ad=21.472n pd=0.664m as=21.472n ps=0.664m w=244 l=100
X10 5v0_half_adder_selector_sc_0/m1_n9_n292# ctrl_sign m1_n698_624# VSS nfet_06v0 ad=31.489n pd=1.041m as=43.711n ps=1.504m w=164 l=120
X11 5v0_half_adder_selector_sc_0/m1_n9_n292# ctrl_sign downstepper_test VDD_3V3_uq0 pfet_06v0 ad=46.849n pd=1.361m as=42.856n ps=1.326m w=244 l=100
X12 ternary_output 5v0_half_adder_selector_sc_0/m1_n437_n664# 5v0_half_adder_selector_sc_0/m1_n9_n292# VSS nfet_06v0 ad=17.057n pd=0.537m as=0 ps=0 w=164 l=120
X13 ternary_output 5v0_half_adder_selector_sc_0/m1_n437_n664# 5v0_half_adder_selector_sc_0/m1_n10_n948# VDD_3V3 pfet_06v0 ad=25.377n pd=0.697m as=21.472n ps=0.664m w=244 l=100
X14 5v0_half_adder_selector_sc_0/m1_n244_n517# 5v0_half_adder_selector_sc_0/m1_n437_n664# VSS VSS nfet_06v0 ad=14.432n pd=0.504m as=0.10465u ps=3.768m w=164 l=120
X15 5v0_half_adder_selector_sc_0/m1_n244_n517# 5v0_half_adder_selector_sc_0/m1_n437_n664# VDD_3V3 VDD_3V3 pfet_06v0 ad=21.472n pd=0.664m as=85.71201n ps=2.652m w=244 l=100
X16 ternary_output 5v0_half_adder_selector_sc_0/m1_n244_n517# 5v0_half_adder_selector_sc_0/m1_n10_n948# VSS nfet_06v0 ad=0 pd=0 as=14.432n ps=0.504m w=164 l=120
X17 ternary_output 5v0_half_adder_selector_sc_0/m1_n244_n517# 5v0_half_adder_selector_sc_0/m1_n9_n292# VDD_3V3 pfet_06v0 ad=0 pd=0 as=0 ps=0 w=244 l=100
X18 a_n1325_n547# m1_n1654_59# VSS VSS nfet_06v0 ad=14.432n pd=0.504m as=14.432n ps=0.504m w=164 l=120
X19 a_n1325_n547# m1_n1654_59# VDD_3V3_uq0 VDD_3V3_uq0 pfet_06v0 ad=21.472n pd=0.664m as=21.472n ps=0.664m w=244 l=100
X20 a_n1898_n981# 5v0_nti_sc_f_0/ternary_output VSS VSS nfet_06v0 ad=14.432n pd=0.504m as=0 ps=0 w=164 l=120
X21 a_n1898_n981# 5v0_nti_sc_f_0/ternary_output VDD_3V3 VDD_3V3 pfet_06v0 ad=21.472n pd=0.664m as=0 ps=0 w=244 l=100
X22 a_n1373_n454# a_n1898_n981# downstepper_test VSS nfet_06v0 ad=3.528n pd=0.195m as=8.599n ps=0.264m w=147 l=120
X23 m1_n698_624# 5v0_nti_sc_f_0/ternary_output a_n1205_n937# VDD_3V3 pfet_06v0 ad=21.384n pd=0.662m as=5.832n ps=0.291m w=243 l=100
X24 m1_n698_624# 5v0_nti_sc_f_0/ternary_output VDD_1V65 VSS nfet_06v0 ad=14.847n pd=0.496m as=10.51n ps=0.29m w=147 l=120
X25 a_n1205_n937# a_n1325_n547# VDD_3V3 VDD_3V3 pfet_06v0 ad=5.832n pd=0.291m as=21.384n ps=0.662m w=243 l=100
X26 downstepper_test m1_n1654_59# a_n1778_n454# VSS nfet_06v0 ad=8.599n pd=0.264m as=3.528n ps=0.195m w=147 l=120
X27 a_n1778_n454# a_n1898_n981# VSS VSS nfet_06v0 ad=3.528n pd=0.195m as=14.847n ps=0.496m w=147 l=120
X28 m1_n698_624# a_n1325_n547# VSS VSS nfet_06v0 ad=14.432n pd=0.504m as=14.432n ps=0.504m w=164 l=120
X29 VDD_1V65 a_n1325_n547# a_n1373_n454# VSS nfet_06v0 ad=10.51n pd=0.29m as=3.528n ps=0.195m w=147 l=120
X30 downstepper_test a_n1898_n981# VDD_3V3 VDD_3V3 pfet_06v0 ad=21.384n pd=0.662m as=21.384n ps=0.662m w=243 l=100
C0 VDD_3V3_uq0 5v0_half_adder_selector_sc_0/m1_n244_n517# 0
C1 ternary_output 5v0_half_adder_selector_sc_0/m1_n10_n948# 0.05319f
C2 m1_n1654_59# ctrl_sign 0
C3 VDD_3V3 5v0_half_adder_selector_sc_0/m1_n239_179# 0.00154f
C4 a_n1373_n454# m1_n698_624# 0
C5 VDD_3V3 a_n1325_n547# 0.16742f
C6 downstepper_test 5v0_half_adder_selector_sc_0/m1_n244_n517# 0.02897f
C7 5v0_half_adder_selector_sc_0/m1_n244_n517# VDD_1V65 0
C8 VDD_3V3 VDD_3V3_uq0 0
C9 a_n1205_n937# downstepper_test 0.00453f
C10 5v0_nti_sc_f_0/ternary_output a_n1325_n547# 0.21872f
C11 a_n1205_n937# VDD_1V65 0.00354f
C12 VDD_3V3 downstepper_test 0.41098f
C13 VDD_3V3_uq0 5v0_nti_sc_f_0/ternary_output 0.16211f
C14 m1_n698_624# ternary_input 0.02397f
C15 5v0_half_adder_selector_sc_0/m1_n9_n292# m1_n698_624# 0.27475f
C16 VDD_3V3 VDD_1V65 0.04713f
C17 a_n1373_n454# ternary_input 0.00136f
C18 downstepper_test 5v0_nti_sc_f_0/ternary_output 0.07077f
C19 VDD_1V65 5v0_nti_sc_f_0/ternary_output 0.21326f
C20 a_n1898_n981# m1_n698_624# 0
C21 a_n1778_n454# downstepper_test 0.0031f
C22 a_n1373_n454# a_n1898_n981# 0
C23 VDD_3V3 5v0_half_adder_selector_sc_0/m1_n244_n517# 0.27028f
C24 m1_n1654_59# m1_n698_624# 0
C25 a_n1778_n454# VDD_1V65 0
C26 5v0_half_adder_selector_sc_0/m1_n437_n664# ternary_input 0.02233f
C27 5v0_half_adder_selector_sc_0/m1_n9_n292# ternary_input 0.02636f
C28 5v0_half_adder_selector_sc_0/m1_n437_n664# 5v0_half_adder_selector_sc_0/m1_n9_n292# 0.04907f
C29 m1_n1654_59# a_n1373_n454# 0
C30 a_n1205_n937# VDD_3V3 0.00891f
C31 5v0_half_adder_selector_sc_0/m1_n244_n517# 5v0_nti_sc_f_0/ternary_output 0.00226f
C32 ternary_output downstepper_test 0.00248f
C33 ctrl_sign 5v0_half_adder_selector_sc_0/m1_n239_179# 0.30291f
C34 5v0_half_adder_selector_sc_0/m1_n10_n948# m1_n698_624# 0.00165f
C35 ctrl_sign a_n1325_n547# 0.00263f
C36 a_n1898_n981# ternary_input 0.02714f
C37 a_n1205_n937# 5v0_nti_sc_f_0/ternary_output 0
C38 ctrl_sign VDD_3V3_uq0 0.38402f
C39 VDD_3V3 5v0_nti_sc_f_0/ternary_output 0.40684f
C40 m1_n1654_59# ternary_input 0.5313f
C41 ctrl_sign downstepper_test 0.14523f
C42 ternary_output 5v0_half_adder_selector_sc_0/m1_n244_n517# 0.23201f
C43 m1_n1654_59# a_n1898_n981# 0.10928f
C44 5v0_half_adder_selector_sc_0/m1_n437_n664# 5v0_half_adder_selector_sc_0/m1_n10_n948# 0.06982f
C45 5v0_half_adder_selector_sc_0/m1_n10_n948# 5v0_half_adder_selector_sc_0/m1_n9_n292# 0.25895f
C46 a_n1778_n454# 5v0_nti_sc_f_0/ternary_output 0.00123f
C47 VDD_3V3 ternary_output 0.15496f
C48 ctrl_sign 5v0_half_adder_selector_sc_0/m1_n244_n517# 0.0109f
C49 m1_n698_624# 5v0_half_adder_selector_sc_0/m1_n239_179# 0.07502f
C50 m1_n698_624# a_n1325_n547# 0.0467f
C51 ternary_output 5v0_nti_sc_f_0/ternary_output 0
C52 VDD_3V3_uq0 m1_n698_624# 0.33323f
C53 a_n1373_n454# a_n1325_n547# 0.00135f
C54 VDD_3V3 ctrl_sign 0
C55 downstepper_test m1_n698_624# 0.38867f
C56 m1_n698_624# VDD_1V65 0.16859f
C57 a_n1373_n454# downstepper_test 0.00442f
C58 ctrl_sign 5v0_nti_sc_f_0/ternary_output 0
C59 ternary_input 5v0_half_adder_selector_sc_0/m1_n239_179# 0.00189f
C60 5v0_half_adder_selector_sc_0/m1_n437_n664# 5v0_half_adder_selector_sc_0/m1_n239_179# 0.00486f
C61 5v0_half_adder_selector_sc_0/m1_n9_n292# 5v0_half_adder_selector_sc_0/m1_n239_179# 0.18379f
C62 a_n1325_n547# ternary_input 0.08497f
C63 a_n1373_n454# VDD_1V65 0.00232f
C64 5v0_half_adder_selector_sc_0/m1_n9_n292# a_n1325_n547# 0
C65 VDD_3V3_uq0 ternary_input 0.96005f
C66 5v0_half_adder_selector_sc_0/m1_n437_n664# VDD_3V3_uq0 0.0015f
C67 5v0_half_adder_selector_sc_0/m1_n9_n292# VDD_3V3_uq0 0.02483f
C68 a_n1898_n981# a_n1325_n547# 0.08248f
C69 5v0_half_adder_selector_sc_0/m1_n244_n517# m1_n698_624# 0.00167f
C70 5v0_half_adder_selector_sc_0/m1_n437_n664# downstepper_test 0.00206f
C71 downstepper_test ternary_input 0.16132f
C72 downstepper_test 5v0_half_adder_selector_sc_0/m1_n9_n292# 0.25302f
C73 a_n1898_n981# VDD_3V3_uq0 0.00196f
C74 VDD_1V65 ternary_input 0.03394f
C75 m1_n1654_59# a_n1325_n547# 0.19351f
C76 a_n1205_n937# m1_n698_624# 0.00334f
C77 VDD_3V3 m1_n698_624# 0.13834f
C78 m1_n1654_59# VDD_3V3_uq0 0.551f
C79 downstepper_test a_n1898_n981# 0.18136f
C80 a_n1898_n981# VDD_1V65 0.01095f
C81 5v0_half_adder_selector_sc_0/m1_n10_n948# 5v0_half_adder_selector_sc_0/m1_n239_179# 0
C82 VDD_3V3 a_n1373_n454# 0.00122f
C83 m1_n1654_59# downstepper_test 0.08313f
C84 m1_n698_624# 5v0_nti_sc_f_0/ternary_output 0.11981f
C85 5v0_half_adder_selector_sc_0/m1_n244_n517# ternary_input 0.09044f
C86 5v0_half_adder_selector_sc_0/m1_n437_n664# 5v0_half_adder_selector_sc_0/m1_n244_n517# 0.37702f
C87 5v0_half_adder_selector_sc_0/m1_n9_n292# 5v0_half_adder_selector_sc_0/m1_n244_n517# 0.14284f
C88 m1_n1654_59# VDD_1V65 0.00115f
C89 a_n1373_n454# 5v0_nti_sc_f_0/ternary_output 0
C90 a_n1205_n937# ternary_input 0
C91 a_n1778_n454# m1_n698_624# 0
C92 a_n1205_n937# 5v0_half_adder_selector_sc_0/m1_n9_n292# 0
C93 5v0_half_adder_selector_sc_0/m1_n10_n948# downstepper_test 0.00615f
C94 VDD_3V3 ternary_input 0.15502f
C95 VDD_3V3 5v0_half_adder_selector_sc_0/m1_n437_n664# 0.40911f
C96 VDD_3V3 5v0_half_adder_selector_sc_0/m1_n9_n292# 0.13661f
C97 m1_n1654_59# 5v0_half_adder_selector_sc_0/m1_n244_n517# 0
C98 a_n1205_n937# a_n1898_n981# 0
C99 5v0_nti_sc_f_0/ternary_output ternary_input 0.60908f
C100 5v0_half_adder_selector_sc_0/m1_n9_n292# 5v0_nti_sc_f_0/ternary_output 0.00372f
C101 ternary_output m1_n698_624# 0
C102 VDD_3V3 a_n1898_n981# 0.59815f
C103 a_n1778_n454# ternary_input 0.00116f
C104 5v0_half_adder_selector_sc_0/m1_n10_n948# 5v0_half_adder_selector_sc_0/m1_n244_n517# 0.11606f
C105 m1_n1654_59# VDD_3V3 0.02893f
C106 a_n1898_n981# 5v0_nti_sc_f_0/ternary_output 0.20745f
C107 a_n1325_n547# 5v0_half_adder_selector_sc_0/m1_n239_179# 0
C108 ctrl_sign m1_n698_624# 0.08746f
C109 VDD_3V3_uq0 5v0_half_adder_selector_sc_0/m1_n239_179# 0.28989f
C110 VDD_3V3_uq0 a_n1325_n547# 0.23112f
C111 m1_n1654_59# 5v0_nti_sc_f_0/ternary_output 0.17279f
C112 a_n1778_n454# a_n1898_n981# 0.00212f
C113 VDD_3V3 5v0_half_adder_selector_sc_0/m1_n10_n948# 0.0303f
C114 ternary_output ternary_input 0.09966f
C115 5v0_half_adder_selector_sc_0/m1_n437_n664# ternary_output 0.18581f
C116 ternary_output 5v0_half_adder_selector_sc_0/m1_n9_n292# 0.11993f
C117 downstepper_test 5v0_half_adder_selector_sc_0/m1_n239_179# 0.09961f
C118 downstepper_test a_n1325_n547# 0.07797f
C119 m1_n1654_59# a_n1778_n454# 0.00135f
C120 VDD_1V65 a_n1325_n547# 0.14775f
C121 downstepper_test VDD_3V3_uq0 0.10943f
C122 VDD_3V3_uq0 VDD_1V65 0
C123 ctrl_sign ternary_input 0.0028f
C124 5v0_half_adder_selector_sc_0/m1_n437_n664# ctrl_sign 0.01302f
C125 ctrl_sign 5v0_half_adder_selector_sc_0/m1_n9_n292# 0.22345f
C126 downstepper_test VDD_1V65 0.13024f
C127 5v0_half_adder_selector_sc_0/m1_n244_n517# 5v0_half_adder_selector_sc_0/m1_n239_179# 0.00395f
C128 5v0_half_adder_selector_sc_0/m1_n244_n517# a_n1325_n547# 0
C129 VDD_1V65 VSS 0.09232f
C130 a_n1205_n937# VSS 0 ; **FLOATING
C131 a_n1373_n454# VSS 0.00335f ; **FLOATING
C132 a_n1778_n454# VSS 0.00573f ; **FLOATING
C133 a_n1898_n981# VSS 0.56173f ; **FLOATING
C134 a_n1325_n547# VSS 0.6002f ; **FLOATING
C135 5v0_nti_sc_f_0/ternary_output VSS 1.36076f
C136 m1_n1654_59# VSS 0.62941f ; **FLOATING
C137 VDD_3V3_uq0 VSS 6.3874f
C138 5v0_half_adder_selector_sc_0/m1_n437_n664# VSS 0.571f ; **FLOATING
C139 5v0_half_adder_selector_sc_0/m1_n10_n948# VSS 0.55254f ; **FLOATING
C140 ternary_output VSS 0.30264f
C141 5v0_half_adder_selector_sc_0/m1_n244_n517# VSS 0.39366f ; **FLOATING
C142 VDD_3V3 VSS 6.28664f
C143 5v0_half_adder_selector_sc_0/m1_n239_179# VSS 0.30065f ; **FLOATING
C144 5v0_half_adder_selector_sc_0/m1_n9_n292# VSS 0.50953f ; **FLOATING
C145 downstepper_test VSS 0.64154f
C146 ctrl_sign VSS 0.56557f
C147 m1_n698_624# VSS 0.54918f ; **FLOATING
C148 ternary_input VSS 1.48124f
