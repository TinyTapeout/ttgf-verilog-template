* NGSPICE file created from 5v0_add_q_sc.ext - technology: gf180mcuD

.option scale=5n

X0 m1_n1654_59# ternary_input VSS VSS nfet_06v0 ad=6.336n pd=0.32m as=6.336n ps=0.32m w=72 l=578
X1 VDD_3V3_uq0 ternary_input m1_n1654_59# VDD_3V3_uq0 pfet_06v0 ad=12.81n pd=0.349m as=12.688n ps=0.348m w=244 l=100
X2 m1_n1654_59# ternary_input VDD_3V3_uq0 VDD_3V3_uq0 pfet_06v0 ad=12.688n pd=0.348m as=21.472n ps=0.664m w=244 l=100
X3 m1_n1654_59# ternary_input VDD_3V3_uq0 VDD_3V3_uq0 pfet_06v0 ad=27.328n pd=0.712m as=12.81n ps=0.349m w=244 l=100
X4 5v0_nti_sc_f_0/ternary_output ternary_input VSS VSS nfet_06v0 ad=12.7n pd=0.454m as=11.303n ps=0.432m w=127 l=120
X5 5v0_nti_sc_f_0/ternary_output ternary_input VDD_3V3_uq0 VDD_3V3_uq0 pfet_06v0 ad=9.696n pd=0.394m as=8.928n ps=0.378m w=96 l=150
X6 5v0_half_adder_selector_sc_0/res_stage0 5v0_half_adder_selector_sc_0/m1_n239_179# downstepper_test VSS nfet_06v0 ad=14.432n pd=0.504m as=14.432n ps=0.504m w=164 l=120
X7 5v0_half_adder_selector_sc_0/res_stage0 5v0_half_adder_selector_sc_0/m1_n239_179# upstepper_test VDD_3V3_uq0 pfet_06v0 ad=21.472n pd=0.664m as=21.472n ps=0.664m w=244 l=100
X8 5v0_half_adder_selector_sc_0/m1_n239_179# ctrl_sign VSS VSS nfet_06v0 ad=14.432n pd=0.504m as=14.432n ps=0.504m w=164 l=120
X9 5v0_half_adder_selector_sc_0/m1_n239_179# ctrl_sign VDD_3V3_uq0 VDD_3V3_uq0 pfet_06v0 ad=21.472n pd=0.664m as=21.472n ps=0.664m w=244 l=100
X10 5v0_half_adder_selector_sc_0/res_stage0 ctrl_sign upstepper_test VSS nfet_06v0 ad=31.489n pd=1.041m as=43.711n ps=1.504m w=164 l=120
X11 5v0_half_adder_selector_sc_0/res_stage0 ctrl_sign downstepper_test VDD_3V3_uq0 pfet_06v0 ad=46.849n pd=1.361m as=42.856n ps=1.326m w=244 l=100
X12 ternary_output 5v0_half_adder_selector_sc_0/ctrl_over 5v0_half_adder_selector_sc_0/res_stage0 VSS nfet_06v0 ad=17.057n pd=0.537m as=0 ps=0 w=164 l=120
X13 ternary_output 5v0_half_adder_selector_sc_0/ctrl_over ternary_input VDD_3V3 pfet_06v0 ad=25.377n pd=0.697m as=21.472n ps=0.664m w=244 l=100
X14 5v0_half_adder_selector_sc_0/m1_n244_n517# 5v0_half_adder_selector_sc_0/ctrl_over VSS VSS nfet_06v0 ad=14.432n pd=0.504m as=0.10465u ps=3.768m w=164 l=120
X15 5v0_half_adder_selector_sc_0/m1_n244_n517# 5v0_half_adder_selector_sc_0/ctrl_over VDD_3V3 VDD_3V3 pfet_06v0 ad=21.472n pd=0.664m as=85.71201n ps=2.652m w=244 l=100
X16 ternary_output 5v0_half_adder_selector_sc_0/m1_n244_n517# ternary_input VSS nfet_06v0 ad=0 pd=0 as=14.432n ps=0.504m w=164 l=120
X17 ternary_output 5v0_half_adder_selector_sc_0/m1_n244_n517# 5v0_half_adder_selector_sc_0/res_stage0 VDD_3V3 pfet_06v0 ad=0 pd=0 as=0 ps=0 w=244 l=100
X18 a_n1325_n547# m1_n1654_59# VSS VSS nfet_06v0 ad=14.432n pd=0.504m as=14.432n ps=0.504m w=164 l=120
X19 a_n1325_n547# m1_n1654_59# VDD_3V3_uq0 VDD_3V3_uq0 pfet_06v0 ad=21.472n pd=0.664m as=21.472n ps=0.664m w=244 l=100
X20 a_n1898_n981# 5v0_nti_sc_f_0/ternary_output VSS VSS nfet_06v0 ad=14.432n pd=0.504m as=0 ps=0 w=164 l=120
X21 a_n1898_n981# 5v0_nti_sc_f_0/ternary_output VDD_3V3 VDD_3V3 pfet_06v0 ad=21.472n pd=0.664m as=0 ps=0 w=244 l=100
X22 a_n1373_n454# a_n1898_n981# downstepper_test VSS nfet_06v0 ad=3.528n pd=0.195m as=8.599n ps=0.264m w=147 l=120
X23 upstepper_test 5v0_nti_sc_f_0/ternary_output a_n1205_n937# VDD_3V3 pfet_06v0 ad=21.384n pd=0.662m as=5.832n ps=0.291m w=243 l=100
X24 upstepper_test 5v0_nti_sc_f_0/ternary_output VDD_1V65 VSS nfet_06v0 ad=14.847n pd=0.496m as=10.51n ps=0.29m w=147 l=120
X25 a_n1205_n937# a_n1325_n547# VDD_3V3 VDD_3V3 pfet_06v0 ad=5.832n pd=0.291m as=21.384n ps=0.662m w=243 l=100
X26 downstepper_test m1_n1654_59# a_n1778_n454# VSS nfet_06v0 ad=8.599n pd=0.264m as=3.528n ps=0.195m w=147 l=120
X27 a_n1778_n454# a_n1898_n981# VSS VSS nfet_06v0 ad=3.528n pd=0.195m as=14.847n ps=0.496m w=147 l=120
X28 upstepper_test a_n1325_n547# VSS VSS nfet_06v0 ad=14.432n pd=0.504m as=14.432n ps=0.504m w=164 l=120
X29 VDD_1V65 a_n1325_n547# a_n1373_n454# VSS nfet_06v0 ad=10.51n pd=0.29m as=3.528n ps=0.195m w=147 l=120
X30 downstepper_test a_n1898_n981# VDD_3V3 VDD_3V3 pfet_06v0 ad=21.384n pd=0.662m as=21.384n ps=0.662m w=243 l=100
C0 upstepper_test 5v0_nti_sc_f_0/ternary_output 0.11981f
C1 a_n1373_n454# downstepper_test 0.00442f
C2 VDD_3V3_uq0 VDD_3V3 0
C3 VDD_3V3 5v0_half_adder_selector_sc_0/res_stage0 0.13661f
C4 downstepper_test VDD_3V3 0.41098f
C5 ternary_output 5v0_half_adder_selector_sc_0/ctrl_over 0.18581f
C6 VDD_3V3_uq0 a_n1325_n547# 0.23112f
C7 a_n1325_n547# 5v0_half_adder_selector_sc_0/res_stage0 0
C8 5v0_half_adder_selector_sc_0/m1_n244_n517# 5v0_half_adder_selector_sc_0/m1_n239_179# 0.00395f
C9 a_n1898_n981# VDD_1V65 0.01095f
C10 downstepper_test a_n1325_n547# 0.07797f
C11 a_n1778_n454# m1_n1654_59# 0.00135f
C12 5v0_half_adder_selector_sc_0/5v0_tgate_sel_2_sc_1/input_A 5v0_half_adder_selector_sc_0/res_stage0 0.00385f
C13 a_n1373_n454# a_n1898_n981# 0
C14 a_n1373_n454# VDD_1V65 0.00232f
C15 VDD_3V3_uq0 ternary_input 0.96005f
C16 5v0_half_adder_selector_sc_0/res_stage0 ternary_input 0.28146f
C17 5v0_half_adder_selector_sc_0/m1_n244_n517# ctrl_sign 0.0109f
C18 VDD_3V3_uq0 upstepper_test 0.33323f
C19 upstepper_test 5v0_half_adder_selector_sc_0/res_stage0 0.27475f
C20 downstepper_test 5v0_half_adder_selector_sc_0/5v0_tgate_sel_2_sc_1/input_A 0
C21 5v0_half_adder_selector_sc_0/m1_n244_n517# 5v0_nti_sc_f_0/ternary_output 0.00226f
C22 a_n1898_n981# VDD_3V3 0.59815f
C23 downstepper_test ternary_input 0.16661f
C24 VDD_3V3 VDD_1V65 0.04713f
C25 a_n1373_n454# VDD_3V3 0.00122f
C26 downstepper_test upstepper_test 0.38867f
C27 5v0_half_adder_selector_sc_0/ctrl_over 5v0_half_adder_selector_sc_0/m1_n239_179# 0.00486f
C28 ternary_output 5v0_nti_sc_f_0/ternary_output 0
C29 a_n1898_n981# a_n1325_n547# 0.08248f
C30 a_n1325_n547# VDD_1V65 0.14775f
C31 a_n1373_n454# a_n1325_n547# 0.00135f
C32 5v0_nti_sc_f_0/ternary_output a_n1778_n454# 0.00123f
C33 5v0_half_adder_selector_sc_0/ctrl_over ctrl_sign 0.01302f
C34 ctrl_sign m1_n1654_59# 0
C35 a_n1898_n981# ternary_input 0.02714f
C36 VDD_3V3 a_n1325_n547# 0.16742f
C37 VDD_1V65 ternary_input 0.03394f
C38 a_n1373_n454# ternary_input 0.00136f
C39 5v0_nti_sc_f_0/ternary_output m1_n1654_59# 0.17279f
C40 upstepper_test a_n1898_n981# 0
C41 5v0_half_adder_selector_sc_0/m1_n244_n517# VDD_3V3_uq0 0
C42 5v0_half_adder_selector_sc_0/m1_n244_n517# 5v0_half_adder_selector_sc_0/res_stage0 0.14284f
C43 upstepper_test VDD_1V65 0.16859f
C44 a_n1373_n454# upstepper_test 0
C45 5v0_half_adder_selector_sc_0/5v0_tgate_sel_2_sc_1/input_A VDD_3V3 0.03098f
C46 VDD_3V3 ternary_input 0.15434f
C47 downstepper_test 5v0_half_adder_selector_sc_0/m1_n244_n517# 0.02897f
C48 ctrl_sign 5v0_half_adder_selector_sc_0/m1_n239_179# 0.30291f
C49 ternary_output VDD_3V3_uq0 0
C50 upstepper_test VDD_3V3 0.13834f
C51 ternary_output 5v0_half_adder_selector_sc_0/res_stage0 0.11993f
C52 5v0_nti_sc_f_0/ternary_output a_n1205_n937# 0
C53 a_n1325_n547# ternary_input 0.08497f
C54 ternary_output downstepper_test 0.00248f
C55 upstepper_test a_n1325_n547# 0.0467f
C56 ctrl_sign 5v0_nti_sc_f_0/ternary_output 0
C57 VDD_3V3_uq0 5v0_half_adder_selector_sc_0/ctrl_over 0.0015f
C58 VDD_3V3_uq0 m1_n1654_59# 0.551f
C59 5v0_half_adder_selector_sc_0/ctrl_over 5v0_half_adder_selector_sc_0/res_stage0 0.04907f
C60 downstepper_test a_n1778_n454# 0.0031f
C61 upstepper_test 5v0_half_adder_selector_sc_0/5v0_tgate_sel_2_sc_1/input_A 0
C62 5v0_half_adder_selector_sc_0/m1_n244_n517# VDD_1V65 0
C63 upstepper_test ternary_input 0.02545f
C64 downstepper_test 5v0_half_adder_selector_sc_0/ctrl_over 0.00206f
C65 downstepper_test m1_n1654_59# 0.08313f
C66 VDD_3V3_uq0 5v0_half_adder_selector_sc_0/m1_n239_179# 0.28989f
C67 5v0_half_adder_selector_sc_0/m1_n239_179# 5v0_half_adder_selector_sc_0/res_stage0 0.18379f
C68 5v0_half_adder_selector_sc_0/res_stage0 a_n1205_n937# 0
C69 5v0_half_adder_selector_sc_0/m1_n244_n517# VDD_3V3 0.27028f
C70 downstepper_test 5v0_half_adder_selector_sc_0/m1_n239_179# 0.09961f
C71 downstepper_test a_n1205_n937# 0.00453f
C72 a_n1898_n981# a_n1778_n454# 0.00212f
C73 VDD_3V3_uq0 ctrl_sign 0.38402f
C74 VDD_1V65 a_n1778_n454# 0
C75 5v0_half_adder_selector_sc_0/m1_n244_n517# a_n1325_n547# 0
C76 ctrl_sign 5v0_half_adder_selector_sc_0/res_stage0 0.22345f
C77 ternary_output VDD_3V3 0.15496f
C78 a_n1898_n981# m1_n1654_59# 0.10928f
C79 VDD_3V3_uq0 5v0_nti_sc_f_0/ternary_output 0.16211f
C80 5v0_nti_sc_f_0/ternary_output 5v0_half_adder_selector_sc_0/res_stage0 0.00372f
C81 VDD_1V65 m1_n1654_59# 0.00115f
C82 a_n1373_n454# m1_n1654_59# 0
C83 5v0_half_adder_selector_sc_0/m1_n244_n517# 5v0_half_adder_selector_sc_0/5v0_tgate_sel_2_sc_1/input_A 0.07353f
C84 downstepper_test ctrl_sign 0.14523f
C85 5v0_half_adder_selector_sc_0/m1_n244_n517# ternary_input 0.13297f
C86 downstepper_test 5v0_nti_sc_f_0/ternary_output 0.07077f
C87 5v0_half_adder_selector_sc_0/m1_n244_n517# upstepper_test 0.00167f
C88 5v0_half_adder_selector_sc_0/ctrl_over VDD_3V3 0.40911f
C89 VDD_3V3 m1_n1654_59# 0.02893f
C90 a_n1898_n981# a_n1205_n937# 0
C91 VDD_1V65 a_n1205_n937# 0.00354f
C92 ternary_output ternary_input 0.19159f
C93 a_n1325_n547# m1_n1654_59# 0.19351f
C94 ternary_output upstepper_test 0
C95 VDD_3V3 5v0_half_adder_selector_sc_0/m1_n239_179# 0.00154f
C96 VDD_3V3 a_n1205_n937# 0.00891f
C97 VDD_3V3_uq0 5v0_half_adder_selector_sc_0/res_stage0 0.02483f
C98 a_n1778_n454# ternary_input 0.00116f
C99 a_n1898_n981# 5v0_nti_sc_f_0/ternary_output 0.20745f
C100 5v0_half_adder_selector_sc_0/ctrl_over 5v0_half_adder_selector_sc_0/5v0_tgate_sel_2_sc_1/input_A 0.01944f
C101 5v0_nti_sc_f_0/ternary_output VDD_1V65 0.21326f
C102 upstepper_test a_n1778_n454# 0
C103 a_n1373_n454# 5v0_nti_sc_f_0/ternary_output 0
C104 5v0_half_adder_selector_sc_0/ctrl_over ternary_input 0.0727f
C105 m1_n1654_59# ternary_input 0.5313f
C106 downstepper_test VDD_3V3_uq0 0.10943f
C107 a_n1325_n547# 5v0_half_adder_selector_sc_0/m1_n239_179# 0
C108 downstepper_test 5v0_half_adder_selector_sc_0/res_stage0 0.25302f
C109 ctrl_sign VDD_3V3 0
C110 upstepper_test m1_n1654_59# 0
C111 VDD_3V3 5v0_nti_sc_f_0/ternary_output 0.40684f
C112 ctrl_sign a_n1325_n547# 0.00263f
C113 5v0_half_adder_selector_sc_0/m1_n239_179# ternary_input 0.00191f
C114 a_n1205_n937# ternary_input 0
C115 upstepper_test 5v0_half_adder_selector_sc_0/m1_n239_179# 0.07502f
C116 5v0_nti_sc_f_0/ternary_output a_n1325_n547# 0.21872f
C117 ternary_output 5v0_half_adder_selector_sc_0/m1_n244_n517# 0.23201f
C118 upstepper_test a_n1205_n937# 0.00334f
C119 5v0_half_adder_selector_sc_0/5v0_tgate_sel_2_sc_1/input_A ctrl_sign 0
C120 VDD_3V3_uq0 a_n1898_n981# 0.00196f
C121 VDD_3V3_uq0 VDD_1V65 0
C122 ctrl_sign ternary_input 0.00264f
C123 upstepper_test ctrl_sign 0.08746f
C124 5v0_nti_sc_f_0/ternary_output ternary_input 0.60908f
C125 downstepper_test a_n1898_n981# 0.18136f
C126 downstepper_test VDD_1V65 0.13024f
C127 5v0_half_adder_selector_sc_0/m1_n244_n517# 5v0_half_adder_selector_sc_0/ctrl_over 0.37702f
C128 5v0_half_adder_selector_sc_0/m1_n244_n517# m1_n1654_59# 0
C129 VDD_1V65 VSS 0.09232f
C130 a_n1205_n937# VSS 0 ; **FLOATING
C131 a_n1373_n454# VSS 0.00335f ; **FLOATING
C132 a_n1778_n454# VSS 0.00573f ; **FLOATING
C133 a_n1898_n981# VSS 0.56173f ; **FLOATING
C134 a_n1325_n547# VSS 0.6002f ; **FLOATING
C135 5v0_nti_sc_f_0/ternary_output VSS 1.36077f
C136 m1_n1654_59# VSS 0.62941f ; **FLOATING
C137 5v0_half_adder_selector_sc_0/5v0_tgate_sel_2_sc_1/input_A VSS 0
C138 5v0_half_adder_selector_sc_0/ctrl_over VSS 0.571f
C139 ternary_input VSS 2.00726f
C140 ternary_output VSS 0.28152f
C141 5v0_half_adder_selector_sc_0/m1_n244_n517# VSS 0.39366f ; **FLOATING
C142 VDD_3V3 VSS 6.28492f
C143 5v0_half_adder_selector_sc_0/m1_n239_179# VSS 0.30065f ; **FLOATING
C144 5v0_half_adder_selector_sc_0/res_stage0 VSS 0.50953f
C145 downstepper_test VSS 0.64154f
C146 ctrl_sign VSS 0.56557f
C147 VDD_3V3_uq0 VSS 6.37692f
C148 upstepper_test VSS 0.54918f
