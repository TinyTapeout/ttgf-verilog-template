* NGSPICE file created from 5v0_add_q_sc.ext - technology: gf180mcuD

.option scale=5n

X0 pti ternary_input VSS VSS nfet_06v0 ad=6.336n pd=0.32m as=6.336n ps=0.32m w=72 l=578
X1 VDD_3V3 ternary_input pti VDD_3V3 pfet_06v0 ad=12.81n pd=0.349m as=12.688n ps=0.348m w=244 l=100
X2 pti ternary_input VDD_3V3 VDD_3V3 pfet_06v0 ad=12.688n pd=0.348m as=21.472n ps=0.664m w=244 l=100
X3 pti ternary_input VDD_3V3 VDD_3V3 pfet_06v0 ad=27.328n pd=0.712m as=12.81n ps=0.349m w=244 l=100
X4 nti ternary_input VSS VSS nfet_06v0 ad=12.7n pd=0.454m as=11.303n ps=0.432m w=127 l=120
X5 nti ternary_input VDD_3V3 VDD_3V3 pfet_06v0 ad=9.696n pd=0.394m as=8.928n ps=0.378m w=96 l=150
X6 5v0_half_adder_selector_sc_0/res_stage0 5v0_half_adder_selector_sc_0/m1_n239_179# downstepper_test VSS nfet_06v0 ad=14.432n pd=0.504m as=14.432n ps=0.504m w=164 l=120
X7 5v0_half_adder_selector_sc_0/res_stage0 5v0_half_adder_selector_sc_0/m1_n239_179# upstepper_test VDD_3V3 pfet_06v0 ad=21.472n pd=0.664m as=21.472n ps=0.664m w=244 l=100
X8 5v0_half_adder_selector_sc_0/m1_n239_179# ctrl_sign VSS VSS nfet_06v0 ad=14.432n pd=0.504m as=14.432n ps=0.504m w=164 l=120
X9 5v0_half_adder_selector_sc_0/m1_n239_179# ctrl_sign VDD_3V3 VDD_3V3 pfet_06v0 ad=21.472n pd=0.664m as=21.472n ps=0.664m w=244 l=100
X10 5v0_half_adder_selector_sc_0/res_stage0 ctrl_sign upstepper_test VSS nfet_06v0 ad=31.489n pd=1.041m as=43.711n ps=1.504m w=164 l=120
X11 5v0_half_adder_selector_sc_0/res_stage0 ctrl_sign downstepper_test VDD_3V3 pfet_06v0 ad=46.849n pd=1.361m as=42.856n ps=1.326m w=244 l=100
X12 ternary_output ctrl_over 5v0_half_adder_selector_sc_0/res_stage0 VSS nfet_06v0 ad=17.057n pd=0.537m as=0 ps=0 w=164 l=120
X13 ternary_output ctrl_over ternary_input VDD_3V3_uq0 pfet_06v0 ad=25.377n pd=0.697m as=21.472n ps=0.664m w=244 l=100
X14 5v0_half_adder_selector_sc_0/m1_n244_n517# ctrl_over VSS VSS nfet_06v0 ad=14.432n pd=0.504m as=0.10465u ps=3.768m w=164 l=120
X15 5v0_half_adder_selector_sc_0/m1_n244_n517# ctrl_over VDD_3V3_uq0 VDD_3V3_uq0 pfet_06v0 ad=21.472n pd=0.664m as=85.71201n ps=2.652m w=244 l=100
X16 ternary_output 5v0_half_adder_selector_sc_0/m1_n244_n517# ternary_input VSS nfet_06v0 ad=0 pd=0 as=14.432n ps=0.504m w=164 l=120
X17 ternary_output 5v0_half_adder_selector_sc_0/m1_n244_n517# 5v0_half_adder_selector_sc_0/res_stage0 VDD_3V3_uq0 pfet_06v0 ad=0 pd=0 as=0 ps=0 w=244 l=100
X18 inv_pti pti VSS VSS nfet_06v0 ad=14.432n pd=0.504m as=14.432n ps=0.504m w=164 l=120
X19 inv_pti pti VDD_3V3 VDD_3V3 pfet_06v0 ad=21.472n pd=0.664m as=21.472n ps=0.664m w=244 l=100
X20 inv_nti nti VSS VSS nfet_06v0 ad=14.432n pd=0.504m as=0 ps=0 w=164 l=120
X21 inv_nti nti VDD_3V3_uq0 VDD_3V3_uq0 pfet_06v0 ad=21.472n pd=0.664m as=0 ps=0 w=244 l=100
X22 a_n1373_n454# inv_nti downstepper_test VSS nfet_06v0 ad=3.528n pd=0.195m as=8.599n ps=0.264m w=147 l=120
X23 upstepper_test nti a_n1205_n937# VDD_3V3_uq0 pfet_06v0 ad=21.384n pd=0.662m as=5.832n ps=0.291m w=243 l=100
X24 upstepper_test nti VDD_1V65 VSS nfet_06v0 ad=14.847n pd=0.496m as=10.51n ps=0.29m w=147 l=120
X25 a_n1205_n937# inv_pti VDD_3V3_uq0 VDD_3V3_uq0 pfet_06v0 ad=5.832n pd=0.291m as=21.384n ps=0.662m w=243 l=100
X26 downstepper_test pti a_n1778_n454# VSS nfet_06v0 ad=8.599n pd=0.264m as=3.528n ps=0.195m w=147 l=120
X27 a_n1778_n454# inv_nti VSS VSS nfet_06v0 ad=3.528n pd=0.195m as=14.847n ps=0.496m w=147 l=120
X28 upstepper_test inv_pti VSS VSS nfet_06v0 ad=14.432n pd=0.504m as=14.432n ps=0.504m w=164 l=120
X29 VDD_1V65 inv_pti a_n1373_n454# VSS nfet_06v0 ad=10.51n pd=0.29m as=3.528n ps=0.195m w=147 l=120
X30 downstepper_test inv_nti VDD_3V3_uq0 VDD_3V3_uq0 pfet_06v0 ad=21.384n pd=0.662m as=21.384n ps=0.662m w=243 l=100
C0 a_n1205_n937# ternary_input 0
C1 5v0_half_adder_selector_sc_0/res_stage0 5v0_half_adder_selector_sc_0/m1_n244_n517# 0.14284f
C2 5v0_half_adder_selector_sc_0/m1_n244_n517# ctrl_over 0.37702f
C3 5v0_half_adder_selector_sc_0/res_stage0 upstepper_test 0.27475f
C4 upstepper_test ctrl_over 0
C5 VDD_3V3 ctrl_sign 0.3841f
C6 a_n1205_n937# 5v0_half_adder_selector_sc_0/res_stage0 0
C7 5v0_half_adder_selector_sc_0/m1_n239_179# ctrl_sign 0.30291f
C8 a_n1778_n454# downstepper_test 0.0031f
C9 VDD_3V3 VDD_3V3_uq0 0
C10 VDD_3V3 inv_pti 0.23387f
C11 a_n1778_n454# nti 0.00123f
C12 ctrl_sign downstepper_test 0.14523f
C13 5v0_half_adder_selector_sc_0/m1_n244_n517# VDD_1V65 0
C14 a_n1778_n454# ternary_input 0.00116f
C15 ctrl_sign nti 0
C16 upstepper_test 5v0_half_adder_selector_sc_0/m1_n244_n517# 0.00167f
C17 5v0_half_adder_selector_sc_0/m1_n244_n517# pti 0
C18 upstepper_test VDD_1V65 0.16859f
C19 VDD_1V65 pti 0.00115f
C20 ctrl_sign ternary_input 0.00264f
C21 ternary_output downstepper_test 0.00248f
C22 upstepper_test pti 0
C23 a_n1205_n937# VDD_1V65 0.00354f
C24 5v0_half_adder_selector_sc_0/m1_n239_179# VDD_3V3_uq0 0.00154f
C25 5v0_half_adder_selector_sc_0/m1_n239_179# inv_pti 0
C26 a_n1205_n937# upstepper_test 0.00334f
C27 ternary_output nti 0
C28 VDD_3V3_uq0 downstepper_test 0.41098f
C29 inv_pti downstepper_test 0.07797f
C30 ternary_output ternary_input 0.19159f
C31 5v0_half_adder_selector_sc_0/res_stage0 ctrl_sign 0.22345f
C32 ctrl_sign ctrl_over 0.01302f
C33 VDD_3V3_uq0 nti 0.40684f
C34 inv_pti nti 0.21872f
C35 VDD_3V3_uq0 a_n1373_n454# 0.00122f
C36 inv_pti a_n1373_n454# 0.00135f
C37 VDD_3V3_uq0 ternary_input 0.15434f
C38 inv_pti ternary_input 0.08497f
C39 ternary_output 5v0_half_adder_selector_sc_0/res_stage0 0.11993f
C40 ternary_output ctrl_over 0.18581f
C41 5v0_half_adder_selector_sc_0/5v0_tgate_sel_2_sc_1/input_A downstepper_test 0
C42 5v0_half_adder_selector_sc_0/res_stage0 VDD_3V3_uq0 0.13661f
C43 ctrl_over VDD_3V3_uq0 0.40911f
C44 5v0_half_adder_selector_sc_0/res_stage0 inv_pti 0
C45 VDD_3V3 inv_nti 0.00196f
C46 a_n1778_n454# VDD_1V65 0
C47 upstepper_test a_n1778_n454# 0
C48 a_n1778_n454# pti 0.00135f
C49 5v0_half_adder_selector_sc_0/m1_n244_n517# ctrl_sign 0.0109f
C50 upstepper_test ctrl_sign 0.08746f
C51 ctrl_sign pti 0
C52 5v0_half_adder_selector_sc_0/res_stage0 5v0_half_adder_selector_sc_0/5v0_tgate_sel_2_sc_1/input_A 0.00385f
C53 5v0_half_adder_selector_sc_0/5v0_tgate_sel_2_sc_1/input_A ctrl_over 0.01944f
C54 ternary_output 5v0_half_adder_selector_sc_0/m1_n244_n517# 0.23201f
C55 ternary_output upstepper_test 0
C56 inv_nti downstepper_test 0.18136f
C57 5v0_half_adder_selector_sc_0/m1_n244_n517# VDD_3V3_uq0 0.27028f
C58 inv_nti nti 0.20745f
C59 5v0_half_adder_selector_sc_0/m1_n244_n517# inv_pti 0
C60 VDD_1V65 VDD_3V3_uq0 0.04713f
C61 VDD_1V65 inv_pti 0.14775f
C62 inv_nti a_n1373_n454# 0
C63 upstepper_test VDD_3V3_uq0 0.13834f
C64 VDD_3V3_uq0 pti 0.02893f
C65 inv_nti ternary_input 0.02714f
C66 upstepper_test inv_pti 0.04606f
C67 inv_pti pti 0.19351f
C68 a_n1205_n937# VDD_3V3_uq0 0.00891f
C69 5v0_half_adder_selector_sc_0/5v0_tgate_sel_2_sc_1/input_A 5v0_half_adder_selector_sc_0/m1_n244_n517# 0.07353f
C70 VDD_3V3 5v0_half_adder_selector_sc_0/m1_n239_179# 0.28989f
C71 5v0_half_adder_selector_sc_0/5v0_tgate_sel_2_sc_1/input_A upstepper_test 0
C72 VDD_3V3 downstepper_test 0.10966f
C73 VDD_3V3 nti 0.16206f
C74 VDD_3V3 ternary_input 0.96008f
C75 ternary_output ctrl_sign 0
C76 5v0_half_adder_selector_sc_0/m1_n239_179# downstepper_test 0.09961f
C77 inv_nti VDD_1V65 0.01095f
C78 VDD_3V3 5v0_half_adder_selector_sc_0/res_stage0 0.02483f
C79 VDD_3V3 ctrl_over 0.0015f
C80 ctrl_sign VDD_3V3_uq0 0
C81 ctrl_sign inv_pti 0.00263f
C82 upstepper_test inv_nti 0
C83 inv_nti pti 0.10928f
C84 5v0_half_adder_selector_sc_0/m1_n239_179# ternary_input 0.00191f
C85 a_n1205_n937# inv_nti 0
C86 nti downstepper_test 0.07077f
C87 downstepper_test a_n1373_n454# 0.00442f
C88 ternary_output VDD_3V3_uq0 0.15496f
C89 ternary_input downstepper_test 0.16661f
C90 nti a_n1373_n454# 0
C91 5v0_half_adder_selector_sc_0/m1_n239_179# 5v0_half_adder_selector_sc_0/res_stage0 0.18379f
C92 5v0_half_adder_selector_sc_0/m1_n239_179# ctrl_over 0.00486f
C93 ternary_input nti 0.60908f
C94 5v0_half_adder_selector_sc_0/5v0_tgate_sel_2_sc_1/input_A ctrl_sign 0
C95 ternary_input a_n1373_n454# 0.00136f
C96 VDD_3V3_uq0 inv_pti 0.16742f
C97 5v0_half_adder_selector_sc_0/res_stage0 downstepper_test 0.25302f
C98 ctrl_over downstepper_test 0.00206f
C99 5v0_half_adder_selector_sc_0/res_stage0 nti 0.00372f
C100 VDD_3V3 5v0_half_adder_selector_sc_0/m1_n244_n517# 0
C101 VDD_3V3 VDD_1V65 0
C102 5v0_half_adder_selector_sc_0/res_stage0 ternary_input 0.28146f
C103 ctrl_over ternary_input 0.0727f
C104 VDD_3V3 upstepper_test 0.33479f
C105 VDD_3V3 pti 0.55208f
C106 5v0_half_adder_selector_sc_0/5v0_tgate_sel_2_sc_1/input_A VDD_3V3_uq0 0.03098f
C107 inv_nti a_n1778_n454# 0.00212f
C108 5v0_half_adder_selector_sc_0/res_stage0 ctrl_over 0.04907f
C109 5v0_half_adder_selector_sc_0/m1_n239_179# 5v0_half_adder_selector_sc_0/m1_n244_n517# 0.00395f
C110 5v0_half_adder_selector_sc_0/m1_n239_179# upstepper_test 0.07502f
C111 5v0_half_adder_selector_sc_0/m1_n244_n517# downstepper_test 0.02897f
C112 VDD_1V65 downstepper_test 0.13024f
C113 upstepper_test downstepper_test 0.38867f
C114 5v0_half_adder_selector_sc_0/m1_n244_n517# nti 0.00226f
C115 downstepper_test pti 0.08313f
C116 VDD_1V65 nti 0.21326f
C117 a_n1205_n937# downstepper_test 0.00453f
C118 VDD_1V65 a_n1373_n454# 0.00232f
C119 upstepper_test nti 0.11981f
C120 nti pti 0.17279f
C121 5v0_half_adder_selector_sc_0/m1_n244_n517# ternary_input 0.13297f
C122 VDD_1V65 ternary_input 0.03394f
C123 upstepper_test a_n1373_n454# 0
C124 pti a_n1373_n454# 0
C125 a_n1205_n937# nti 0
C126 inv_nti VDD_3V3_uq0 0.59815f
C127 upstepper_test ternary_input 0.02545f
C128 inv_nti inv_pti 0.08248f
C129 ternary_input pti 0.5313f
C130 pti VSS 0.62941f
C131 VDD_1V65 VSS 0.09232f
C132 inv_nti VSS 0.56173f
C133 inv_pti VSS 0.59892f
C134 a_n1205_n937# VSS 0 ; **FLOATING
C135 a_n1373_n454# VSS 0.00335f ; **FLOATING
C136 a_n1778_n454# VSS 0.00573f ; **FLOATING
C137 nti VSS 1.36077f
C138 VDD_3V3 VSS 6.27502f
C139 5v0_half_adder_selector_sc_0/5v0_tgate_sel_2_sc_1/input_A VSS 0
C140 ctrl_over VSS 0.55135f
C141 ternary_input VSS 2.00726f
C142 ternary_output VSS 0.28152f
C143 5v0_half_adder_selector_sc_0/m1_n244_n517# VSS 0.39366f ; **FLOATING
C144 VDD_3V3_uq0 VSS 6.2849f
C145 5v0_half_adder_selector_sc_0/m1_n239_179# VSS 0.30065f ; **FLOATING
C146 5v0_half_adder_selector_sc_0/res_stage0 VSS 0.50953f
C147 downstepper_test VSS 0.64154f
C148 ctrl_sign VSS 0.56557f
C149 upstepper_test VSS 0.54869f
