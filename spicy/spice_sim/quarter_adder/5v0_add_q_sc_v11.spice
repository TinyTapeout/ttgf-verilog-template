* NGSPICE file created from 5v0_add_q_sc.ext - technology: gf180mcuD

.option scale=5n

X0 pti ternary_input VSS VSS nfet_06v0 ad=6.336n pd=0.32m as=6.336n ps=0.32m w=72 l=578
X1 VDD_3V3_uq0 ternary_input pti VDD_3V3_uq0 pfet_06v0 ad=12.81n pd=0.349m as=12.688n ps=0.348m w=244 l=100
X2 pti ternary_input VDD_3V3_uq0 VDD_3V3_uq0 pfet_06v0 ad=12.688n pd=0.348m as=21.472n ps=0.664m w=244 l=100
X3 pti ternary_input VDD_3V3_uq0 VDD_3V3_uq0 pfet_06v0 ad=27.328n pd=0.712m as=12.81n ps=0.349m w=244 l=100
X4 nti ternary_input VSS VSS nfet_06v0 ad=12.7n pd=0.454m as=11.303n ps=0.432m w=127 l=120
X5 nti ternary_input VDD_3V3_uq0 VDD_3V3_uq0 pfet_06v0 ad=9.696n pd=0.394m as=8.928n ps=0.378m w=96 l=150
X6 5v0_half_adder_selector_sc_0/res_stage0 5v0_half_adder_selector_sc_0/m1_n239_179# downstepper_test VSS nfet_06v0 ad=14.432n pd=0.504m as=14.432n ps=0.504m w=164 l=120
X7 5v0_half_adder_selector_sc_0/res_stage0 5v0_half_adder_selector_sc_0/m1_n239_179# upstepper_test VDD_3V3_uq0 pfet_06v0 ad=21.472n pd=0.664m as=21.472n ps=0.664m w=244 l=100
X8 5v0_half_adder_selector_sc_0/m1_n239_179# ctrl_sign VSS VSS nfet_06v0 ad=14.432n pd=0.504m as=14.432n ps=0.504m w=164 l=120
X9 5v0_half_adder_selector_sc_0/m1_n239_179# ctrl_sign VDD_3V3_uq0 VDD_3V3_uq0 pfet_06v0 ad=21.472n pd=0.664m as=21.472n ps=0.664m w=244 l=100
X10 5v0_half_adder_selector_sc_0/res_stage0 ctrl_sign upstepper_test VSS nfet_06v0 ad=31.489n pd=1.041m as=43.711n ps=1.504m w=164 l=120
X11 5v0_half_adder_selector_sc_0/res_stage0 ctrl_sign downstepper_test VDD_3V3_uq0 pfet_06v0 ad=46.849n pd=1.361m as=42.856n ps=1.326m w=244 l=100
X12 ternary_output 5v0_half_adder_selector_sc_0/ctrl_over 5v0_half_adder_selector_sc_0/res_stage0 VSS nfet_06v0 ad=17.057n pd=0.537m as=0 ps=0 w=164 l=120
X13 ternary_output 5v0_half_adder_selector_sc_0/ctrl_over ternary_input VDD_3V3 pfet_06v0 ad=25.377n pd=0.697m as=21.472n ps=0.664m w=244 l=100
X14 5v0_half_adder_selector_sc_0/m1_n244_n517# 5v0_half_adder_selector_sc_0/ctrl_over VSS VSS nfet_06v0 ad=14.432n pd=0.504m as=0.10465u ps=3.768m w=164 l=120
X15 5v0_half_adder_selector_sc_0/m1_n244_n517# 5v0_half_adder_selector_sc_0/ctrl_over VDD_3V3 VDD_3V3 pfet_06v0 ad=21.472n pd=0.664m as=85.71201n ps=2.652m w=244 l=100
X16 ternary_output 5v0_half_adder_selector_sc_0/m1_n244_n517# ternary_input VSS nfet_06v0 ad=0 pd=0 as=14.432n ps=0.504m w=164 l=120
X17 ternary_output 5v0_half_adder_selector_sc_0/m1_n244_n517# 5v0_half_adder_selector_sc_0/res_stage0 VDD_3V3 pfet_06v0 ad=0 pd=0 as=0 ps=0 w=244 l=100
X18 inv_pti pti VSS VSS nfet_06v0 ad=14.432n pd=0.504m as=14.432n ps=0.504m w=164 l=120
X19 inv_pti pti VDD_3V3_uq0 VDD_3V3_uq0 pfet_06v0 ad=21.472n pd=0.664m as=21.472n ps=0.664m w=244 l=100
X20 inv_nti nti VSS VSS nfet_06v0 ad=14.432n pd=0.504m as=0 ps=0 w=164 l=120
X21 inv_nti nti VDD_3V3 VDD_3V3 pfet_06v0 ad=21.472n pd=0.664m as=0 ps=0 w=244 l=100
X22 a_n1373_n454# inv_nti downstepper_test VSS nfet_06v0 ad=3.528n pd=0.195m as=8.599n ps=0.264m w=147 l=120
X23 upstepper_test nti a_n1205_n937# VDD_3V3 pfet_06v0 ad=21.384n pd=0.662m as=5.832n ps=0.291m w=243 l=100
X24 upstepper_test nti VDD_1V65 VSS nfet_06v0 ad=14.847n pd=0.496m as=10.51n ps=0.29m w=147 l=120
X25 a_n1205_n937# inv_pti VDD_3V3 VDD_3V3 pfet_06v0 ad=5.832n pd=0.291m as=21.384n ps=0.662m w=243 l=100
X26 downstepper_test pti a_n1778_n454# VSS nfet_06v0 ad=8.599n pd=0.264m as=3.528n ps=0.195m w=147 l=120
X27 a_n1778_n454# inv_nti VSS VSS nfet_06v0 ad=3.528n pd=0.195m as=14.847n ps=0.496m w=147 l=120
X28 upstepper_test inv_pti VSS VSS nfet_06v0 ad=14.432n pd=0.504m as=14.432n ps=0.504m w=164 l=120
X29 VDD_1V65 inv_pti a_n1373_n454# VSS nfet_06v0 ad=10.51n pd=0.29m as=3.528n ps=0.195m w=147 l=120
X30 downstepper_test inv_nti VDD_3V3 VDD_3V3 pfet_06v0 ad=21.384n pd=0.662m as=21.384n ps=0.662m w=243 l=100
C0 VDD_1V65 nti 0.21326f
C1 downstepper_test a_n1373_n454# 0.00442f
C2 inv_pti inv_nti 0.08248f
C3 VDD_3V3 5v0_half_adder_selector_sc_0/res_stage0 0.13661f
C4 ctrl_sign ternary_input 0.00264f
C5 pti ternary_input 0.5313f
C6 VDD_1V65 inv_pti 0.14775f
C7 VDD_3V3 inv_nti 0.59815f
C8 pti ctrl_sign 0
C9 VDD_3V3_uq0 upstepper_test 0.33323f
C10 5v0_half_adder_selector_sc_0/5v0_tgate_sel_2_sc_1/input_A ctrl_sign 0
C11 a_n1778_n454# ternary_input 0.00116f
C12 VDD_3V3_uq0 5v0_half_adder_selector_sc_0/m1_n244_n517# 0
C13 a_n1373_n454# ternary_input 0.00136f
C14 downstepper_test upstepper_test 0.38867f
C15 VDD_1V65 VDD_3V3 0.04713f
C16 VDD_3V3_uq0 5v0_half_adder_selector_sc_0/res_stage0 0.02483f
C17 5v0_half_adder_selector_sc_0/m1_n244_n517# downstepper_test 0.02897f
C18 pti a_n1778_n454# 0.00135f
C19 inv_pti nti 0.21872f
C20 downstepper_test 5v0_half_adder_selector_sc_0/res_stage0 0.25302f
C21 pti a_n1373_n454# 0
C22 ternary_output upstepper_test 0
C23 VDD_3V3_uq0 inv_nti 0.00196f
C24 5v0_half_adder_selector_sc_0/m1_n239_179# 5v0_half_adder_selector_sc_0/ctrl_over 0.00486f
C25 ternary_output 5v0_half_adder_selector_sc_0/m1_n244_n517# 0.23201f
C26 a_n1205_n937# upstepper_test 0.00334f
C27 ternary_input upstepper_test 0.02545f
C28 downstepper_test inv_nti 0.18136f
C29 VDD_3V3 nti 0.40684f
C30 ternary_output 5v0_half_adder_selector_sc_0/res_stage0 0.11993f
C31 VDD_3V3_uq0 VDD_1V65 0
C32 VDD_3V3 5v0_half_adder_selector_sc_0/ctrl_over 0.40911f
C33 5v0_half_adder_selector_sc_0/m1_n244_n517# ternary_input 0.13297f
C34 inv_pti 5v0_half_adder_selector_sc_0/m1_n239_179# 0
C35 ctrl_sign upstepper_test 0.08746f
C36 VDD_1V65 downstepper_test 0.13024f
C37 5v0_half_adder_selector_sc_0/res_stage0 a_n1205_n937# 0
C38 5v0_half_adder_selector_sc_0/res_stage0 ternary_input 0.28146f
C39 pti upstepper_test 0
C40 5v0_half_adder_selector_sc_0/5v0_tgate_sel_2_sc_1/input_A upstepper_test 0
C41 5v0_half_adder_selector_sc_0/m1_n244_n517# ctrl_sign 0.0109f
C42 VDD_3V3 inv_pti 0.16742f
C43 pti 5v0_half_adder_selector_sc_0/m1_n244_n517# 0
C44 5v0_half_adder_selector_sc_0/5v0_tgate_sel_2_sc_1/input_A 5v0_half_adder_selector_sc_0/m1_n244_n517# 0.07353f
C45 ctrl_sign 5v0_half_adder_selector_sc_0/res_stage0 0.22345f
C46 VDD_3V3 5v0_half_adder_selector_sc_0/m1_n239_179# 0.00154f
C47 a_n1778_n454# upstepper_test 0
C48 inv_nti a_n1205_n937# 0
C49 inv_nti ternary_input 0.02714f
C50 5v0_half_adder_selector_sc_0/5v0_tgate_sel_2_sc_1/input_A 5v0_half_adder_selector_sc_0/res_stage0 0.00385f
C51 a_n1373_n454# upstepper_test 0
C52 VDD_3V3_uq0 nti 0.16211f
C53 VDD_3V3_uq0 5v0_half_adder_selector_sc_0/ctrl_over 0.0015f
C54 VDD_1V65 a_n1205_n937# 0.00354f
C55 VDD_1V65 ternary_input 0.03394f
C56 downstepper_test nti 0.07077f
C57 pti inv_nti 0.10928f
C58 5v0_half_adder_selector_sc_0/ctrl_over downstepper_test 0.00206f
C59 VDD_3V3_uq0 inv_pti 0.23112f
C60 VDD_3V3_uq0 5v0_half_adder_selector_sc_0/m1_n239_179# 0.28989f
C61 a_n1778_n454# inv_nti 0.00212f
C62 VDD_1V65 pti 0.00115f
C63 inv_pti downstepper_test 0.07797f
C64 ternary_output nti 0
C65 inv_nti a_n1373_n454# 0
C66 ternary_output 5v0_half_adder_selector_sc_0/ctrl_over 0.18581f
C67 5v0_half_adder_selector_sc_0/m1_n239_179# downstepper_test 0.09961f
C68 VDD_3V3_uq0 VDD_3V3 0
C69 VDD_1V65 a_n1778_n454# 0
C70 5v0_half_adder_selector_sc_0/m1_n244_n517# upstepper_test 0.00167f
C71 a_n1205_n937# nti 0
C72 nti ternary_input 0.60908f
C73 5v0_half_adder_selector_sc_0/ctrl_over ternary_input 0.0727f
C74 VDD_3V3 downstepper_test 0.41098f
C75 VDD_1V65 a_n1373_n454# 0.00232f
C76 5v0_half_adder_selector_sc_0/res_stage0 upstepper_test 0.27475f
C77 ctrl_sign nti 0
C78 5v0_half_adder_selector_sc_0/m1_n244_n517# 5v0_half_adder_selector_sc_0/res_stage0 0.14284f
C79 ctrl_sign 5v0_half_adder_selector_sc_0/ctrl_over 0.01302f
C80 inv_pti ternary_input 0.08497f
C81 pti nti 0.17279f
C82 5v0_half_adder_selector_sc_0/5v0_tgate_sel_2_sc_1/input_A 5v0_half_adder_selector_sc_0/ctrl_over 0.01944f
C83 inv_nti upstepper_test 0
C84 5v0_half_adder_selector_sc_0/m1_n239_179# ternary_input 0.00191f
C85 VDD_3V3 ternary_output 0.15496f
C86 inv_pti ctrl_sign 0.00263f
C87 a_n1778_n454# nti 0.00123f
C88 pti inv_pti 0.19351f
C89 5v0_half_adder_selector_sc_0/m1_n239_179# ctrl_sign 0.30291f
C90 VDD_3V3 a_n1205_n937# 0.00891f
C91 VDD_3V3 ternary_input 0.15434f
C92 VDD_1V65 upstepper_test 0.16859f
C93 nti a_n1373_n454# 0
C94 VDD_3V3_uq0 downstepper_test 0.10943f
C95 VDD_1V65 5v0_half_adder_selector_sc_0/m1_n244_n517# 0
C96 VDD_3V3 ctrl_sign 0
C97 VDD_3V3 pti 0.02893f
C98 VDD_3V3 5v0_half_adder_selector_sc_0/5v0_tgate_sel_2_sc_1/input_A 0.03098f
C99 inv_pti a_n1373_n454# 0.00135f
C100 VDD_3V3_uq0 ternary_output 0
C101 ternary_output downstepper_test 0.00248f
C102 nti upstepper_test 0.11981f
C103 VDD_1V65 inv_nti 0.01095f
C104 VDD_3V3_uq0 ternary_input 0.96005f
C105 VDD_3V3 a_n1373_n454# 0.00122f
C106 5v0_half_adder_selector_sc_0/m1_n244_n517# nti 0.00226f
C107 downstepper_test a_n1205_n937# 0.00453f
C108 downstepper_test ternary_input 0.16661f
C109 5v0_half_adder_selector_sc_0/m1_n244_n517# 5v0_half_adder_selector_sc_0/ctrl_over 0.37702f
C110 VDD_3V3_uq0 ctrl_sign 0.38402f
C111 5v0_half_adder_selector_sc_0/res_stage0 nti 0.00372f
C112 inv_pti upstepper_test 0.0467f
C113 VDD_3V3_uq0 pti 0.551f
C114 5v0_half_adder_selector_sc_0/ctrl_over 5v0_half_adder_selector_sc_0/res_stage0 0.04907f
C115 ctrl_sign downstepper_test 0.14523f
C116 inv_pti 5v0_half_adder_selector_sc_0/m1_n244_n517# 0
C117 5v0_half_adder_selector_sc_0/m1_n239_179# upstepper_test 0.07502f
C118 pti downstepper_test 0.08313f
C119 5v0_half_adder_selector_sc_0/5v0_tgate_sel_2_sc_1/input_A downstepper_test 0
C120 ternary_output ternary_input 0.19159f
C121 5v0_half_adder_selector_sc_0/m1_n244_n517# 5v0_half_adder_selector_sc_0/m1_n239_179# 0.00395f
C122 inv_pti 5v0_half_adder_selector_sc_0/res_stage0 0
C123 inv_nti nti 0.20745f
C124 VDD_3V3 upstepper_test 0.13834f
C125 a_n1778_n454# downstepper_test 0.0031f
C126 5v0_half_adder_selector_sc_0/m1_n239_179# 5v0_half_adder_selector_sc_0/res_stage0 0.18379f
C127 a_n1205_n937# ternary_input 0
C128 VDD_3V3 5v0_half_adder_selector_sc_0/m1_n244_n517# 0.27028f
C129 pti VSS 0.62941f
C130 VDD_1V65 VSS 0.09232f
C131 inv_nti VSS 0.56173f
C132 inv_pti VSS 0.6002f
C133 a_n1205_n937# VSS 0 ; **FLOATING
C134 a_n1373_n454# VSS 0.00335f ; **FLOATING
C135 a_n1778_n454# VSS 0.00573f ; **FLOATING
C136 nti VSS 1.36077f
C137 5v0_half_adder_selector_sc_0/5v0_tgate_sel_2_sc_1/input_A VSS 0
C138 5v0_half_adder_selector_sc_0/ctrl_over VSS 0.571f
C139 ternary_input VSS 2.00726f
C140 ternary_output VSS 0.28152f
C141 5v0_half_adder_selector_sc_0/m1_n244_n517# VSS 0.39366f ; **FLOATING
C142 VDD_3V3 VSS 6.2849f
C143 5v0_half_adder_selector_sc_0/m1_n239_179# VSS 0.30065f ; **FLOATING
C144 5v0_half_adder_selector_sc_0/res_stage0 VSS 0.50953f
C145 downstepper_test VSS 0.64154f
C146 ctrl_sign VSS 0.56557f
C147 VDD_3V3_uq0 VSS 6.37693f
C148 upstepper_test VSS 0.54918f
