* NGSPICE file created from 5v0_add_q_sc.ext - technology: gf180mcuD

.option scale=5n

X0 pti ternary_input VSS VSS nfet_06v0 ad=6.336n pd=0.32m as=6.336n ps=0.32m w=72 l=578
X1 5v0_pti_sc_0/VDD_3V3 ternary_input pti 5v0_pti_sc_0/VDD_3V3 pfet_06v0 ad=12.81n pd=0.349m as=12.688n ps=0.348m w=244 l=100
X2 pti ternary_input 5v0_pti_sc_0/VDD_3V3 5v0_pti_sc_0/VDD_3V3 pfet_06v0 ad=12.688n pd=0.348m as=21.472n ps=0.664m w=244 l=100
X3 pti ternary_input 5v0_pti_sc_0/VDD_3V3 5v0_pti_sc_0/VDD_3V3 pfet_06v0 ad=27.328n pd=0.712m as=12.81n ps=0.349m w=244 l=100
X4 nti ternary_input VSS VSS nfet_06v0 ad=12.7n pd=0.454m as=11.303n ps=0.432m w=127 l=120
X5 nti ternary_input 5v0_pti_sc_0/VDD_3V3 5v0_pti_sc_0/VDD_3V3 pfet_06v0 ad=9.696n pd=0.394m as=8.928n ps=0.378m w=96 l=150
X6 5v0_half_adder_selector_sc_0/res_stage0 5v0_half_adder_selector_sc_0/m1_n239_179# downstepper_test VSS nfet_06v0 ad=14.432n pd=0.504m as=14.432n ps=0.504m w=164 l=120
X7 5v0_half_adder_selector_sc_0/res_stage0 5v0_half_adder_selector_sc_0/m1_n239_179# upstepper_test 5v0_pti_sc_0/VDD_3V3 pfet_06v0 ad=21.472n pd=0.664m as=21.472n ps=0.664m w=244 l=100
X8 5v0_half_adder_selector_sc_0/m1_n239_179# ctrl_sign VSS VSS nfet_06v0 ad=14.432n pd=0.504m as=14.432n ps=0.504m w=164 l=120
X9 5v0_half_adder_selector_sc_0/m1_n239_179# ctrl_sign 5v0_pti_sc_0/VDD_3V3 5v0_pti_sc_0/VDD_3V3 pfet_06v0 ad=21.472n pd=0.664m as=21.472n ps=0.664m w=244 l=100
X10 5v0_half_adder_selector_sc_0/res_stage0 ctrl_sign upstepper_test VSS nfet_06v0 ad=31.489n pd=1.041m as=43.711n ps=1.504m w=164 l=120
X11 5v0_half_adder_selector_sc_0/res_stage0 ctrl_sign downstepper_test 5v0_pti_sc_0/VDD_3V3 pfet_06v0 ad=46.849n pd=1.361m as=42.856n ps=1.326m w=244 l=100
X12 ternary_output 5v0_half_adder_selector_sc_0/ctrl_over 5v0_half_adder_selector_sc_0/res_stage0 VSS nfet_06v0 ad=17.057n pd=0.537m as=0 ps=0 w=164 l=120
X13 ternary_output 5v0_half_adder_selector_sc_0/ctrl_over ternary_input VDD_3V3 pfet_06v0 ad=25.377n pd=0.697m as=21.472n ps=0.664m w=244 l=100
X14 5v0_half_adder_selector_sc_0/m1_n244_n517# 5v0_half_adder_selector_sc_0/ctrl_over VSS VSS nfet_06v0 ad=14.432n pd=0.504m as=0.10465u ps=3.768m w=164 l=120
X15 5v0_half_adder_selector_sc_0/m1_n244_n517# 5v0_half_adder_selector_sc_0/ctrl_over VDD_3V3 VDD_3V3 pfet_06v0 ad=21.472n pd=0.664m as=85.71201n ps=2.652m w=244 l=100
X16 ternary_output 5v0_half_adder_selector_sc_0/m1_n244_n517# ternary_input VSS nfet_06v0 ad=0 pd=0 as=14.432n ps=0.504m w=164 l=120
X17 ternary_output 5v0_half_adder_selector_sc_0/m1_n244_n517# 5v0_half_adder_selector_sc_0/res_stage0 VDD_3V3 pfet_06v0 ad=0 pd=0 as=0 ps=0 w=244 l=100
X18 inv_pti pti VSS VSS nfet_06v0 ad=14.432n pd=0.504m as=14.432n ps=0.504m w=164 l=120
X19 inv_pti pti 5v0_pti_sc_0/VDD_3V3 5v0_pti_sc_0/VDD_3V3 pfet_06v0 ad=21.472n pd=0.664m as=21.472n ps=0.664m w=244 l=100
X20 inv_nti nti VSS VSS nfet_06v0 ad=14.432n pd=0.504m as=0 ps=0 w=164 l=120
X21 inv_nti nti VDD_3V3 VDD_3V3 pfet_06v0 ad=21.472n pd=0.664m as=0 ps=0 w=244 l=100
X22 a_n1373_n454# inv_nti downstepper_test VSS nfet_06v0 ad=3.528n pd=0.195m as=8.599n ps=0.264m w=147 l=120
X23 upstepper_test nti a_n1205_n937# VDD_3V3 pfet_06v0 ad=21.384n pd=0.662m as=5.832n ps=0.291m w=243 l=100
X24 upstepper_test nti VDD_1V65 VSS nfet_06v0 ad=14.847n pd=0.496m as=10.51n ps=0.29m w=147 l=120
X25 a_n1205_n937# inv_pti VDD_3V3 VDD_3V3 pfet_06v0 ad=5.832n pd=0.291m as=21.384n ps=0.662m w=243 l=100
X26 downstepper_test pti a_n1778_n454# VSS nfet_06v0 ad=8.599n pd=0.264m as=3.528n ps=0.195m w=147 l=120
X27 a_n1778_n454# inv_nti VSS VSS nfet_06v0 ad=3.528n pd=0.195m as=14.847n ps=0.496m w=147 l=120
X28 upstepper_test inv_pti VSS VSS nfet_06v0 ad=14.432n pd=0.504m as=14.432n ps=0.504m w=164 l=120
X29 VDD_1V65 inv_pti a_n1373_n454# VSS nfet_06v0 ad=10.51n pd=0.29m as=3.528n ps=0.195m w=147 l=120
X30 downstepper_test inv_nti VDD_3V3 VDD_3V3 pfet_06v0 ad=21.384n pd=0.662m as=21.384n ps=0.662m w=243 l=100
C0 VDD_1V65 inv_nti 0.01095f
C1 downstepper_test 5v0_half_adder_selector_sc_0/m1_n244_n517# 0.02897f
C2 5v0_half_adder_selector_sc_0/m1_n239_179# ctrl_sign 0.30291f
C3 ternary_output 5v0_half_adder_selector_sc_0/m1_n244_n517# 0.23201f
C4 5v0_half_adder_selector_sc_0/ctrl_over 5v0_half_adder_selector_sc_0/m1_n239_179# 0.00486f
C5 VDD_1V65 upstepper_test 0.16859f
C6 ternary_input inv_pti 0.08497f
C7 nti 5v0_half_adder_selector_sc_0/m1_n244_n517# 0.00226f
C8 ternary_input VDD_3V3 0.15434f
C9 5v0_half_adder_selector_sc_0/5v0_tgate_sel_2_sc_1/input_A upstepper_test 0
C10 a_n1205_n937# downstepper_test 0.00453f
C11 VDD_3V3 inv_pti 0.16742f
C12 5v0_pti_sc_0/VDD_3V3 5v0_half_adder_selector_sc_0/m1_n244_n517# 0
C13 ternary_output downstepper_test 0.00248f
C14 pti a_n1373_n454# 0
C15 ternary_input a_n1778_n454# 0.00116f
C16 upstepper_test 5v0_half_adder_selector_sc_0/res_stage0 0.27475f
C17 nti a_n1205_n937# 0
C18 ctrl_sign 5v0_half_adder_selector_sc_0/m1_n244_n517# 0.0109f
C19 nti downstepper_test 0.07077f
C20 5v0_half_adder_selector_sc_0/ctrl_over 5v0_half_adder_selector_sc_0/m1_n244_n517# 0.37702f
C21 nti ternary_output 0
C22 VDD_1V65 a_n1373_n454# 0.00232f
C23 ternary_input inv_nti 0.02714f
C24 pti 5v0_half_adder_selector_sc_0/m1_n244_n517# 0
C25 5v0_half_adder_selector_sc_0/m1_n239_179# 5v0_half_adder_selector_sc_0/res_stage0 0.18379f
C26 ternary_input upstepper_test 0.02545f
C27 5v0_pti_sc_0/VDD_3V3 downstepper_test 0.10943f
C28 inv_nti inv_pti 0.08248f
C29 ctrl_sign downstepper_test 0.14523f
C30 VDD_3V3 inv_nti 0.59815f
C31 VDD_1V65 5v0_half_adder_selector_sc_0/m1_n244_n517# 0
C32 5v0_half_adder_selector_sc_0/ctrl_over downstepper_test 0.00206f
C33 inv_pti upstepper_test 0.0467f
C34 nti 5v0_pti_sc_0/VDD_3V3 0.16211f
C35 5v0_half_adder_selector_sc_0/ctrl_over ternary_output 0.18581f
C36 VDD_3V3 upstepper_test 0.13834f
C37 5v0_half_adder_selector_sc_0/5v0_tgate_sel_2_sc_1/input_A 5v0_half_adder_selector_sc_0/m1_n244_n517# 0.07353f
C38 nti ctrl_sign 0
C39 ternary_input 5v0_half_adder_selector_sc_0/m1_n239_179# 0.00191f
C40 pti downstepper_test 0.08313f
C41 inv_nti a_n1778_n454# 0.00212f
C42 VDD_1V65 a_n1205_n937# 0.00354f
C43 5v0_half_adder_selector_sc_0/res_stage0 5v0_half_adder_selector_sc_0/m1_n244_n517# 0.14284f
C44 ternary_input a_n1373_n454# 0.00136f
C45 upstepper_test a_n1778_n454# 0
C46 5v0_half_adder_selector_sc_0/m1_n239_179# inv_pti 0
C47 ctrl_sign 5v0_pti_sc_0/VDD_3V3 0.38402f
C48 VDD_1V65 downstepper_test 0.13024f
C49 nti pti 0.17279f
C50 VDD_3V3 5v0_half_adder_selector_sc_0/m1_n239_179# 0.00154f
C51 5v0_half_adder_selector_sc_0/ctrl_over 5v0_pti_sc_0/VDD_3V3 0.0015f
C52 5v0_half_adder_selector_sc_0/5v0_tgate_sel_2_sc_1/input_A downstepper_test 0
C53 5v0_half_adder_selector_sc_0/ctrl_over ctrl_sign 0.01302f
C54 a_n1373_n454# inv_pti 0.00135f
C55 inv_nti upstepper_test 0
C56 nti VDD_1V65 0.21326f
C57 pti 5v0_pti_sc_0/VDD_3V3 0.551f
C58 a_n1205_n937# 5v0_half_adder_selector_sc_0/res_stage0 0
C59 VDD_3V3 a_n1373_n454# 0.00122f
C60 ternary_input 5v0_half_adder_selector_sc_0/m1_n244_n517# 0.13297f
C61 pti ctrl_sign 0
C62 5v0_half_adder_selector_sc_0/res_stage0 downstepper_test 0.25302f
C63 ternary_output 5v0_half_adder_selector_sc_0/res_stage0 0.11993f
C64 VDD_1V65 5v0_pti_sc_0/VDD_3V3 0
C65 inv_pti 5v0_half_adder_selector_sc_0/m1_n244_n517# 0
C66 nti 5v0_half_adder_selector_sc_0/res_stage0 0.00372f
C67 VDD_3V3 5v0_half_adder_selector_sc_0/m1_n244_n517# 0.27028f
C68 ternary_input a_n1205_n937# 0
C69 5v0_half_adder_selector_sc_0/m1_n239_179# upstepper_test 0.07502f
C70 5v0_half_adder_selector_sc_0/5v0_tgate_sel_2_sc_1/input_A ctrl_sign 0
C71 ternary_input downstepper_test 0.16661f
C72 a_n1373_n454# inv_nti 0
C73 ternary_input ternary_output 0.19159f
C74 5v0_half_adder_selector_sc_0/5v0_tgate_sel_2_sc_1/input_A 5v0_half_adder_selector_sc_0/ctrl_over 0.01944f
C75 VDD_1V65 pti 0.00115f
C76 5v0_pti_sc_0/VDD_3V3 5v0_half_adder_selector_sc_0/res_stage0 0.02483f
C77 a_n1373_n454# upstepper_test 0
C78 VDD_3V3 a_n1205_n937# 0.00891f
C79 ctrl_sign 5v0_half_adder_selector_sc_0/res_stage0 0.22345f
C80 ternary_input nti 0.60908f
C81 inv_pti downstepper_test 0.07797f
C82 5v0_half_adder_selector_sc_0/ctrl_over 5v0_half_adder_selector_sc_0/res_stage0 0.04907f
C83 VDD_3V3 downstepper_test 0.41098f
C84 VDD_3V3 ternary_output 0.15496f
C85 nti inv_pti 0.21872f
C86 ternary_input 5v0_pti_sc_0/VDD_3V3 0.96005f
C87 nti VDD_3V3 0.40684f
C88 upstepper_test 5v0_half_adder_selector_sc_0/m1_n244_n517# 0.00167f
C89 a_n1778_n454# downstepper_test 0.0031f
C90 ternary_input ctrl_sign 0.00264f
C91 5v0_half_adder_selector_sc_0/ctrl_over ternary_input 0.0727f
C92 5v0_pti_sc_0/VDD_3V3 inv_pti 0.23112f
C93 a_n1205_n937# inv_nti 0
C94 VDD_3V3 5v0_pti_sc_0/VDD_3V3 0
C95 nti a_n1778_n454# 0.00123f
C96 ctrl_sign inv_pti 0.00263f
C97 inv_nti downstepper_test 0.18136f
C98 a_n1205_n937# upstepper_test 0.00334f
C99 5v0_half_adder_selector_sc_0/5v0_tgate_sel_2_sc_1/input_A 5v0_half_adder_selector_sc_0/res_stage0 0.00385f
C100 ternary_input pti 0.5313f
C101 VDD_3V3 ctrl_sign 0
C102 5v0_half_adder_selector_sc_0/m1_n239_179# 5v0_half_adder_selector_sc_0/m1_n244_n517# 0.00395f
C103 5v0_half_adder_selector_sc_0/ctrl_over VDD_3V3 0.40911f
C104 upstepper_test downstepper_test 0.38867f
C105 ternary_output upstepper_test 0
C106 nti inv_nti 0.20745f
C107 ternary_input VDD_1V65 0.03394f
C108 pti inv_pti 0.19351f
C109 VDD_3V3 pti 0.02893f
C110 nti upstepper_test 0.11981f
C111 VDD_1V65 inv_pti 0.14775f
C112 inv_nti 5v0_pti_sc_0/VDD_3V3 0.00196f
C113 5v0_half_adder_selector_sc_0/m1_n239_179# downstepper_test 0.09961f
C114 VDD_3V3 VDD_1V65 0.04713f
C115 5v0_pti_sc_0/VDD_3V3 upstepper_test 0.33323f
C116 pti a_n1778_n454# 0.00135f
C117 ternary_input 5v0_half_adder_selector_sc_0/res_stage0 0.28146f
C118 5v0_half_adder_selector_sc_0/5v0_tgate_sel_2_sc_1/input_A VDD_3V3 0.03098f
C119 a_n1373_n454# downstepper_test 0.00442f
C120 ctrl_sign upstepper_test 0.08746f
C121 VDD_1V65 a_n1778_n454# 0
C122 inv_pti 5v0_half_adder_selector_sc_0/res_stage0 0
C123 pti inv_nti 0.10928f
C124 VDD_3V3 5v0_half_adder_selector_sc_0/res_stage0 0.13661f
C125 nti a_n1373_n454# 0
C126 5v0_half_adder_selector_sc_0/m1_n239_179# 5v0_pti_sc_0/VDD_3V3 0.28989f
C127 pti upstepper_test 0
C128 pti VSS 0.62941f
C129 VDD_1V65 VSS 0.09232f
C130 inv_nti VSS 0.56173f
C131 inv_pti VSS 0.6002f
C132 a_n1205_n937# VSS 0 ; **FLOATING
C133 a_n1373_n454# VSS 0.00335f ; **FLOATING
C134 a_n1778_n454# VSS 0.00573f ; **FLOATING
C135 nti VSS 1.36077f
C136 5v0_pti_sc_0/VDD_3V3 VSS 6.27264f
C137 5v0_half_adder_selector_sc_0/5v0_tgate_sel_2_sc_1/input_A VSS 0
C138 5v0_half_adder_selector_sc_0/ctrl_over VSS 0.571f
C139 ternary_input VSS 2.00726f
C140 ternary_output VSS 0.28152f
C141 5v0_half_adder_selector_sc_0/m1_n244_n517# VSS 0.39366f ; **FLOATING
C142 VDD_3V3 VSS 6.2849f
C143 5v0_half_adder_selector_sc_0/m1_n239_179# VSS 0.30065f ; **FLOATING
C144 5v0_half_adder_selector_sc_0/res_stage0 VSS 0.50953f
C145 downstepper_test VSS 0.64154f
C146 ctrl_sign VSS 0.56557f
C147 upstepper_test VSS 0.54918f
