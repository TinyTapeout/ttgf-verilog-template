* NGSPICE file created from 5v0_add_q_sc.ext - technology: gf180mcuD

.option scale=5n

X0 pti ternary_input VSS VSS nfet_06v0 ad=6.336n pd=0.32m as=6.336n ps=0.32m w=72 l=578
X1 VDD_3V3 ternary_input pti VDD_3V3 pfet_06v0 ad=12.81n pd=0.349m as=12.688n ps=0.348m w=244 l=100
X2 pti ternary_input VDD_3V3 VDD_3V3 pfet_06v0 ad=12.688n pd=0.348m as=21.472n ps=0.664m w=244 l=100
X3 pti ternary_input VDD_3V3 VDD_3V3 pfet_06v0 ad=27.328n pd=0.712m as=12.81n ps=0.349m w=244 l=100
X4 nti ternary_input VSS VSS nfet_06v0 ad=12.7n pd=0.454m as=11.303n ps=0.432m w=127 l=120
X5 nti ternary_input VDD_3V3 VDD_3V3 pfet_06v0 ad=9.696n pd=0.394m as=8.928n ps=0.378m w=96 l=150
X6 5v0_half_adder_selector_sc_0/res_stage0 5v0_half_adder_selector_sc_0/m1_n239_179# downstepper_test VSS nfet_06v0 ad=14.432n pd=0.504m as=14.432n ps=0.504m w=164 l=120
X7 5v0_half_adder_selector_sc_0/res_stage0 5v0_half_adder_selector_sc_0/m1_n239_179# upstepper_test VDD_3V3 pfet_06v0 ad=21.472n pd=0.664m as=21.472n ps=0.664m w=244 l=100
X8 5v0_half_adder_selector_sc_0/m1_n239_179# ctrl_sign VSS VSS nfet_06v0 ad=14.432n pd=0.504m as=14.432n ps=0.504m w=164 l=120
X9 5v0_half_adder_selector_sc_0/m1_n239_179# ctrl_sign VDD_3V3 VDD_3V3 pfet_06v0 ad=21.472n pd=0.664m as=21.472n ps=0.664m w=244 l=100
X10 5v0_half_adder_selector_sc_0/res_stage0 ctrl_sign upstepper_test VSS nfet_06v0 ad=31.489n pd=1.041m as=43.711n ps=1.504m w=164 l=120
X11 5v0_half_adder_selector_sc_0/res_stage0 ctrl_sign downstepper_test VDD_3V3 pfet_06v0 ad=46.849n pd=1.361m as=42.856n ps=1.326m w=244 l=100
X12 ternary_output 5v0_half_adder_selector_sc_0/ctrl_over 5v0_half_adder_selector_sc_0/res_stage0 VSS nfet_06v0 ad=17.057n pd=0.537m as=0 ps=0 w=164 l=120
X13 ternary_output 5v0_half_adder_selector_sc_0/ctrl_over ternary_input VDD_3V3_uq0 pfet_06v0 ad=25.377n pd=0.697m as=21.472n ps=0.664m w=244 l=100
X14 5v0_half_adder_selector_sc_0/m1_n244_n517# 5v0_half_adder_selector_sc_0/ctrl_over VSS VSS nfet_06v0 ad=14.432n pd=0.504m as=0.10465u ps=3.768m w=164 l=120
X15 5v0_half_adder_selector_sc_0/m1_n244_n517# 5v0_half_adder_selector_sc_0/ctrl_over VDD_3V3_uq0 VDD_3V3_uq0 pfet_06v0 ad=21.472n pd=0.664m as=85.71201n ps=2.652m w=244 l=100
X16 ternary_output 5v0_half_adder_selector_sc_0/m1_n244_n517# ternary_input VSS nfet_06v0 ad=0 pd=0 as=14.432n ps=0.504m w=164 l=120
X17 ternary_output 5v0_half_adder_selector_sc_0/m1_n244_n517# 5v0_half_adder_selector_sc_0/res_stage0 VDD_3V3_uq0 pfet_06v0 ad=0 pd=0 as=0 ps=0 w=244 l=100
X18 a_n1325_n547# pti VSS VSS nfet_06v0 ad=14.432n pd=0.504m as=14.432n ps=0.504m w=164 l=120
X19 a_n1325_n547# pti VDD_3V3 VDD_3V3 pfet_06v0 ad=21.472n pd=0.664m as=21.472n ps=0.664m w=244 l=100
X20 a_n1898_n981# nti VSS VSS nfet_06v0 ad=14.432n pd=0.504m as=0 ps=0 w=164 l=120
X21 a_n1898_n981# nti VDD_3V3_uq0 VDD_3V3_uq0 pfet_06v0 ad=21.472n pd=0.664m as=0 ps=0 w=244 l=100
X22 a_n1373_n454# a_n1898_n981# downstepper_test VSS nfet_06v0 ad=3.528n pd=0.195m as=8.599n ps=0.264m w=147 l=120
X23 upstepper_test nti a_n1205_n937# VDD_3V3_uq0 pfet_06v0 ad=21.384n pd=0.662m as=5.832n ps=0.291m w=243 l=100
X24 upstepper_test nti VDD_1V65 VSS nfet_06v0 ad=14.847n pd=0.496m as=10.51n ps=0.29m w=147 l=120
X25 a_n1205_n937# a_n1325_n547# VDD_3V3_uq0 VDD_3V3_uq0 pfet_06v0 ad=5.832n pd=0.291m as=21.384n ps=0.662m w=243 l=100
X26 downstepper_test pti a_n1778_n454# VSS nfet_06v0 ad=8.599n pd=0.264m as=3.528n ps=0.195m w=147 l=120
X27 a_n1778_n454# a_n1898_n981# VSS VSS nfet_06v0 ad=3.528n pd=0.195m as=14.847n ps=0.496m w=147 l=120
X28 upstepper_test a_n1325_n547# VSS VSS nfet_06v0 ad=14.432n pd=0.504m as=14.432n ps=0.504m w=164 l=120
X29 VDD_1V65 a_n1325_n547# a_n1373_n454# VSS nfet_06v0 ad=10.51n pd=0.29m as=3.528n ps=0.195m w=147 l=120
X30 downstepper_test a_n1898_n981# VDD_3V3_uq0 VDD_3V3_uq0 pfet_06v0 ad=21.384n pd=0.662m as=21.384n ps=0.662m w=243 l=100
C0 5v0_half_adder_selector_sc_0/m1_n244_n517# ternary_input 0.13297f
C1 downstepper_test pti 0.08313f
C2 a_n1325_n547# VDD_3V3_uq0 0.16742f
C3 ternary_input 5v0_half_adder_selector_sc_0/ctrl_over 0.0727f
C4 nti VDD_3V3 0.16211f
C5 a_n1205_n937# ternary_input 0
C6 pti ctrl_sign 0
C7 5v0_half_adder_selector_sc_0/m1_n239_179# 5v0_half_adder_selector_sc_0/m1_n244_n517# 0.00395f
C8 a_n1898_n981# VDD_3V3 0.00196f
C9 a_n1778_n454# ternary_input 0.00116f
C10 5v0_half_adder_selector_sc_0/m1_n239_179# 5v0_half_adder_selector_sc_0/ctrl_over 0.00486f
C11 VDD_1V65 nti 0.21326f
C12 downstepper_test VDD_3V3 0.10943f
C13 5v0_half_adder_selector_sc_0/res_stage0 VDD_3V3 0.02483f
C14 VDD_1V65 a_n1898_n981# 0.01095f
C15 ctrl_sign VDD_3V3 0.38402f
C16 pti 5v0_half_adder_selector_sc_0/m1_n244_n517# 0
C17 downstepper_test VDD_1V65 0.13024f
C18 a_n1778_n454# pti 0.00135f
C19 a_n1373_n454# upstepper_test 0
C20 5v0_half_adder_selector_sc_0/m1_n244_n517# VDD_3V3 0
C21 VDD_3V3 5v0_half_adder_selector_sc_0/ctrl_over 0.0015f
C22 upstepper_test a_n1325_n547# 0.0467f
C23 VDD_1V65 5v0_half_adder_selector_sc_0/m1_n244_n517# 0
C24 VDD_1V65 a_n1205_n937# 0.00354f
C25 upstepper_test VDD_3V3_uq0 0.13834f
C26 a_n1778_n454# VDD_1V65 0
C27 a_n1373_n454# ternary_input 0.00136f
C28 ternary_output nti 0
C29 a_n1325_n547# ternary_input 0.08497f
C30 a_n1898_n981# nti 0.20745f
C31 downstepper_test ternary_output 0.00248f
C32 5v0_half_adder_selector_sc_0/res_stage0 ternary_output 0.11993f
C33 5v0_half_adder_selector_sc_0/m1_n239_179# a_n1325_n547# 0
C34 downstepper_test nti 0.07077f
C35 5v0_half_adder_selector_sc_0/res_stage0 nti 0.00372f
C36 downstepper_test a_n1898_n981# 0.18136f
C37 ctrl_sign nti 0
C38 VDD_3V3_uq0 ternary_input 0.15434f
C39 a_n1373_n454# pti 0
C40 5v0_half_adder_selector_sc_0/m1_n239_179# VDD_3V3_uq0 0.00154f
C41 5v0_half_adder_selector_sc_0/res_stage0 downstepper_test 0.25302f
C42 a_n1325_n547# pti 0.19351f
C43 downstepper_test ctrl_sign 0.14523f
C44 5v0_half_adder_selector_sc_0/res_stage0 ctrl_sign 0.22345f
C45 ternary_output 5v0_half_adder_selector_sc_0/m1_n244_n517# 0.23201f
C46 5v0_half_adder_selector_sc_0/5v0_tgate_sel_2_sc_1/input_A downstepper_test 0
C47 5v0_half_adder_selector_sc_0/5v0_tgate_sel_2_sc_1/input_A 5v0_half_adder_selector_sc_0/res_stage0 0.00385f
C48 5v0_half_adder_selector_sc_0/m1_n244_n517# nti 0.00226f
C49 ternary_output 5v0_half_adder_selector_sc_0/ctrl_over 0.18581f
C50 5v0_half_adder_selector_sc_0/5v0_tgate_sel_2_sc_1/input_A ctrl_sign 0
C51 a_n1205_n937# nti 0
C52 pti VDD_3V3_uq0 0.02893f
C53 a_n1325_n547# VDD_3V3 0.23112f
C54 a_n1778_n454# nti 0.00123f
C55 a_n1205_n937# a_n1898_n981# 0
C56 a_n1373_n454# VDD_1V65 0.00232f
C57 downstepper_test 5v0_half_adder_selector_sc_0/m1_n244_n517# 0.02897f
C58 5v0_half_adder_selector_sc_0/res_stage0 5v0_half_adder_selector_sc_0/m1_n244_n517# 0.14284f
C59 a_n1778_n454# a_n1898_n981# 0.00212f
C60 downstepper_test 5v0_half_adder_selector_sc_0/ctrl_over 0.00206f
C61 5v0_half_adder_selector_sc_0/m1_n244_n517# ctrl_sign 0.0109f
C62 5v0_half_adder_selector_sc_0/res_stage0 5v0_half_adder_selector_sc_0/ctrl_over 0.04907f
C63 downstepper_test a_n1205_n937# 0.00453f
C64 5v0_half_adder_selector_sc_0/5v0_tgate_sel_2_sc_1/input_A 5v0_half_adder_selector_sc_0/m1_n244_n517# 0.07353f
C65 a_n1325_n547# VDD_1V65 0.14775f
C66 5v0_half_adder_selector_sc_0/res_stage0 a_n1205_n937# 0
C67 ctrl_sign 5v0_half_adder_selector_sc_0/ctrl_over 0.01302f
C68 VDD_3V3_uq0 VDD_3V3 0
C69 a_n1778_n454# downstepper_test 0.0031f
C70 5v0_half_adder_selector_sc_0/5v0_tgate_sel_2_sc_1/input_A 5v0_half_adder_selector_sc_0/ctrl_over 0.01944f
C71 upstepper_test ternary_input 0.02545f
C72 VDD_1V65 VDD_3V3_uq0 0.04713f
C73 5v0_half_adder_selector_sc_0/m1_n239_179# upstepper_test 0.07502f
C74 5v0_half_adder_selector_sc_0/m1_n244_n517# 5v0_half_adder_selector_sc_0/ctrl_over 0.37702f
C75 upstepper_test pti 0
C76 5v0_half_adder_selector_sc_0/m1_n239_179# ternary_input 0.00191f
C77 a_n1373_n454# nti 0
C78 upstepper_test VDD_3V3 0.33323f
C79 a_n1373_n454# a_n1898_n981# 0
C80 a_n1325_n547# nti 0.21872f
C81 pti ternary_input 0.5313f
C82 upstepper_test VDD_1V65 0.16859f
C83 a_n1325_n547# a_n1898_n981# 0.08248f
C84 a_n1373_n454# downstepper_test 0.00442f
C85 ternary_output VDD_3V3_uq0 0.15496f
C86 downstepper_test a_n1325_n547# 0.07797f
C87 5v0_half_adder_selector_sc_0/res_stage0 a_n1325_n547# 0
C88 VDD_3V3_uq0 nti 0.40684f
C89 a_n1325_n547# ctrl_sign 0.00263f
C90 a_n1898_n981# VDD_3V3_uq0 0.59815f
C91 ternary_input VDD_3V3 0.96005f
C92 downstepper_test VDD_3V3_uq0 0.41098f
C93 5v0_half_adder_selector_sc_0/res_stage0 VDD_3V3_uq0 0.13661f
C94 5v0_half_adder_selector_sc_0/m1_n239_179# VDD_3V3 0.28989f
C95 VDD_1V65 ternary_input 0.03394f
C96 VDD_3V3_uq0 ctrl_sign 0
C97 5v0_half_adder_selector_sc_0/5v0_tgate_sel_2_sc_1/input_A VDD_3V3_uq0 0.03098f
C98 a_n1325_n547# 5v0_half_adder_selector_sc_0/m1_n244_n517# 0
C99 pti VDD_3V3 0.551f
C100 5v0_half_adder_selector_sc_0/m1_n244_n517# VDD_3V3_uq0 0.27028f
C101 upstepper_test ternary_output 0
C102 VDD_3V3_uq0 5v0_half_adder_selector_sc_0/ctrl_over 0.40911f
C103 VDD_1V65 pti 0.00115f
C104 a_n1205_n937# VDD_3V3_uq0 0.00891f
C105 upstepper_test nti 0.11981f
C106 upstepper_test a_n1898_n981# 0
C107 upstepper_test downstepper_test 0.38867f
C108 VDD_1V65 VDD_3V3 0
C109 5v0_half_adder_selector_sc_0/res_stage0 upstepper_test 0.27475f
C110 upstepper_test ctrl_sign 0.08746f
C111 5v0_half_adder_selector_sc_0/5v0_tgate_sel_2_sc_1/input_A upstepper_test 0
C112 ternary_output ternary_input 0.19159f
C113 nti ternary_input 0.60908f
C114 a_n1898_n981# ternary_input 0.02714f
C115 upstepper_test 5v0_half_adder_selector_sc_0/m1_n244_n517# 0.00167f
C116 downstepper_test ternary_input 0.16661f
C117 5v0_half_adder_selector_sc_0/res_stage0 ternary_input 0.28146f
C118 upstepper_test a_n1205_n937# 0.00334f
C119 a_n1373_n454# a_n1325_n547# 0.00135f
C120 ctrl_sign ternary_input 0.00264f
C121 a_n1778_n454# upstepper_test 0
C122 5v0_half_adder_selector_sc_0/m1_n239_179# downstepper_test 0.09961f
C123 5v0_half_adder_selector_sc_0/res_stage0 5v0_half_adder_selector_sc_0/m1_n239_179# 0.18379f
C124 pti nti 0.17279f
C125 5v0_half_adder_selector_sc_0/m1_n239_179# ctrl_sign 0.30291f
C126 a_n1898_n981# pti 0.10928f
C127 a_n1373_n454# VDD_3V3_uq0 0.00122f
C128 pti VSS 0.62941f
C129 VDD_1V65 VSS 0.09232f
C130 a_n1205_n937# VSS 0 ; **FLOATING
C131 a_n1373_n454# VSS 0.00335f ; **FLOATING
C132 a_n1778_n454# VSS 0.00573f ; **FLOATING
C133 a_n1898_n981# VSS 0.56173f ; **FLOATING
C134 a_n1325_n547# VSS 0.6002f ; **FLOATING
C135 nti VSS 1.36076f
C136 VDD_3V3 VSS 6.27328f
C137 5v0_half_adder_selector_sc_0/5v0_tgate_sel_2_sc_1/input_A VSS 0
C138 5v0_half_adder_selector_sc_0/ctrl_over VSS 0.571f
C139 ternary_input VSS 2.00726f
C140 ternary_output VSS 0.28152f
C141 5v0_half_adder_selector_sc_0/m1_n244_n517# VSS 0.39366f ; **FLOATING
C142 VDD_3V3_uq0 VSS 6.28492f
C143 5v0_half_adder_selector_sc_0/m1_n239_179# VSS 0.30065f ; **FLOATING
C144 5v0_half_adder_selector_sc_0/res_stage0 VSS 0.50953f
C145 downstepper_test VSS 0.64154f
C146 ctrl_sign VSS 0.56557f
C147 upstepper_test VSS 0.54918f
