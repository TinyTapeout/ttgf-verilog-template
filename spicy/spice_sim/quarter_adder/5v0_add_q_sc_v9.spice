* NGSPICE file created from 5v0_add_q_sc.ext - technology: gf180mcuD

.option scale=5n

X0 pti ternary_input VSS VSS nfet_06v0 ad=6.336n pd=0.32m as=6.336n ps=0.32m w=72 l=578
X1 VDD_3V3_uq0 ternary_input pti VDD_3V3_uq0 pfet_06v0 ad=12.81n pd=0.349m as=12.688n ps=0.348m w=244 l=100
X2 pti ternary_input VDD_3V3_uq0 VDD_3V3_uq0 pfet_06v0 ad=12.688n pd=0.348m as=21.472n ps=0.664m w=244 l=100
X3 pti ternary_input VDD_3V3_uq0 VDD_3V3_uq0 pfet_06v0 ad=27.328n pd=0.712m as=12.81n ps=0.349m w=244 l=100
X4 nti ternary_input VSS VSS nfet_06v0 ad=12.7n pd=0.454m as=11.303n ps=0.432m w=127 l=120
X5 nti ternary_input VDD_3V3_uq0 VDD_3V3_uq0 pfet_06v0 ad=9.696n pd=0.394m as=8.928n ps=0.378m w=96 l=150
X6 5v0_half_adder_selector_sc_0/res_stage0 5v0_half_adder_selector_sc_0/m1_n239_179# downstepper_test VSS nfet_06v0 ad=14.432n pd=0.504m as=14.432n ps=0.504m w=164 l=120
X7 5v0_half_adder_selector_sc_0/res_stage0 5v0_half_adder_selector_sc_0/m1_n239_179# upstepper_test VDD_3V3_uq0 pfet_06v0 ad=21.472n pd=0.664m as=21.472n ps=0.664m w=244 l=100
X8 5v0_half_adder_selector_sc_0/m1_n239_179# ctrl_sign VSS VSS nfet_06v0 ad=14.432n pd=0.504m as=14.432n ps=0.504m w=164 l=120
X9 5v0_half_adder_selector_sc_0/m1_n239_179# ctrl_sign VDD_3V3_uq0 VDD_3V3_uq0 pfet_06v0 ad=21.472n pd=0.664m as=21.472n ps=0.664m w=244 l=100
X10 5v0_half_adder_selector_sc_0/res_stage0 ctrl_sign upstepper_test VSS nfet_06v0 ad=31.489n pd=1.041m as=43.711n ps=1.504m w=164 l=120
X11 5v0_half_adder_selector_sc_0/res_stage0 ctrl_sign downstepper_test VDD_3V3_uq0 pfet_06v0 ad=46.849n pd=1.361m as=42.856n ps=1.326m w=244 l=100
X12 ternary_output 5v0_half_adder_selector_sc_0/ctrl_over 5v0_half_adder_selector_sc_0/res_stage0 VSS nfet_06v0 ad=17.057n pd=0.537m as=0 ps=0 w=164 l=120
X13 ternary_output 5v0_half_adder_selector_sc_0/ctrl_over ternary_input VDD_3V3 pfet_06v0 ad=25.377n pd=0.697m as=21.472n ps=0.664m w=244 l=100
X14 5v0_half_adder_selector_sc_0/m1_n244_n517# 5v0_half_adder_selector_sc_0/ctrl_over VSS VSS nfet_06v0 ad=14.432n pd=0.504m as=0.10465u ps=3.768m w=164 l=120
X15 5v0_half_adder_selector_sc_0/m1_n244_n517# 5v0_half_adder_selector_sc_0/ctrl_over VDD_3V3 VDD_3V3 pfet_06v0 ad=21.472n pd=0.664m as=85.71201n ps=2.652m w=244 l=100
X16 ternary_output 5v0_half_adder_selector_sc_0/m1_n244_n517# ternary_input VSS nfet_06v0 ad=0 pd=0 as=14.432n ps=0.504m w=164 l=120
X17 ternary_output 5v0_half_adder_selector_sc_0/m1_n244_n517# 5v0_half_adder_selector_sc_0/res_stage0 VDD_3V3 pfet_06v0 ad=0 pd=0 as=0 ps=0 w=244 l=100
X18 a_n1325_n547# pti VSS VSS nfet_06v0 ad=14.432n pd=0.504m as=14.432n ps=0.504m w=164 l=120
X19 a_n1325_n547# pti VDD_3V3_uq0 VDD_3V3_uq0 pfet_06v0 ad=21.472n pd=0.664m as=21.472n ps=0.664m w=244 l=100
X20 a_n1898_n981# nti VSS VSS nfet_06v0 ad=14.432n pd=0.504m as=0 ps=0 w=164 l=120
X21 a_n1898_n981# nti VDD_3V3 VDD_3V3 pfet_06v0 ad=21.472n pd=0.664m as=0 ps=0 w=244 l=100
X22 a_n1373_n454# a_n1898_n981# downstepper_test VSS nfet_06v0 ad=3.528n pd=0.195m as=8.599n ps=0.264m w=147 l=120
X23 upstepper_test nti a_n1205_n937# VDD_3V3 pfet_06v0 ad=21.384n pd=0.662m as=5.832n ps=0.291m w=243 l=100
X24 upstepper_test nti VDD_1V65 VSS nfet_06v0 ad=14.847n pd=0.496m as=10.51n ps=0.29m w=147 l=120
X25 a_n1205_n937# a_n1325_n547# VDD_3V3 VDD_3V3 pfet_06v0 ad=5.832n pd=0.291m as=21.384n ps=0.662m w=243 l=100
X26 downstepper_test pti a_n1778_n454# VSS nfet_06v0 ad=8.599n pd=0.264m as=3.528n ps=0.195m w=147 l=120
X27 a_n1778_n454# a_n1898_n981# VSS VSS nfet_06v0 ad=3.528n pd=0.195m as=14.847n ps=0.496m w=147 l=120
X28 upstepper_test a_n1325_n547# VSS VSS nfet_06v0 ad=14.432n pd=0.504m as=14.432n ps=0.504m w=164 l=120
X29 VDD_1V65 a_n1325_n547# a_n1373_n454# VSS nfet_06v0 ad=10.51n pd=0.29m as=3.528n ps=0.195m w=147 l=120
X30 downstepper_test a_n1898_n981# VDD_3V3 VDD_3V3 pfet_06v0 ad=21.384n pd=0.662m as=21.384n ps=0.662m w=243 l=100
C0 a_n1898_n981# a_n1205_n937# 0
C1 ternary_input downstepper_test 0.16661f
C2 VDD_1V65 pti 0.00115f
C3 nti 5v0_half_adder_selector_sc_0/res_stage0 0.00372f
C4 5v0_half_adder_selector_sc_0/res_stage0 ternary_output 0.11993f
C5 a_n1325_n547# VDD_3V3 0.16742f
C6 5v0_half_adder_selector_sc_0/5v0_tgate_sel_2_sc_1/input_A VDD_3V3 0.03098f
C7 VDD_1V65 a_n1205_n937# 0.00354f
C8 a_n1373_n454# a_n1898_n981# 0
C9 VDD_3V3_uq0 pti 0.551f
C10 upstepper_test VDD_3V3 0.13834f
C11 5v0_half_adder_selector_sc_0/m1_n239_179# VDD_3V3_uq0 0.28989f
C12 5v0_half_adder_selector_sc_0/m1_n244_n517# VDD_1V65 0
C13 5v0_half_adder_selector_sc_0/m1_n239_179# 5v0_half_adder_selector_sc_0/ctrl_over 0.00486f
C14 ctrl_sign VDD_3V3 0
C15 upstepper_test a_n1778_n454# 0
C16 a_n1373_n454# VDD_1V65 0.00232f
C17 5v0_half_adder_selector_sc_0/m1_n244_n517# VDD_3V3_uq0 0
C18 a_n1325_n547# nti 0.21872f
C19 5v0_half_adder_selector_sc_0/m1_n244_n517# 5v0_half_adder_selector_sc_0/ctrl_over 0.37702f
C20 a_n1898_n981# VDD_3V3 0.59815f
C21 5v0_half_adder_selector_sc_0/res_stage0 downstepper_test 0.25302f
C22 upstepper_test nti 0.11981f
C23 upstepper_test ternary_output 0
C24 a_n1898_n981# a_n1778_n454# 0.00212f
C25 ctrl_sign nti 0
C26 VDD_1V65 VDD_3V3 0.04713f
C27 5v0_half_adder_selector_sc_0/res_stage0 ternary_input 0.28146f
C28 5v0_half_adder_selector_sc_0/m1_n244_n517# pti 0
C29 VDD_1V65 a_n1778_n454# 0
C30 5v0_half_adder_selector_sc_0/m1_n244_n517# 5v0_half_adder_selector_sc_0/m1_n239_179# 0.00395f
C31 VDD_3V3_uq0 VDD_3V3 0
C32 nti a_n1898_n981# 0.20745f
C33 a_n1373_n454# pti 0
C34 5v0_half_adder_selector_sc_0/ctrl_over VDD_3V3 0.40911f
C35 a_n1325_n547# downstepper_test 0.07797f
C36 5v0_half_adder_selector_sc_0/5v0_tgate_sel_2_sc_1/input_A downstepper_test 0
C37 upstepper_test downstepper_test 0.38867f
C38 nti VDD_1V65 0.21326f
C39 ctrl_sign downstepper_test 0.14523f
C40 a_n1325_n547# ternary_input 0.08497f
C41 nti VDD_3V3_uq0 0.16211f
C42 VDD_3V3_uq0 ternary_output 0
C43 pti VDD_3V3 0.02893f
C44 upstepper_test ternary_input 0.02545f
C45 5v0_half_adder_selector_sc_0/m1_n239_179# VDD_3V3 0.00154f
C46 ternary_output 5v0_half_adder_selector_sc_0/ctrl_over 0.18581f
C47 pti a_n1778_n454# 0.00135f
C48 ctrl_sign ternary_input 0.00264f
C49 a_n1898_n981# downstepper_test 0.18136f
C50 VDD_3V3 a_n1205_n937# 0.00891f
C51 5v0_half_adder_selector_sc_0/m1_n244_n517# VDD_3V3 0.27028f
C52 VDD_1V65 downstepper_test 0.13024f
C53 a_n1373_n454# VDD_3V3 0.00122f
C54 nti pti 0.17279f
C55 a_n1898_n981# ternary_input 0.02714f
C56 VDD_3V3_uq0 downstepper_test 0.10943f
C57 nti a_n1205_n937# 0
C58 a_n1325_n547# 5v0_half_adder_selector_sc_0/res_stage0 0
C59 5v0_half_adder_selector_sc_0/res_stage0 5v0_half_adder_selector_sc_0/5v0_tgate_sel_2_sc_1/input_A 0.00385f
C60 5v0_half_adder_selector_sc_0/ctrl_over downstepper_test 0.00206f
C61 VDD_1V65 ternary_input 0.03394f
C62 upstepper_test 5v0_half_adder_selector_sc_0/res_stage0 0.27475f
C63 5v0_half_adder_selector_sc_0/m1_n244_n517# nti 0.00226f
C64 5v0_half_adder_selector_sc_0/m1_n244_n517# ternary_output 0.23201f
C65 ctrl_sign 5v0_half_adder_selector_sc_0/res_stage0 0.22345f
C66 nti a_n1373_n454# 0
C67 VDD_3V3_uq0 ternary_input 0.96005f
C68 ternary_input 5v0_half_adder_selector_sc_0/ctrl_over 0.0727f
C69 pti downstepper_test 0.08313f
C70 5v0_half_adder_selector_sc_0/m1_n239_179# downstepper_test 0.09961f
C71 downstepper_test a_n1205_n937# 0.00453f
C72 upstepper_test a_n1325_n547# 0.0467f
C73 upstepper_test 5v0_half_adder_selector_sc_0/5v0_tgate_sel_2_sc_1/input_A 0
C74 nti VDD_3V3 0.40684f
C75 ctrl_sign a_n1325_n547# 0.00263f
C76 ctrl_sign 5v0_half_adder_selector_sc_0/5v0_tgate_sel_2_sc_1/input_A 0
C77 pti ternary_input 0.5313f
C78 ternary_output VDD_3V3 0.15496f
C79 5v0_half_adder_selector_sc_0/m1_n244_n517# downstepper_test 0.02897f
C80 nti a_n1778_n454# 0.00123f
C81 5v0_half_adder_selector_sc_0/m1_n239_179# ternary_input 0.00191f
C82 upstepper_test ctrl_sign 0.08746f
C83 a_n1373_n454# downstepper_test 0.00442f
C84 ternary_input a_n1205_n937# 0
C85 VDD_3V3_uq0 5v0_half_adder_selector_sc_0/res_stage0 0.02483f
C86 5v0_half_adder_selector_sc_0/res_stage0 5v0_half_adder_selector_sc_0/ctrl_over 0.04907f
C87 a_n1325_n547# a_n1898_n981# 0.08248f
C88 5v0_half_adder_selector_sc_0/m1_n244_n517# ternary_input 0.13297f
C89 upstepper_test a_n1898_n981# 0
C90 a_n1373_n454# ternary_input 0.00136f
C91 nti ternary_output 0
C92 a_n1325_n547# VDD_1V65 0.14775f
C93 VDD_3V3 downstepper_test 0.41098f
C94 upstepper_test VDD_1V65 0.16859f
C95 downstepper_test a_n1778_n454# 0.0031f
C96 a_n1325_n547# VDD_3V3_uq0 0.23112f
C97 5v0_half_adder_selector_sc_0/m1_n239_179# 5v0_half_adder_selector_sc_0/res_stage0 0.18379f
C98 5v0_half_adder_selector_sc_0/5v0_tgate_sel_2_sc_1/input_A 5v0_half_adder_selector_sc_0/ctrl_over 0.01944f
C99 5v0_half_adder_selector_sc_0/res_stage0 a_n1205_n937# 0
C100 upstepper_test VDD_3V3_uq0 0.33323f
C101 ternary_input VDD_3V3 0.15434f
C102 ctrl_sign VDD_3V3_uq0 0.38402f
C103 5v0_half_adder_selector_sc_0/m1_n244_n517# 5v0_half_adder_selector_sc_0/res_stage0 0.14284f
C104 ternary_input a_n1778_n454# 0.00116f
C105 ctrl_sign 5v0_half_adder_selector_sc_0/ctrl_over 0.01302f
C106 nti downstepper_test 0.07077f
C107 VDD_1V65 a_n1898_n981# 0.01095f
C108 ternary_output downstepper_test 0.00248f
C109 a_n1325_n547# pti 0.19351f
C110 VDD_3V3_uq0 a_n1898_n981# 0.00196f
C111 5v0_half_adder_selector_sc_0/m1_n239_179# a_n1325_n547# 0
C112 upstepper_test pti 0
C113 nti ternary_input 0.60908f
C114 ternary_input ternary_output 0.19159f
C115 5v0_half_adder_selector_sc_0/m1_n239_179# upstepper_test 0.07502f
C116 ctrl_sign pti 0
C117 VDD_3V3_uq0 VDD_1V65 0
C118 upstepper_test a_n1205_n937# 0.00334f
C119 5v0_half_adder_selector_sc_0/m1_n239_179# ctrl_sign 0.30291f
C120 5v0_half_adder_selector_sc_0/m1_n244_n517# a_n1325_n547# 0
C121 5v0_half_adder_selector_sc_0/m1_n244_n517# 5v0_half_adder_selector_sc_0/5v0_tgate_sel_2_sc_1/input_A 0.07353f
C122 5v0_half_adder_selector_sc_0/res_stage0 VDD_3V3 0.13661f
C123 5v0_half_adder_selector_sc_0/m1_n244_n517# upstepper_test 0.00167f
C124 a_n1325_n547# a_n1373_n454# 0.00135f
C125 pti a_n1898_n981# 0.10928f
C126 5v0_half_adder_selector_sc_0/m1_n244_n517# ctrl_sign 0.0109f
C127 VDD_3V3_uq0 5v0_half_adder_selector_sc_0/ctrl_over 0.0015f
C128 upstepper_test a_n1373_n454# 0
C129 pti VSS 0.62941f
C130 VDD_1V65 VSS 0.09232f
C131 a_n1205_n937# VSS 0 ; **FLOATING
C132 a_n1373_n454# VSS 0.00335f ; **FLOATING
C133 a_n1778_n454# VSS 0.00573f ; **FLOATING
C134 a_n1898_n981# VSS 0.56173f ; **FLOATING
C135 a_n1325_n547# VSS 0.6002f ; **FLOATING
C136 nti VSS 1.36076f
C137 5v0_half_adder_selector_sc_0/5v0_tgate_sel_2_sc_1/input_A VSS 0
C138 5v0_half_adder_selector_sc_0/ctrl_over VSS 0.571f
C139 ternary_input VSS 2.00726f
C140 ternary_output VSS 0.28152f
C141 5v0_half_adder_selector_sc_0/m1_n244_n517# VSS 0.39366f ; **FLOATING
C142 VDD_3V3 VSS 6.2849f
C143 5v0_half_adder_selector_sc_0/m1_n239_179# VSS 0.30065f ; **FLOATING
C144 5v0_half_adder_selector_sc_0/res_stage0 VSS 0.50953f
C145 downstepper_test VSS 0.64154f
C146 ctrl_sign VSS 0.56557f
C147 VDD_3V3_uq0 VSS 6.37693f
C148 upstepper_test VSS 0.54918f
