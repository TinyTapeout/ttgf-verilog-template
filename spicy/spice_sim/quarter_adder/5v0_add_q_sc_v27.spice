* NGSPICE file created from 5v0_add_q_sc.ext - technology: gf180mcuD

.option scale=5n

X0 pti ternary_input VSS VSS nfet_06v0 ad=6.336n pd=0.32m as=6.478n ps=0.255m w=72 l=578
X1 VDD_3V3_uq0 ternary_input pti VDD_3V3_uq0 pfet_06v0 ad=12.81n pd=0.349m as=12.688n ps=0.348m w=244 l=100
X2 VDD_3V3_uq0 ternary_input 5v0_pti_sc_0/nti VDD_3V3_uq0 pfet_06v0 ad=13.616n pd=0.392m as=9.696n ps=0.394m w=96 l=150
X3 VSS ternary_input 5v0_pti_sc_0/nti VSS nfet_06v0 ad=6.478n pd=0.255m as=12.7n ps=0.454m w=127 l=120
X4 pti ternary_input VDD_3V3_uq0 VDD_3V3_uq0 pfet_06v0 ad=12.688n pd=0.348m as=13.616n ps=0.392m w=244 l=100
X5 pti ternary_input VDD_3V3_uq0 VDD_3V3_uq0 pfet_06v0 ad=27.328n pd=0.712m as=12.81n ps=0.349m w=244 l=100
X6 5v0_half_adder_selector_sc_0/res_stage0 5v0_half_adder_selector_sc_0/m1_n239_179# downstepper_test VSS nfet_06v0 ad=14.432n pd=0.504m as=14.432n ps=0.504m w=164 l=120
X7 5v0_half_adder_selector_sc_0/res_stage0 5v0_half_adder_selector_sc_0/m1_n239_179# upstepper_test VDD_3V3_uq0 pfet_06v0 ad=21.472n pd=0.664m as=21.472n ps=0.664m w=244 l=100
X8 5v0_half_adder_selector_sc_0/m1_n239_179# ctrl_sign VSS VSS nfet_06v0 ad=14.432n pd=0.504m as=14.432n ps=0.504m w=164 l=120
X9 5v0_half_adder_selector_sc_0/m1_n239_179# ctrl_sign VDD_3V3_uq0 VDD_3V3_uq0 pfet_06v0 ad=21.472n pd=0.664m as=21.472n ps=0.664m w=244 l=100
X10 5v0_half_adder_selector_sc_0/res_stage0 ctrl_sign upstepper_test VSS nfet_06v0 ad=31.489n pd=1.041m as=43.711n ps=1.504m w=164 l=120
X11 5v0_half_adder_selector_sc_0/res_stage0 ctrl_sign downstepper_test VDD_3V3_uq0 pfet_06v0 ad=46.849n pd=1.361m as=42.856n ps=1.326m w=244 l=100
X12 ternary_output ctrl_over 5v0_half_adder_selector_sc_0/res_stage0 VSS nfet_06v0 ad=17.057n pd=0.537m as=0 ps=0 w=164 l=120
X13 ternary_output ctrl_over ternary_input VDD_3V3 pfet_06v0 ad=25.377n pd=0.697m as=21.472n ps=0.664m w=244 l=100
X14 5v0_half_adder_selector_sc_0/m1_n244_n517# ctrl_over VSS VSS nfet_06v0 ad=14.432n pd=0.504m as=99.96301n ps=3.526m w=164 l=120
X15 5v0_half_adder_selector_sc_0/m1_n244_n517# ctrl_over VDD_3V3 VDD_3V3 pfet_06v0 ad=21.472n pd=0.664m as=42.857n ps=1.327m w=244 l=100
X16 ternary_output 5v0_half_adder_selector_sc_0/m1_n244_n517# ternary_input VSS nfet_06v0 ad=0 pd=0 as=14.432n ps=0.504m w=164 l=120
X17 ternary_output 5v0_half_adder_selector_sc_0/m1_n244_n517# 5v0_half_adder_selector_sc_0/res_stage0 VDD_3V3 pfet_06v0 ad=0 pd=0 as=0 ps=0 w=244 l=100
X18 inv_pti pti VSS VSS nfet_06v0 ad=14.432n pd=0.504m as=14.432n ps=0.504m w=164 l=120
X19 inv_pti pti VDD_3V3_uq0 VDD_3V3_uq0 pfet_06v0 ad=21.472n pd=0.664m as=21.472n ps=0.664m w=244 l=100
X20 a_n1373_n454# inv_nti downstepper_test VSS nfet_06v0 ad=3.528n pd=0.195m as=8.599n ps=0.264m w=147 l=120
X21 upstepper_test 5v0_pti_sc_0/nti a_n1205_n937# VDD_3V3 pfet_06v0 ad=21.384n pd=0.662m as=5.832n ps=0.291m w=243 l=100
X22 inv_nti 5v0_pti_sc_0/nti VDD_3V3 VDD_3V3 pfet_06v0 ad=21.472n pd=0.664m as=21.472n ps=0.664m w=244 l=100
X23 upstepper_test 5v0_pti_sc_0/nti VDD_1V65 VSS nfet_06v0 ad=14.847n pd=0.496m as=10.51n ps=0.29m w=147 l=120
X24 a_n1205_n937# inv_pti VDD_3V3 VDD_3V3 pfet_06v0 ad=5.832n pd=0.291m as=21.384n ps=0.662m w=243 l=100
X25 downstepper_test pti a_n1778_n454# VSS nfet_06v0 ad=8.599n pd=0.264m as=3.528n ps=0.195m w=147 l=120
X26 inv_nti 5v0_pti_sc_0/nti VSS VSS nfet_06v0 ad=14.432n pd=0.504m as=14.432n ps=0.504m w=164 l=120
X27 a_n1778_n454# inv_nti VSS VSS nfet_06v0 ad=3.528n pd=0.195m as=14.847n ps=0.496m w=147 l=120
X28 upstepper_test inv_pti VSS VSS nfet_06v0 ad=14.432n pd=0.504m as=14.432n ps=0.504m w=164 l=120
X29 VDD_1V65 inv_pti a_n1373_n454# VSS nfet_06v0 ad=10.51n pd=0.29m as=3.528n ps=0.195m w=147 l=120
X30 downstepper_test inv_nti VDD_3V3 VDD_3V3 pfet_06v0 ad=21.384n pd=0.662m as=21.384n ps=0.662m w=243 l=100
C0 ctrl_over VDD_3V3_uq0 0.0015f
C1 a_n1778_n454# inv_nti 0.00214f
C2 upstepper_test 5v0_half_adder_selector_sc_0/m1_n239_179# 0.07502f
C3 5v0_half_adder_selector_sc_0/5v0_tgate_sel_2_sc_1/input_A downstepper_test 0
C4 upstepper_test 5v0_pti_sc_0/nti 0.11981f
C5 inv_pti VDD_3V3 0.1674f
C6 ternary_input pti 0.54978f
C7 upstepper_test VDD_1V65 0.16859f
C8 5v0_half_adder_selector_sc_0/m1_n239_179# VDD_3V3_uq0 0.28989f
C9 VDD_3V3_uq0 5v0_pti_sc_0/nti 0.16194f
C10 ternary_input ctrl_over 0.0727f
C11 ternary_input a_n1373_n454# 0.00136f
C12 VDD_1V65 VDD_3V3_uq0 0
C13 ternary_input 5v0_half_adder_selector_sc_0/m1_n239_179# 0.00191f
C14 ctrl_sign pti 0
C15 pti 5v0_half_adder_selector_sc_0/m1_n244_n517# 0
C16 ternary_input 5v0_pti_sc_0/nti 0.61523f
C17 ternary_output 5v0_half_adder_selector_sc_0/res_stage0 0.11993f
C18 ternary_input VDD_1V65 0.03394f
C19 ctrl_sign ctrl_over 0.01302f
C20 inv_nti pti 0.11055f
C21 inv_pti downstepper_test 0.07797f
C22 ctrl_over 5v0_half_adder_selector_sc_0/m1_n244_n517# 0.37702f
C23 a_n1778_n454# downstepper_test 0.0031f
C24 ctrl_sign 5v0_half_adder_selector_sc_0/m1_n239_179# 0.30291f
C25 5v0_half_adder_selector_sc_0/m1_n239_179# 5v0_half_adder_selector_sc_0/m1_n244_n517# 0.00395f
C26 upstepper_test ternary_output 0
C27 a_n1373_n454# inv_nti 0
C28 pti VDD_3V3 0.02893f
C29 upstepper_test 5v0_half_adder_selector_sc_0/res_stage0 0.27475f
C30 ctrl_sign 5v0_pti_sc_0/nti 0
C31 5v0_pti_sc_0/nti 5v0_half_adder_selector_sc_0/m1_n244_n517# 0.00226f
C32 VDD_1V65 5v0_half_adder_selector_sc_0/m1_n244_n517# 0
C33 ternary_output VDD_3V3_uq0 0
C34 5v0_half_adder_selector_sc_0/res_stage0 VDD_3V3_uq0 0.02483f
C35 ctrl_over VDD_3V3 0.40911f
C36 a_n1373_n454# VDD_3V3 0.00122f
C37 inv_nti 5v0_pti_sc_0/nti 0.20874f
C38 inv_nti VDD_1V65 0.01114f
C39 a_n1205_n937# 5v0_pti_sc_0/nti 0
C40 5v0_half_adder_selector_sc_0/m1_n239_179# VDD_3V3 0.00154f
C41 VDD_3V3 5v0_pti_sc_0/nti 0.41493f
C42 upstepper_test VDD_3V3_uq0 0.33323f
C43 a_n1205_n937# VDD_1V65 0.00354f
C44 ternary_input ternary_output 0.19159f
C45 ternary_input 5v0_half_adder_selector_sc_0/res_stage0 0.28146f
C46 VDD_1V65 VDD_3V3 0.04703f
C47 pti downstepper_test 0.08313f
C48 ctrl_over 5v0_half_adder_selector_sc_0/5v0_tgate_sel_2_sc_1/input_A 0.01944f
C49 upstepper_test ternary_input 0.02545f
C50 ctrl_over downstepper_test 0.00206f
C51 a_n1373_n454# downstepper_test 0.00442f
C52 ctrl_sign ternary_output 0
C53 ternary_output 5v0_half_adder_selector_sc_0/m1_n244_n517# 0.23201f
C54 ctrl_sign 5v0_half_adder_selector_sc_0/res_stage0 0.22345f
C55 5v0_half_adder_selector_sc_0/res_stage0 5v0_half_adder_selector_sc_0/m1_n244_n517# 0.14284f
C56 ternary_input VDD_3V3_uq0 0.93054f
C57 5v0_half_adder_selector_sc_0/m1_n239_179# downstepper_test 0.09961f
C58 downstepper_test 5v0_pti_sc_0/nti 0.07205f
C59 inv_pti pti 0.19351f
C60 VDD_1V65 downstepper_test 0.13024f
C61 a_n1778_n454# pti 0.00135f
C62 ctrl_sign upstepper_test 0.08746f
C63 upstepper_test 5v0_half_adder_selector_sc_0/m1_n244_n517# 0.00167f
C64 a_n1205_n937# 5v0_half_adder_selector_sc_0/res_stage0 0
C65 a_n1373_n454# inv_pti 0.00135f
C66 ternary_output VDD_3V3 0.15496f
C67 VDD_3V3 5v0_half_adder_selector_sc_0/res_stage0 0.13661f
C68 ctrl_sign VDD_3V3_uq0 0.38402f
C69 VDD_3V3_uq0 5v0_half_adder_selector_sc_0/m1_n244_n517# 0
C70 upstepper_test inv_nti 0.0011f
C71 inv_pti 5v0_half_adder_selector_sc_0/m1_n239_179# 0
C72 upstepper_test a_n1205_n937# 0.00334f
C73 inv_pti 5v0_pti_sc_0/nti 0.21873f
C74 inv_nti VDD_3V3_uq0 0.00196f
C75 upstepper_test VDD_3V3 0.13823f
C76 inv_pti VDD_1V65 0.14775f
C77 a_n1778_n454# 5v0_pti_sc_0/nti 0.00142f
C78 ctrl_sign ternary_input 0.00264f
C79 ternary_input 5v0_half_adder_selector_sc_0/m1_n244_n517# 0.13297f
C80 a_n1778_n454# VDD_1V65 0
C81 5v0_half_adder_selector_sc_0/5v0_tgate_sel_2_sc_1/input_A 5v0_half_adder_selector_sc_0/res_stage0 0.00385f
C82 VDD_3V3 VDD_3V3_uq0 0
C83 ternary_input inv_nti 0.02537f
C84 ternary_output downstepper_test 0.00248f
C85 5v0_half_adder_selector_sc_0/res_stage0 downstepper_test 0.25302f
C86 ternary_input a_n1205_n937# 0
C87 upstepper_test 5v0_half_adder_selector_sc_0/5v0_tgate_sel_2_sc_1/input_A 0
C88 a_n1373_n454# pti 0
C89 ctrl_sign 5v0_half_adder_selector_sc_0/m1_n244_n517# 0.0109f
C90 ternary_input VDD_3V3 0.15325f
C91 upstepper_test downstepper_test 0.38867f
C92 pti 5v0_pti_sc_0/nti 0.1782f
C93 downstepper_test VDD_3V3_uq0 0.10943f
C94 inv_pti 5v0_half_adder_selector_sc_0/res_stage0 0
C95 VDD_1V65 pti 0.00115f
C96 5v0_half_adder_selector_sc_0/m1_n239_179# ctrl_over 0.00486f
C97 ctrl_sign VDD_3V3 0
C98 VDD_3V3 5v0_half_adder_selector_sc_0/m1_n244_n517# 0.27028f
C99 a_n1373_n454# 5v0_pti_sc_0/nti 0
C100 a_n1205_n937# inv_nti 0
C101 a_n1373_n454# VDD_1V65 0.00232f
C102 upstepper_test inv_pti 0.0467f
C103 inv_nti VDD_3V3 0.55403f
C104 ternary_input downstepper_test 0.16659f
C105 upstepper_test a_n1778_n454# 0
C106 a_n1205_n937# VDD_3V3 0.00891f
C107 inv_pti VDD_3V3_uq0 0.23112f
C108 VDD_1V65 5v0_pti_sc_0/nti 0.21326f
C109 ctrl_sign 5v0_half_adder_selector_sc_0/5v0_tgate_sel_2_sc_1/input_A 0
C110 5v0_half_adder_selector_sc_0/5v0_tgate_sel_2_sc_1/input_A 5v0_half_adder_selector_sc_0/m1_n244_n517# 0.07353f
C111 ctrl_sign downstepper_test 0.14523f
C112 downstepper_test 5v0_half_adder_selector_sc_0/m1_n244_n517# 0.02897f
C113 ternary_input inv_pti 0.08498f
C114 ternary_input a_n1778_n454# 0.00116f
C115 inv_nti downstepper_test 0.1819f
C116 5v0_half_adder_selector_sc_0/5v0_tgate_sel_2_sc_1/input_A VDD_3V3 0.03098f
C117 ternary_output ctrl_over 0.18581f
C118 ctrl_over 5v0_half_adder_selector_sc_0/res_stage0 0.04907f
C119 a_n1205_n937# downstepper_test 0.00453f
C120 upstepper_test pti 0
C121 VDD_3V3 downstepper_test 0.41008f
C122 ctrl_sign inv_pti 0.00263f
C123 inv_pti 5v0_half_adder_selector_sc_0/m1_n244_n517# 0
C124 5v0_half_adder_selector_sc_0/m1_n239_179# 5v0_half_adder_selector_sc_0/res_stage0 0.18379f
C125 ternary_output 5v0_pti_sc_0/nti 0
C126 pti VDD_3V3_uq0 0.54139f
C127 5v0_half_adder_selector_sc_0/res_stage0 5v0_pti_sc_0/nti 0.00372f
C128 upstepper_test ctrl_over 0
C129 upstepper_test a_n1373_n454# 0
C130 inv_pti inv_nti 0.08256f
C131 pti VSS 0.62139f
C132 VDD_1V65 VSS 0.09068f
C133 inv_nti VSS 0.5358f
C134 inv_pti VSS 0.6002f
C135 a_n1205_n937# VSS 0 ; **FLOATING
C136 a_n1373_n454# VSS 0.00335f ; **FLOATING
C137 a_n1778_n454# VSS 0.00573f ; **FLOATING
C138 5v0_half_adder_selector_sc_0/5v0_tgate_sel_2_sc_1/input_A VSS 0
C139 ctrl_over VSS 0.55135f
C140 ternary_input VSS 1.93066f
C141 ternary_output VSS 0.28152f
C142 5v0_half_adder_selector_sc_0/m1_n244_n517# VSS 0.39366f ; **FLOATING
C143 VDD_3V3 VSS 4.05558f
C144 5v0_half_adder_selector_sc_0/m1_n239_179# VSS 0.30065f ; **FLOATING
C145 5v0_half_adder_selector_sc_0/res_stage0 VSS 0.50953f
C146 downstepper_test VSS 0.64132f
C147 ctrl_sign VSS 0.56557f
C148 VDD_3V3_uq0 VSS 6.35626f
C149 upstepper_test VSS 0.54838f
C150 5v0_pti_sc_0/nti VSS 1.27643f
