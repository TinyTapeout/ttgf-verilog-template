* Testbench for 5V0 Inverter

* 1. Include the GF180 models (adjust path if your PDK_ROOT is not exported)
.include "$PDK_ROOT/gf180mcuD/libs.tech/ngspice/design.ngspice"
.lib "$PDK_ROOT/gf180mcuD/libs.tech/ngspice/sm141064.ngspice" typical

* 2. Include your Magic-extracted netlist
.include "native_pti_v0.spice"

* 3. Define Power and Ground (5.0V for mv devices)
Vdd VDD 0 DC 5.0
Vss VSS 0 DC 0.0

* 4. Define Input Stimulus (0V to 5.0V pulse)
Vin A 0 PWL(
+   0.0n  0.0
+   2.0n  0.0
+   2.1n  2.5
+   5.0n  2.5
+   5.1n  5.0
+   8.0n  5.0
+   8.1n  2.5
+  11.0n  2.5
+  11.1n  0.0
+  14.0n  0.0
+ )

.dc Vin 0 5.0 0.01
* 6. Simulation Commands
.tran 1p 20n
.op
.control
run
plot v(A) v(Y)
plot i(Vdd)
.endc
.end
