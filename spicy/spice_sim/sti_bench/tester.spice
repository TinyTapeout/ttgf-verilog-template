* Pass-Transistor Transmissive Properties Test (5V0)

.include "$PDK_ROOT/gf180mcuD/libs.tech/ngspice/design.ngspice"
.lib "$PDK_ROOT/gf180mcuD/libs.tech/ngspice/sm141064.ngspice" typical

* 2. Include your Magic-extracted netlist
.include "5v0_sti_sc_v11.spice"

* Absolute power rails for transistor gates and bulk/wells
Vdd 5v0_nti_sc_f_0/VDD_3V3 0 DC 5.0
Vd2 5v0_pti_sc_0/VDD_3V3 0 DC 5.0
Vss 5v0_pti_sc_0/VSS 0 DC 0.0
Vhf VDD_1V65 0 DC 2.5
Vin ternary_input 0 PWL(
+   0.0n  0.0
+   2.0n  0.0
+   2.1n  2.5
+   5.0n  2.5
+   5.1n  5.0
+   8.0n  5.0
+   8.1n  2.5
+  11.0n  2.5
+  11.1n  0.0
+  14.0n  0.0
+ )

CLoad ternary_output 0 10ff

* 6. Simulation Commands
.tran 1p 20n
.op
.control
run
plot v(ternary_input) v(ternary_output)
plot v(5v0_nti_sc_f_0/ternary_output)
plot v(5v0_pti_sc_0/ternary_output)
plot i(Vdd) i(Vhf) i(Vd2)
.endc
.end
