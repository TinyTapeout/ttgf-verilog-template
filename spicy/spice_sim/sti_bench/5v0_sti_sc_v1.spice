* NGSPICE file created from 5v0_sti_sc.ext - technology: gf180mcuD

.option scale=5n

X0 gf180mcu_fd_sc_mcu7t5v0__inv_1_1/I ternary_input 5v0_pti_sc_0/VSS 5v0_pti_sc_0/VSS nfet_06v0 ad=6.336n pd=0.32m as=6.336n ps=0.32m w=72 l=578
X1 5v0_pti_sc_0/VDD_3V3 ternary_input gf180mcu_fd_sc_mcu7t5v0__inv_1_1/I 5v0_pti_sc_0/VDD_3V3 pfet_06v0 ad=12.81n pd=0.349m as=12.688n ps=0.348m w=244 l=100
X2 gf180mcu_fd_sc_mcu7t5v0__inv_1_1/I ternary_input 5v0_pti_sc_0/VDD_3V3 5v0_pti_sc_0/VDD_3V3 pfet_06v0 ad=12.688n pd=0.348m as=21.472n ps=0.664m w=244 l=100
X3 gf180mcu_fd_sc_mcu7t5v0__inv_1_1/I ternary_input 5v0_pti_sc_0/VDD_3V3 5v0_pti_sc_0/VDD_3V3 pfet_06v0 ad=27.328n pd=0.712m as=12.81n ps=0.349m w=244 l=100
X4 5v0_nti_sc_f_0/ternary_output ternary_input 5v0_pti_sc_0/VSS 5v0_pti_sc_0/VSS nfet_06v0 ad=12.7n pd=0.454m as=11.303n ps=0.432m w=127 l=120
X5 5v0_nti_sc_f_0/ternary_output ternary_input 5v0_nti_sc_f_0/VDD_3V3 5v0_nti_sc_f_0/VDD_3V3 pfet_06v0 ad=9.696n pd=0.394m as=8.928n ps=0.378m w=96 l=150
X6 gf180mcu_fd_sc_mcu7t5v0__inv_1_0/ZN 5v0_nti_sc_f_0/ternary_output 5v0_pti_sc_0/VSS 5v0_pti_sc_0/VSS nfet_06v0 ad=14.432n pd=0.504m as=14.432n ps=0.504m w=164 l=120
X7 gf180mcu_fd_sc_mcu7t5v0__inv_1_0/ZN 5v0_nti_sc_f_0/ternary_output 5v0_nti_sc_f_0/VDD_3V3 5v0_nti_sc_f_0/VDD_3V3 pfet_06v0 ad=21.472n pd=0.664m as=21.472n ps=0.664m w=244 l=100
X8 gf180mcu_fd_sc_mcu7t5v0__inv_1_1/ZN gf180mcu_fd_sc_mcu7t5v0__inv_1_1/I 5v0_pti_sc_0/VSS 5v0_pti_sc_0/VSS nfet_06v0 ad=14.432n pd=0.504m as=60.935n ps=2.264m w=164 l=120
X9 gf180mcu_fd_sc_mcu7t5v0__inv_1_1/ZN gf180mcu_fd_sc_mcu7t5v0__inv_1_1/I 5v0_pti_sc_0/VDD_3V3 5v0_pti_sc_0/VDD_3V3 pfet_06v0 ad=21.472n pd=0.664m as=68.564n ps=2.026m w=244 l=100
X10 a_849_392# gf180mcu_fd_sc_mcu7t5v0__inv_1_0/ZN 5v0_nti_sc_f_0/VDD_3V3 5v0_nti_sc_f_0/VDD_3V3 pfet_06v0 ad=21.716n pd=0.666m as=21.472n ps=0.664m w=244 l=100
X11 a_869_n14# gf180mcu_fd_sc_mcu7t5v0__inv_1_0/ZN VDD_1V65 5v0_pti_sc_0/VSS nfet_06v0 ad=4.1n pd=0.214m as=15.908n ps=0.522m w=164 l=120
X12 ternary_output gf180mcu_fd_sc_mcu7t5v0__inv_1_1/I a_869_n14# 5v0_pti_sc_0/VSS nfet_06v0 ad=15.908n pd=0.522m as=4.1n ps=0.214m w=164 l=120
X13 a_1221_n313# gf180mcu_fd_sc_mcu7t5v0__inv_1_1/ZN 5v0_pti_sc_0/VSS 5v0_pti_sc_0/VSS nfet_06v0 ad=14.432n pd=0.504m as=14.432n ps=0.504m w=164 l=120
C0 5v0_pti_sc_0/VDD_3V3 gf180mcu_fd_sc_mcu7t5v0__inv_1_1/I 0.57752f
C1 ternary_input gf180mcu_fd_sc_mcu7t5v0__inv_1_1/I 0.50134f
C2 a_869_n14# gf180mcu_fd_sc_mcu7t5v0__inv_1_0/ZN 0
C3 VDD_1V65 gf180mcu_fd_sc_mcu7t5v0__inv_1_0/ZN 0.17137f
C4 ternary_input a_849_392# 0
C5 5v0_nti_sc_f_0/VDD_3V3 gf180mcu_fd_sc_mcu7t5v0__inv_1_0/ZN 0.38023f
C6 5v0_nti_sc_f_0/ternary_output gf180mcu_fd_sc_mcu7t5v0__inv_1_1/I 0.01933f
C7 ternary_input ternary_output 0
C8 5v0_pti_sc_0/VDD_3V3 gf180mcu_fd_sc_mcu7t5v0__inv_1_1/ZN 0.14169f
C9 ternary_input gf180mcu_fd_sc_mcu7t5v0__inv_1_1/ZN 0
C10 a_869_n14# VDD_1V65 0.00257f
C11 gf180mcu_fd_sc_mcu7t5v0__inv_1_1/I a_849_392# 0.04014f
C12 5v0_pti_sc_0/VDD_3V3 gf180mcu_fd_sc_mcu7t5v0__inv_1_0/ZN 0
C13 gf180mcu_fd_sc_mcu7t5v0__inv_1_1/I ternary_output 0.0269f
C14 ternary_input gf180mcu_fd_sc_mcu7t5v0__inv_1_0/ZN 0.00563f
C15 gf180mcu_fd_sc_mcu7t5v0__inv_1_1/I gf180mcu_fd_sc_mcu7t5v0__inv_1_1/ZN 0.17226f
C16 a_849_392# ternary_output 0.03223f
C17 a_849_392# gf180mcu_fd_sc_mcu7t5v0__inv_1_1/ZN 0
C18 5v0_nti_sc_f_0/ternary_output gf180mcu_fd_sc_mcu7t5v0__inv_1_0/ZN 0.1658f
C19 gf180mcu_fd_sc_mcu7t5v0__inv_1_1/ZN ternary_output 0.00228f
C20 ternary_input VDD_1V65 0
C21 ternary_input 5v0_nti_sc_f_0/VDD_3V3 0.43757f
C22 a_1221_n313# ternary_input 0
C23 gf180mcu_fd_sc_mcu7t5v0__inv_1_1/I gf180mcu_fd_sc_mcu7t5v0__inv_1_0/ZN 0.22939f
C24 a_849_392# gf180mcu_fd_sc_mcu7t5v0__inv_1_0/ZN 0.01664f
C25 5v0_nti_sc_f_0/ternary_output 5v0_nti_sc_f_0/VDD_3V3 0.32274f
C26 ternary_output gf180mcu_fd_sc_mcu7t5v0__inv_1_0/ZN 0.00862f
C27 gf180mcu_fd_sc_mcu7t5v0__inv_1_1/ZN gf180mcu_fd_sc_mcu7t5v0__inv_1_0/ZN 0
C28 gf180mcu_fd_sc_mcu7t5v0__inv_1_1/I a_869_n14# 0.00267f
C29 gf180mcu_fd_sc_mcu7t5v0__inv_1_1/I VDD_1V65 0.04336f
C30 gf180mcu_fd_sc_mcu7t5v0__inv_1_1/I 5v0_nti_sc_f_0/VDD_3V3 0.10255f
C31 a_1221_n313# gf180mcu_fd_sc_mcu7t5v0__inv_1_1/I 0.00232f
C32 a_869_n14# a_849_392# 0.00162f
C33 ternary_input 5v0_pti_sc_0/VDD_3V3 0.57406f
C34 5v0_nti_sc_f_0/VDD_3V3 a_849_392# 0.18572f
C35 a_869_n14# ternary_output 0.00257f
C36 VDD_1V65 ternary_output 0.00912f
C37 5v0_nti_sc_f_0/VDD_3V3 ternary_output 0.02273f
C38 a_1221_n313# ternary_output 0.01021f
C39 5v0_nti_sc_f_0/VDD_3V3 gf180mcu_fd_sc_mcu7t5v0__inv_1_1/ZN 0.00263f
C40 ternary_input 5v0_nti_sc_f_0/ternary_output 0.19601f
C41 a_1221_n313# gf180mcu_fd_sc_mcu7t5v0__inv_1_1/ZN 0.01112f
C42 ternary_output 5v0_pti_sc_0/VSS 0.45451f
C43 VDD_1V65 5v0_pti_sc_0/VSS 0.17863f
C44 5v0_pti_sc_0/VDD_3V3 5v0_pti_sc_0/VSS 2.62533f
C45 a_1221_n313# 5v0_pti_sc_0/VSS 0.317f ; **FLOATING
C46 a_869_n14# 5v0_pti_sc_0/VSS 0.00402f ; **FLOATING
C47 a_849_392# 5v0_pti_sc_0/VSS 0.04219f ; **FLOATING
C48 gf180mcu_fd_sc_mcu7t5v0__inv_1_1/ZN 5v0_pti_sc_0/VSS 0.47867f
C49 gf180mcu_fd_sc_mcu7t5v0__inv_1_1/I 5v0_pti_sc_0/VSS 0.85248f
C50 gf180mcu_fd_sc_mcu7t5v0__inv_1_0/ZN 5v0_pti_sc_0/VSS 0.27239f
C51 5v0_nti_sc_f_0/ternary_output 5v0_pti_sc_0/VSS 0.3685f
C52 5v0_nti_sc_f_0/VDD_3V3 5v0_pti_sc_0/VSS 2.78406f
C53 ternary_input 5v0_pti_sc_0/VSS 1.47467f
