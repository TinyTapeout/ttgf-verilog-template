* NGSPICE file created from 5v0_sti_sc.ext - technology: gf180mcuD

.option scale=5n

X0 gf180mcu_fd_sc_mcu7t5v0__inv_1_1/I ternary_input 5v0_pti_sc_0/VSS 5v0_pti_sc_0/VSS nfet_06v0 ad=6.336n pd=0.32m as=6.336n ps=0.32m w=72 l=578
X1 5v0_pti_sc_0/VDD_3V3 ternary_input gf180mcu_fd_sc_mcu7t5v0__inv_1_1/I 5v0_pti_sc_0/VDD_3V3 pfet_06v0 ad=12.81n pd=0.349m as=12.688n ps=0.348m w=244 l=100
X2 gf180mcu_fd_sc_mcu7t5v0__inv_1_1/I ternary_input 5v0_pti_sc_0/VDD_3V3 5v0_pti_sc_0/VDD_3V3 pfet_06v0 ad=12.688n pd=0.348m as=21.472n ps=0.664m w=244 l=100
X3 gf180mcu_fd_sc_mcu7t5v0__inv_1_1/I ternary_input 5v0_pti_sc_0/VDD_3V3 5v0_pti_sc_0/VDD_3V3 pfet_06v0 ad=27.328n pd=0.712m as=12.81n ps=0.349m w=244 l=100
X4 5v0_nti_sc_f_0/ternary_output ternary_input 5v0_pti_sc_0/VSS 5v0_pti_sc_0/VSS nfet_06v0 ad=12.7n pd=0.454m as=11.303n ps=0.432m w=127 l=120
X5 5v0_nti_sc_f_0/ternary_output ternary_input 5v0_nti_sc_f_0/VDD_3V3 5v0_nti_sc_f_0/VDD_3V3 pfet_06v0 ad=9.696n pd=0.394m as=8.928n ps=0.378m w=96 l=150
X6 gf180mcu_fd_sc_mcu7t5v0__inv_1_0/ZN 5v0_nti_sc_f_0/ternary_output 5v0_pti_sc_0/VSS 5v0_pti_sc_0/VSS nfet_06v0 ad=14.432n pd=0.504m as=14.432n ps=0.504m w=164 l=120
X7 gf180mcu_fd_sc_mcu7t5v0__inv_1_0/ZN 5v0_nti_sc_f_0/ternary_output 5v0_nti_sc_f_0/VDD_3V3 5v0_nti_sc_f_0/VDD_3V3 pfet_06v0 ad=21.472n pd=0.664m as=21.472n ps=0.664m w=244 l=100
X8 gf180mcu_fd_sc_mcu7t5v0__inv_1_1/ZN gf180mcu_fd_sc_mcu7t5v0__inv_1_1/I 5v0_pti_sc_0/VSS 5v0_pti_sc_0/VSS nfet_06v0 ad=14.432n pd=0.504m as=55.391n ps=2.138m w=164 l=120
X9 gf180mcu_fd_sc_mcu7t5v0__inv_1_1/ZN gf180mcu_fd_sc_mcu7t5v0__inv_1_1/I 5v0_pti_sc_0/VDD_3V3 5v0_pti_sc_0/VDD_3V3 pfet_06v0 ad=21.472n pd=0.664m as=68.564n ps=2.026m w=244 l=100
X10 ternary_output gf180mcu_fd_sc_mcu7t5v0__inv_1_0/ZN 5v0_nti_sc_f_0/VDD_3V3 5v0_nti_sc_f_0/VDD_3V3 pfet_06v0 ad=18.423n pd=0.592m as=18.216n ps=0.59m w=207 l=100
X11 ternary_output gf180mcu_fd_sc_mcu7t5v0__inv_1_1/ZN 5v0_pti_sc_0/VSS 5v0_pti_sc_0/VSS nfet_06v0 ad=8.888n pd=0.378m as=8.888n ps=0.378m w=101 l=120
X12 ternary_output gf180mcu_fd_sc_mcu7t5v0__inv_1_1/I a_869_21# 5v0_pti_sc_0/VSS nfet_06v0 ad=12.513n pd=0.452m as=3.225n ps=0.179m w=129 l=120
X13 a_869_21# gf180mcu_fd_sc_mcu7t5v0__inv_1_0/ZN VDD_1V65 5v0_pti_sc_0/VSS nfet_06v0 ad=3.225n pd=0.179m as=12.513n ps=0.452m w=129 l=120
C0 gf180mcu_fd_sc_mcu7t5v0__inv_1_0/ZN a_869_21# 0
C1 gf180mcu_fd_sc_mcu7t5v0__inv_1_0/ZN 5v0_pti_sc_0/VDD_3V3 0
C2 gf180mcu_fd_sc_mcu7t5v0__inv_1_0/ZN ternary_output 0.03704f
C3 gf180mcu_fd_sc_mcu7t5v0__inv_1_0/ZN gf180mcu_fd_sc_mcu7t5v0__inv_1_1/I 0.23435f
C4 5v0_nti_sc_f_0/VDD_3V3 gf180mcu_fd_sc_mcu7t5v0__inv_1_1/ZN 0.00263f
C5 ternary_input gf180mcu_fd_sc_mcu7t5v0__inv_1_0/ZN 0.00616f
C6 ternary_output a_869_21# 0.00475f
C7 ternary_output 5v0_pti_sc_0/VDD_3V3 0.09344f
C8 gf180mcu_fd_sc_mcu7t5v0__inv_1_1/I a_869_21# 0.00212f
C9 gf180mcu_fd_sc_mcu7t5v0__inv_1_1/I 5v0_pti_sc_0/VDD_3V3 0.57646f
C10 gf180mcu_fd_sc_mcu7t5v0__inv_1_0/ZN VDD_1V65 0.17137f
C11 ternary_input 5v0_pti_sc_0/VDD_3V3 0.5738f
C12 gf180mcu_fd_sc_mcu7t5v0__inv_1_1/I ternary_output 0.14498f
C13 gf180mcu_fd_sc_mcu7t5v0__inv_1_0/ZN 5v0_nti_sc_f_0/ternary_output 0.16584f
C14 ternary_input ternary_output 0.00469f
C15 ternary_input gf180mcu_fd_sc_mcu7t5v0__inv_1_1/I 0.50134f
C16 a_869_21# VDD_1V65 0.00257f
C17 5v0_nti_sc_f_0/VDD_3V3 gf180mcu_fd_sc_mcu7t5v0__inv_1_0/ZN 0.40718f
C18 ternary_output VDD_1V65 0.01038f
C19 gf180mcu_fd_sc_mcu7t5v0__inv_1_1/I VDD_1V65 0.04218f
C20 ternary_output 5v0_nti_sc_f_0/ternary_output 0.0018f
C21 gf180mcu_fd_sc_mcu7t5v0__inv_1_1/ZN gf180mcu_fd_sc_mcu7t5v0__inv_1_0/ZN 0
C22 ternary_input VDD_1V65 0
C23 gf180mcu_fd_sc_mcu7t5v0__inv_1_1/I 5v0_nti_sc_f_0/ternary_output 0.01933f
C24 ternary_input 5v0_nti_sc_f_0/ternary_output 0.19601f
C25 5v0_nti_sc_f_0/VDD_3V3 ternary_output 0.2262f
C26 5v0_nti_sc_f_0/VDD_3V3 gf180mcu_fd_sc_mcu7t5v0__inv_1_1/I 0.10007f
C27 gf180mcu_fd_sc_mcu7t5v0__inv_1_1/ZN 5v0_pti_sc_0/VDD_3V3 0.10899f
C28 5v0_nti_sc_f_0/VDD_3V3 ternary_input 0.43697f
C29 gf180mcu_fd_sc_mcu7t5v0__inv_1_1/ZN ternary_output 0.31947f
C30 gf180mcu_fd_sc_mcu7t5v0__inv_1_1/ZN gf180mcu_fd_sc_mcu7t5v0__inv_1_1/I 0.17241f
C31 ternary_input gf180mcu_fd_sc_mcu7t5v0__inv_1_1/ZN 0
C32 5v0_nti_sc_f_0/VDD_3V3 5v0_nti_sc_f_0/ternary_output 0.32269f
C33 VDD_1V65 5v0_pti_sc_0/VSS 0.17759f
C34 ternary_output 5v0_pti_sc_0/VSS 1.07123f
C35 5v0_pti_sc_0/VDD_3V3 5v0_pti_sc_0/VSS 2.625f
C36 a_869_21# 5v0_pti_sc_0/VSS 0.00295f ; **FLOATING
C37 gf180mcu_fd_sc_mcu7t5v0__inv_1_1/ZN 5v0_pti_sc_0/VSS 0.45212f
C38 gf180mcu_fd_sc_mcu7t5v0__inv_1_1/I 5v0_pti_sc_0/VSS 0.81091f
C39 gf180mcu_fd_sc_mcu7t5v0__inv_1_0/ZN 5v0_pti_sc_0/VSS 0.29545f
C40 5v0_nti_sc_f_0/ternary_output 5v0_pti_sc_0/VSS 0.36846f
C41 5v0_nti_sc_f_0/VDD_3V3 5v0_pti_sc_0/VSS 2.7877f
C42 ternary_input 5v0_pti_sc_0/VSS 1.46587f
