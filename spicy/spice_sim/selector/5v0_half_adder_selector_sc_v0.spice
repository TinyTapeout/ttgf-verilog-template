* NGSPICE file created from 5v0_half_adder_selector_sc.ext - technology: gf180mcuD

.option scale=5n

X0 m1_n9_n292# m1_n239_179# in_downstep VSS nfet_06v0 ad=14.432n pd=0.504m as=14.432n ps=0.504m w=164 l=120
X1 m1_n9_n292# m1_n239_179# in_upstep VDD_3V3 pfet_06v0 ad=21.472n pd=0.664m as=21.472n ps=0.664m w=244 l=100
X2 m1_n239_179# m1_n357_144# VSS VSS nfet_06v0 ad=14.432n pd=0.504m as=14.432n ps=0.504m w=164 l=120
X3 m1_n239_179# m1_n357_144# VDD_3V3 VDD_3V3 pfet_06v0 ad=21.472n pd=0.664m as=21.472n ps=0.664m w=244 l=100
X4 m1_n9_n292# m1_n357_144# in_upstep VSS nfet_06v0 ad=31.489n pd=1.041m as=14.432n ps=0.504m w=164 l=120
X5 m1_n9_n292# m1_n357_144# in_downstep VDD_3V3 pfet_06v0 ad=46.849n pd=1.361m as=21.472n ps=0.664m w=244 l=100
X6 result m1_n437_n664# m1_n9_n292# VSS nfet_06v0 ad=17.057n pd=0.537m as=0 ps=0 w=164 l=120
X7 result m1_n437_n664# in_reg VDD_3V3_uq0 pfet_06v0 ad=25.377n pd=0.697m as=21.472n ps=0.664m w=244 l=100
X8 m1_n244_n517# m1_n437_n664# VSS VSS nfet_06v0 ad=14.432n pd=0.504m as=28.864n ps=1.008m w=164 l=120
X9 m1_n244_n517# m1_n437_n664# VDD_3V3_uq0 VDD_3V3_uq0 pfet_06v0 ad=21.472n pd=0.664m as=21.472n ps=0.664m w=244 l=100
X10 result m1_n244_n517# in_reg VSS nfet_06v0 ad=0 pd=0 as=14.432n ps=0.504m w=164 l=120
X11 result m1_n244_n517# m1_n9_n292# VDD_3V3_uq0 pfet_06v0 ad=0 pd=0 as=0 ps=0 w=244 l=100
C0 m1_n239_179# in_reg 0
C1 m1_n357_144# VDD_3V3_uq0 0
C2 m1_n239_179# m1_n9_n292# 0.18379f
C3 m1_n239_179# VDD_3V3_uq0 0.00103f
C4 in_downstep in_upstep 0.25015f
C5 m1_n9_n292# VDD_3V3 0.01666f
C6 5v0_tgate_sel_2_sc_1/input_A in_upstep 0
C7 in_reg in_upstep 0.00165f
C8 m1_n437_n664# in_downstep 0.00163f
C9 m1_n9_n292# in_upstep 0.12896f
C10 m1_n244_n517# m1_n437_n664# 0.37702f
C11 5v0_tgate_sel_2_sc_1/input_A m1_n437_n664# 0.01944f
C12 m1_n244_n517# in_downstep 0.02742f
C13 m1_n357_144# m1_n239_179# 0.30291f
C14 5v0_tgate_sel_2_sc_1/input_A in_downstep 0
C15 in_reg m1_n437_n664# 0.06818f
C16 m1_n437_n664# m1_n9_n292# 0.05031f
C17 m1_n437_n664# VDD_3V3_uq0 0.38476f
C18 m1_n357_144# VDD_3V3 0.34341f
C19 in_reg in_downstep 0.00615f
C20 m1_n244_n517# 5v0_tgate_sel_2_sc_1/input_A 0.07353f
C21 m1_n9_n292# in_downstep 0.17288f
C22 m1_n239_179# VDD_3V3 0.26871f
C23 VDD_3V3_uq0 in_downstep 0
C24 m1_n244_n517# in_reg 0.11418f
C25 m1_n244_n517# m1_n9_n292# 0.14285f
C26 m1_n244_n517# VDD_3V3_uq0 0.23373f
C27 5v0_tgate_sel_2_sc_1/input_A m1_n9_n292# 0.00385f
C28 5v0_tgate_sel_2_sc_1/input_A VDD_3V3_uq0 0.03098f
C29 m1_n357_144# in_upstep 0.08621f
C30 in_reg m1_n9_n292# 0.2436f
C31 in_reg VDD_3V3_uq0 0.0303f
C32 m1_n239_179# in_upstep 0.07502f
C33 result m1_n437_n664# 0.16286f
C34 m1_n9_n292# VDD_3V3_uq0 0.06705f
C35 result in_downstep 0
C36 VDD_3V3 in_upstep 0.1781f
C37 m1_n357_144# m1_n437_n664# 0.01302f
C38 m1_n244_n517# result 0.2082f
C39 m1_n239_179# m1_n437_n664# 0.00486f
C40 m1_n357_144# in_downstep 0.14263f
C41 m1_n239_179# in_downstep 0.09818f
C42 result in_reg 0.15483f
C43 m1_n437_n664# VDD_3V3 0.00148f
C44 m1_n244_n517# m1_n357_144# 0.01628f
C45 result m1_n9_n292# 0.07822f
C46 m1_n357_144# 5v0_tgate_sel_2_sc_1/input_A 0
C47 result VDD_3V3_uq0 0.01786f
C48 m1_n244_n517# m1_n239_179# 0.00541f
C49 VDD_3V3 in_downstep 0.04186f
C50 m1_n357_144# m1_n9_n292# 0.22345f
C51 5v0_tgate_sel_2_sc_1/input_A VSS 0
C52 m1_n437_n664# VSS 0.55758f ; **FLOATING
C53 in_reg VSS 0.52668f
C54 result VSS 0.02264f
C55 m1_n244_n517# VSS 0.34224f ; **FLOATING
C56 VDD_3V3_uq0 VSS 2.07393f
C57 m1_n239_179# VSS 0.2822f ; **FLOATING
C58 m1_n9_n292# VSS 0.4658f ; **FLOATING
C59 in_downstep VSS 0.2519f
C60 m1_n357_144# VSS 0.56927f ; **FLOATING
C61 VDD_3V3 VSS 2.06281f
C62 in_upstep VSS 0.3541f
