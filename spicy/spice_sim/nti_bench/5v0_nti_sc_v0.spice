* NGSPICE file created from 5v0_nti_sc.ext - technology: gf180mcuD

.option scale=5n

X0 ternary_output ternary_input VDD_3V3 VDD_3V3 pfet_06v0 ad=11.021n pd=0.42m as=10.272n ps=0.406m w=107 l=528
X1 ternary_output ternary_input VSS VSS nfet_06v0 ad=11.176n pd=0.43m as=7.175n ps=0.24m w=127 l=120
X2 VSS ternary_input ternary_output VSS nfet_06v0 ad=7.175n pd=0.24m as=6.667n ps=0.232m w=127 l=120
X3 ternary_output ternary_input VSS VSS nfet_06v0 ad=6.667n pd=0.232m as=11.303n ps=0.432m w=127 l=120
C0 ternary_output VDD_3V3 0.0797f
C1 ternary_output ternary_input 0.33963f
C2 ternary_input VDD_3V3 0.77821f
C3 ternary_output VSS 0.31194f
C4 ternary_input VSS 0.6503f
C5 VDD_3V3 VSS 2.13064f
