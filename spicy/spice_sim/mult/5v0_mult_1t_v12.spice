* NGSPICE file created from 5v0_mult_1t.ext - technology: gf180mcuD

.option scale=5n

X0 inv in VSS VSS nfet_06v0 ad=6.336n pd=0.32m as=6.478n ps=0.255m w=72 l=578
X1 VDD_3V3_1 in inv VDD_3V3_1 pfet_06v0 ad=12.81n pd=0.349m as=12.688n ps=0.348m w=244 l=100
X2 VDD_3V3_1 in nti VDD_3V3_1 pfet_06v0 ad=13.616n pd=0.392m as=9.696n ps=0.394m w=96 l=150
X3 VSS in nti VSS nfet_06v0 ad=6.478n pd=0.255m as=12.7n ps=0.454m w=127 l=120
X4 inv in VDD_3V3_1 VDD_3V3_1 pfet_06v0 ad=12.688n pd=0.348m as=13.616n ps=0.392m w=244 l=100
X5 inv in VDD_3V3_1 VDD_3V3_1 pfet_06v0 ad=27.328n pd=0.712m as=12.81n ps=0.349m w=244 l=100
X6 mux2_mult_custom_0/a_896_593# sign mux2_mult_custom_0/a_124_24# VDD_3V3_0 pfet_06v0 ad=2.952n pd=0.171m as=6.396n ps=0.227m w=123 l=100
X7 VSS mux2_mult_custom_0/a_124_24# mux_res VSS nfet_06v0 ad=8.72n pd=0.304m as=14.432n ps=0.504m w=164 l=120
X8 mux2_mult_custom_0/a_124_24# sign mux2_mult_custom_0/a_504_104# VSS nfet_06v0 ad=3.744n pd=0.176m as=1.728n ps=0.12m w=72 l=120
X9 VDD_3V3_0 mux2_mult_custom_0/a_124_24# mux_res VDD_3V3_0 pfet_06v0 ad=17.193n pd=0.437m as=21.472n ps=0.664m w=244 l=100
X10 VDD_3V3_0 inv mux2_mult_custom_0/a_896_593# VDD_3V3_0 pfet_06v0 ad=6.396n pd=0.227m as=2.952n ps=0.171m w=123 l=100
X11 mux2_mult_custom_0/a_592_407# sign VSS VSS nfet_06v0 ad=6.336n pd=0.32m as=3.744n ps=0.176m w=72 l=120
X12 mux2_mult_custom_0/a_504_104# original VSS VSS nfet_06v0 ad=1.728n pd=0.12m as=8.72n ps=0.304m w=72 l=120
X13 mux2_mult_custom_0/a_592_407# sign VDD_3V3_0 VDD_3V3_0 pfet_06v0 ad=10.824n pd=0.422m as=6.396n ps=0.227m w=123 l=100
X14 mux2_mult_custom_0/a_537_593# original VDD_3V3_0 VDD_3V3_0 pfet_06v0 ad=3.382n pd=0.178m as=17.193n ps=0.437m w=123 l=100
X15 VSS inv mux2_mult_custom_0/a_896_104# VSS nfet_06v0 ad=3.744n pd=0.176m as=1.728n ps=0.12m w=72 l=120
X16 mux2_mult_custom_0/a_896_104# mux2_mult_custom_0/a_592_407# mux2_mult_custom_0/a_124_24# VSS nfet_06v0 ad=1.728n pd=0.12m as=3.744n ps=0.176m w=72 l=120
X17 mux2_mult_custom_0/a_124_24# mux2_mult_custom_0/a_592_407# mux2_mult_custom_0/a_537_593# VDD_3V3_0 pfet_06v0 ad=6.396n pd=0.227m as=3.382n ps=0.178m w=123 l=100
X18 nor over gf180mcu_fd_sc_mcu7t5v0__nor3_1_0/a_448_472# VDD_3V3_1 pfet_06v0 ad=21.472n pd=0.664m as=15.128n ps=0.368m w=244 l=100
X19 nor over VSS VSS nfet_06v0 ad=8.184n pd=0.362m as=4.836n ps=0.197m w=93 l=120
X20 gf180mcu_fd_sc_mcu7t5v0__nor3_1_0/a_244_472# nti VDD_3V3_1 VDD_3V3_1 pfet_06v0 ad=12.688n pd=0.348m as=21.472n ps=0.664m w=244 l=100
X21 gf180mcu_fd_sc_mcu7t5v0__nor3_1_0/a_448_472# original gf180mcu_fd_sc_mcu7t5v0__nor3_1_0/a_244_472# VDD_3V3_1 pfet_06v0 ad=15.128n pd=0.368m as=12.688n ps=0.348m w=244 l=100
X22 VSS original nor VSS nfet_06v0 ad=4.836n pd=0.197m as=4.836n ps=0.197m w=93 l=120
X23 nor nti VSS VSS nfet_06v0 ad=4.836n pd=0.197m as=8.184n ps=0.362m w=93 l=120
X24 m1_n1363_n1702# nor VSS VSS nfet_06v0 ad=14.432n pd=0.504m as=14.432n ps=0.504m w=164 l=120
X25 m1_n1363_n1702# nor VDD_3V3_0 VDD_3V3_0 pfet_06v0 ad=21.472n pd=0.664m as=21.472n ps=0.664m w=244 l=100
X26 original inv VSS VSS nfet_06v0 ad=14.432n pd=0.504m as=84.604n ps=3.234m w=164 l=120
X27 original inv VDD_3V3_1 VDD_3V3_1 pfet_06v0 ad=21.472n pd=0.664m as=95.796n ps=2.81m w=244 l=100
X28 mux_res m1_n1363_n1702# res VSS nfet_06v0 ad=14.432n pd=0.504m as=14.432n ps=0.504m w=164 l=120
X29 res nor VDD_1V65 VSS nfet_06v0 ad=14.432n pd=0.504m as=14.432n ps=0.504m w=164 l=120
C0 over nor 0.30022f
C1 mux2_mult_custom_0/a_592_407# mux2_mult_custom_0/a_896_593# 0
C2 VDD_3V3_0 nor 0.38577f
C3 in original 0.1631f
C4 mux2_mult_custom_0/a_896_104# mux2_mult_custom_0/a_124_24# 0.00101f
C5 over VDD_3V3_1 0.18631f
C6 nti original 0.31213f
C7 VDD_3V3_0 VDD_3V3_1 0
C8 mux2_mult_custom_0/a_124_24# VDD_1V65 0
C9 nti res 0
C10 nor original 0.12053f
C11 sign in 0.00584f
C12 mux2_mult_custom_0/a_592_407# mux2_mult_custom_0/a_896_104# 0.00166f
C13 VDD_3V3_1 original 0.56436f
C14 VDD_3V3_0 mux2_mult_custom_0/a_124_24# 0.49102f
C15 nor res 0.16969f
C16 sign nor 0
C17 inv in 0.45244f
C18 mux_res in 0.00213f
C19 nti inv 0.00232f
C20 mux2_mult_custom_0/a_124_24# original 0.32838f
C21 sign VDD_3V3_1 0.00142f
C22 VDD_3V3_0 mux2_mult_custom_0/a_592_407# 0.35858f
C23 VDD_3V3_0 mux2_mult_custom_0/a_537_593# 0.00245f
C24 VDD_3V3_0 mux2_mult_custom_0/a_896_593# 0.005f
C25 inv nor 0
C26 res mux2_mult_custom_0/a_124_24# 0.00134f
C27 mux_res nor 0.06829f
C28 inv VDD_3V3_1 0.55173f
C29 sign mux2_mult_custom_0/a_124_24# 0.12833f
C30 mux2_mult_custom_0/a_592_407# original 0.07102f
C31 mux2_mult_custom_0/a_537_593# original 0
C32 mux2_mult_custom_0/a_896_593# original 0
C33 nti gf180mcu_fd_sc_mcu7t5v0__nor3_1_0/a_244_472# 0.01909f
C34 inv mux2_mult_custom_0/a_124_24# 0.00505f
C35 sign mux2_mult_custom_0/a_592_407# 0.22431f
C36 over VDD_1V65 0
C37 nor gf180mcu_fd_sc_mcu7t5v0__nor3_1_0/a_244_472# 0.00216f
C38 mux2_mult_custom_0/a_504_104# original 0
C39 sign mux2_mult_custom_0/a_537_593# 0
C40 mux_res mux2_mult_custom_0/a_124_24# 0.09045f
C41 sign mux2_mult_custom_0/a_896_593# 0.00276f
C42 VDD_3V3_0 VDD_1V65 0.01001f
C43 VDD_3V3_1 gf180mcu_fd_sc_mcu7t5v0__nor3_1_0/a_244_472# 0.00689f
C44 mux2_mult_custom_0/a_896_104# original 0.00154f
C45 VDD_3V3_0 over 0.00126f
C46 mux2_mult_custom_0/a_592_407# inv 0.30165f
C47 in m1_n1363_n1702# 0.00474f
C48 VDD_1V65 original 0.00148f
C49 gf180mcu_fd_sc_mcu7t5v0__nor3_1_0/a_448_472# nor 0.00983f
C50 nti m1_n1363_n1702# 0.00607f
C51 over original 0.0804f
C52 res VDD_1V65 0.02578f
C53 gf180mcu_fd_sc_mcu7t5v0__nor3_1_0/a_448_472# VDD_3V3_1 0.01448f
C54 nor m1_n1363_n1702# 0.39061f
C55 VDD_3V3_0 original 0.2369f
C56 VDD_3V3_1 m1_n1363_n1702# 0.00327f
C57 VDD_3V3_0 res 0.40816f
C58 VDD_3V3_0 sign 0.4897f
C59 mux_res VDD_1V65 0
C60 mux2_mult_custom_0/a_124_24# m1_n1363_n1702# 0.02566f
C61 res original 0.00401f
C62 VDD_3V3_0 inv 0.21619f
C63 sign original 0.22461f
C64 VDD_3V3_0 mux_res 0.07671f
C65 mux2_mult_custom_0/a_592_407# m1_n1363_n1702# 0.00119f
C66 sign res 0
C67 inv original 0.4972f
C68 mux_res original 0.00412f
C69 mux_res res 0.0589f
C70 sign inv 0.35803f
C71 mux_res sign 0
C72 gf180mcu_fd_sc_mcu7t5v0__nor3_1_0/a_244_472# original 0.00714f
C73 gf180mcu_fd_sc_mcu7t5v0__nor3_1_0/a_448_472# over 0.01262f
C74 VDD_1V65 m1_n1363_n1702# 0.12434f
C75 nti in 0.17102f
C76 over m1_n1363_n1702# 0.00178f
C77 VDD_3V3_0 m1_n1363_n1702# 0.20908f
C78 in nor 0.00688f
C79 gf180mcu_fd_sc_mcu7t5v0__nor3_1_0/a_448_472# original 0.01521f
C80 nti nor 0.06288f
C81 in VDD_3V3_1 0.87292f
C82 nti VDD_3V3_1 0.3952f
C83 m1_n1363_n1702# original 0.02222f
C84 nor VDD_3V3_1 0.12688f
C85 in mux2_mult_custom_0/a_124_24# 0.00523f
C86 res m1_n1363_n1702# 0.30043f
C87 sign m1_n1363_n1702# 0.00365f
C88 nor mux2_mult_custom_0/a_124_24# 0.0114f
C89 mux2_mult_custom_0/a_592_407# in 0.00518f
C90 inv m1_n1363_n1702# 0.00214f
C91 VDD_3V3_1 mux2_mult_custom_0/a_124_24# 0.00176f
C92 mux_res m1_n1363_n1702# 0.11502f
C93 mux2_mult_custom_0/a_592_407# nor 0
C94 mux2_mult_custom_0/a_592_407# VDD_3V3_1 0
C95 nor mux2_mult_custom_0/a_504_104# 0
C96 mux2_mult_custom_0/a_592_407# mux2_mult_custom_0/a_124_24# 0.02837f
C97 mux2_mult_custom_0/a_537_593# mux2_mult_custom_0/a_124_24# 0.00556f
C98 nti VDD_1V65 0
C99 mux2_mult_custom_0/a_896_104# nor 0
C100 mux2_mult_custom_0/a_896_593# mux2_mult_custom_0/a_124_24# 0.00106f
C101 in over 0
C102 nti over 0
C103 VDD_3V3_0 in 0.00486f
C104 nor VDD_1V65 0.1548f
C105 VDD_3V3_0 nti 0
C106 mux2_mult_custom_0/a_124_24# mux2_mult_custom_0/a_504_104# 0.00317f
C107 mux2_mult_custom_0/a_592_407# mux2_mult_custom_0/a_537_593# 0
C108 res VSS 0.05678f
C109 VDD_1V65 VSS 0.17428f
C110 m1_n1363_n1702# VSS 0.42239f ; **FLOATING
C111 nor VSS 1.14942f
C112 VDD_3V3_1 VSS 4.42346f
C113 over VSS 0.215f
C114 mux_res VSS 0.05909f
C115 inv VSS 0.76888f
C116 sign VSS 0.44715f
C117 original VSS 1.11723f
C118 VDD_3V3_0 VSS 4.5158f
C119 mux2_mult_custom_0/a_896_104# VSS 0.00302f ; **FLOATING
C120 mux2_mult_custom_0/a_504_104# VSS 0 ; **FLOATING
C121 mux2_mult_custom_0/a_592_407# VSS 0.49094f ; **FLOATING
C122 mux2_mult_custom_0/a_124_24# VSS 0.50074f ; **FLOATING
C123 nti VSS 0.32961f
C124 in VSS 0.96777f
