* NGSPICE file created from 5v0_mult_1t_b.ext - technology: gf180mcuD

.option scale=5n

X0 nti in VSS VSS nfet_06v0 ad=6.336n pd=0.32m as=6.478n ps=0.255m w=72 l=578
X1 VDD_3V3_1 in nti VDD_3V3_1 pfet_06v0 ad=12.81n pd=0.349m as=12.688n ps=0.348m w=244 l=100
X2 VDD_3V3_1 in inverter_pair_short_0/nti VDD_3V3_1 pfet_06v0 ad=13.616n pd=0.392m as=9.696n ps=0.394m w=96 l=150
X3 VSS in inverter_pair_short_0/nti VSS nfet_06v0 ad=6.478n pd=0.255m as=12.7n ps=0.454m w=127 l=120
X4 nti in VDD_3V3_1 VDD_3V3_1 pfet_06v0 ad=12.688n pd=0.348m as=13.616n ps=0.392m w=244 l=100
X5 nti in VDD_3V3_1 VDD_3V3_1 pfet_06v0 ad=27.328n pd=0.712m as=12.81n ps=0.349m w=244 l=100
X6 a_n1011_n1581# nor VSS VSS nfet_06v0 ad=14.432n pd=0.504m as=14.432n ps=0.504m w=164 l=120
X7 a_n1011_n1581# nor VDD_3V3_0 VDD_3V3_0 pfet_06v0 ad=21.472n pd=0.664m as=21.472n ps=0.664m w=244 l=100
X8 original inverter_pair_short_0/nti VSS VSS nfet_06v0 ad=14.432n pd=0.504m as=0.10536u ps=3.904m w=164 l=120
X9 original inverter_pair_short_0/nti VDD_3V3_1 VDD_3V3_1 pfet_06v0 ad=21.472n pd=0.664m as=0.13882u ps=4.048m w=244 l=100
X10 nor gf180mcu_fd_sc_mcu7t5v0__and2_1_0/Z gf180mcu_fd_sc_mcu7t5v0__nor2_1_0/a_224_472# VDD_3V3_1 pfet_06v0 ad=21.472n pd=0.664m as=16.348n ps=0.378m w=244 l=100
X11 VSS gf180mcu_fd_sc_mcu7t5v0__and2_1_0/Z nor VSS nfet_06v0 ad=9.944n pd=0.402m as=5.876n ps=0.217m w=113 l=120
X12 gf180mcu_fd_sc_mcu7t5v0__nor2_1_0/a_224_472# over VDD_3V3_1 VDD_3V3_1 pfet_06v0 ad=16.348n pd=0.378m as=21.472n ps=0.664m w=244 l=100
X13 nor over VSS VSS nfet_06v0 ad=5.876n pd=0.217m as=9.944n ps=0.402m w=113 l=120
X14 VDD_3V3_1 original gf180mcu_fd_sc_mcu7t5v0__and2_1_0/a_36_159# VDD_3V3_1 pfet_06v0 ad=16.23n pd=0.411m as=6.24n ps=0.224m w=120 l=100
X15 gf180mcu_fd_sc_mcu7t5v0__and2_1_0/Z gf180mcu_fd_sc_mcu7t5v0__and2_1_0/a_36_159# VDD_3V3_1 VDD_3V3_1 pfet_06v0 ad=21.384n pd=0.662m as=16.23n ps=0.411m w=243 l=100
X16 gf180mcu_fd_sc_mcu7t5v0__and2_1_0/Z gf180mcu_fd_sc_mcu7t5v0__and2_1_0/a_36_159# VSS VSS nfet_06v0 ad=14.344n pd=0.502m as=9.362n ps=0.311m w=163 l=120
X17 VSS original gf180mcu_fd_sc_mcu7t5v0__and2_1_0/a_244_159# VSS nfet_06v0 ad=9.362n pd=0.311m as=2.336n ps=0.137m w=73 l=120
X18 gf180mcu_fd_sc_mcu7t5v0__and2_1_0/a_244_159# nti gf180mcu_fd_sc_mcu7t5v0__and2_1_0/a_36_159# VSS nfet_06v0 ad=2.336n pd=0.137m as=6.424n ps=0.322m w=73 l=120
X19 gf180mcu_fd_sc_mcu7t5v0__and2_1_0/a_36_159# nti VDD_3V3_1 VDD_3V3_1 pfet_06v0 ad=6.24n pd=0.224m as=10.56n ps=0.416m w=120 l=100
X20 res a_n1011_n1581# VDD_1V65 VSS nfet_06v0 ad=8.528n pd=0.268m as=14.432n ps=0.504m w=164 l=120
X21 a_209_n1430# a_n95_n2014# a_n563_n1613# VSS nfet_06v0 ad=1.728n pd=0.12m as=3.744n ps=0.176m w=72 l=120
X22 VDD_3V3_0 inverter_pair_short_0/nti a_209_n1970# VDD_3V3_0 pfet_06v0 ad=6.396n pd=0.227m as=2.952n ps=0.171m w=123 l=100
X23 a_n563_n1613# sign a_n183_n1430# VSS nfet_06v0 ad=3.744n pd=0.176m as=1.728n ps=0.12m w=72 l=120
X24 a_n183_n1430# original VSS VSS nfet_06v0 ad=1.728n pd=0.12m as=8.72n ps=0.304m w=72 l=120
X25 a_n563_n1613# a_n95_n2014# a_n150_n1970# VDD_3V3_0 pfet_06v0 ad=6.396n pd=0.227m as=3.382n ps=0.178m w=123 l=100
X26 a_n95_n2014# sign VDD_3V3_0 VDD_3V3_0 pfet_06v0 ad=10.824n pd=0.422m as=6.396n ps=0.227m w=123 l=100
X27 VDD_3V3_0 a_n563_n1613# a_n667_n1970# VDD_3V3_0 pfet_06v0 ad=17.193n pd=0.437m as=15.128n ps=0.368m w=244 l=100
X28 VSS a_n563_n1613# a_n667_n1486# VSS nfet_06v0 ad=8.72n pd=0.304m as=8.528n ps=0.268m w=164 l=120
X29 a_n667_n1970# a_n1011_n1581# res VDD_3V3_0 pfet_06v0 ad=15.128n pd=0.368m as=21.472n ps=0.664m w=244 l=100
X30 a_n95_n2014# sign VSS VSS nfet_06v0 ad=6.336n pd=0.32m as=3.744n ps=0.176m w=72 l=120
X31 a_n150_n1970# original VDD_3V3_0 VDD_3V3_0 pfet_06v0 ad=3.382n pd=0.178m as=17.193n ps=0.437m w=123 l=100
X32 a_n667_n1486# nor res VSS nfet_06v0 ad=8.528n pd=0.268m as=8.528n ps=0.268m w=164 l=120
X33 a_209_n1970# sign a_n563_n1613# VDD_3V3_0 pfet_06v0 ad=2.952n pd=0.171m as=6.396n ps=0.227m w=123 l=100
X34 VSS inverter_pair_short_0/nti a_209_n1430# VSS nfet_06v0 ad=3.744n pd=0.176m as=1.728n ps=0.12m w=72 l=120
C0 VDD_1V65 res 0.02972f
C1 a_n1011_n1581# VDD_1V65 0.12271f
C2 a_n667_n1486# original 0.00305f
C3 gf180mcu_fd_sc_mcu7t5v0__and2_1_0/Z over 0.02124f
C4 nti res 0
C5 a_n1011_n1581# nti 0.00378f
C6 VDD_3V3_0 over 0.00261f
C7 over gf180mcu_fd_sc_mcu7t5v0__nor2_1_0/a_224_472# 0.00898f
C8 sign VDD_3V3_1 0.00354f
C9 in a_n1011_n1581# 0
C10 gf180mcu_fd_sc_mcu7t5v0__and2_1_0/a_36_159# VDD_1V65 0
C11 sign a_n563_n1613# 0.12833f
C12 VDD_3V3_1 gf180mcu_fd_sc_mcu7t5v0__and2_1_0/Z 0.27507f
C13 nor res 0.07706f
C14 nor a_n1011_n1581# 0.31216f
C15 nti gf180mcu_fd_sc_mcu7t5v0__and2_1_0/a_36_159# 0.26623f
C16 VDD_3V3_1 VDD_3V3_0 0.00136f
C17 VDD_3V3_1 gf180mcu_fd_sc_mcu7t5v0__nor2_1_0/a_224_472# 0.01452f
C18 in gf180mcu_fd_sc_mcu7t5v0__and2_1_0/a_36_159# 0.00106f
C19 VDD_3V3_0 a_n563_n1613# 0.49402f
C20 a_209_n1430# original 0.00154f
C21 nor gf180mcu_fd_sc_mcu7t5v0__and2_1_0/a_36_159# 0.05938f
C22 VDD_3V3_1 inverter_pair_short_0/nti 0.33293f
C23 a_n150_n1970# original 0
C24 VDD_3V3_0 a_n667_n1486# 0.00154f
C25 inverter_pair_short_0/nti a_n563_n1613# 0.00505f
C26 VDD_3V3_1 a_n95_n2014# 0.0016f
C27 a_n95_n2014# a_n563_n1613# 0.02837f
C28 over nti 0
C29 a_209_n1970# a_n563_n1613# 0.00106f
C30 VDD_1V65 a_n563_n1613# 0
C31 nor over 0.20682f
C32 a_n1011_n1581# res 0.29914f
C33 VDD_3V3_1 nti 0.57863f
C34 VDD_3V3_1 in 0.87095f
C35 in a_n563_n1613# 0.00813f
C36 a_n667_n1970# res 0.0097f
C37 a_n667_n1486# VDD_1V65 0
C38 sign original 0.22468f
C39 sign a_n150_n1970# 0
C40 nor VDD_3V3_1 0.11021f
C41 gf180mcu_fd_sc_mcu7t5v0__and2_1_0/Z original 0.01481f
C42 a_n1011_n1581# gf180mcu_fd_sc_mcu7t5v0__and2_1_0/a_36_159# 0
C43 nor a_n563_n1613# 0.03081f
C44 VDD_3V3_0 original 0.23799f
C45 VDD_3V3_0 a_n150_n1970# 0.00245f
C46 gf180mcu_fd_sc_mcu7t5v0__nor2_1_0/a_224_472# original 0
C47 nor a_n667_n1486# 0.00319f
C48 a_n183_n1430# a_n563_n1613# 0.00317f
C49 gf180mcu_fd_sc_mcu7t5v0__and2_1_0/a_244_159# original 0
C50 a_209_n1430# a_n95_n2014# 0.00166f
C51 inverter_pair_short_0/nti original 0.4393f
C52 a_n95_n2014# original 0.07104f
C53 a_n95_n2014# a_n150_n1970# 0
C54 a_209_n1970# original 0
C55 VDD_1V65 original 0.0012f
C56 sign VDD_3V3_0 0.4895f
C57 VDD_3V3_1 a_n1011_n1581# 0.00102f
C58 gf180mcu_fd_sc_mcu7t5v0__and2_1_0/Z VDD_3V3_0 0.00161f
C59 a_n563_n1613# res 0.02016f
C60 a_n1011_n1581# a_n563_n1613# 0.02018f
C61 nti original 0.16888f
C62 in original 0.16601f
C63 a_n667_n1970# a_n563_n1613# 0.00243f
C64 a_209_n1430# nor 0
C65 gf180mcu_fd_sc_mcu7t5v0__and2_1_0/a_244_159# gf180mcu_fd_sc_mcu7t5v0__and2_1_0/Z 0
C66 VDD_3V3_1 gf180mcu_fd_sc_mcu7t5v0__and2_1_0/a_36_159# 0.25656f
C67 sign inverter_pair_short_0/nti 0.35803f
C68 nor original 0.0598f
C69 a_n667_n1486# res 0.00421f
C70 sign a_n95_n2014# 0.22431f
C71 sign a_209_n1970# 0.00276f
C72 VDD_3V3_0 inverter_pair_short_0/nti 0.21645f
C73 VDD_3V3_0 a_n95_n2014# 0.35821f
C74 a_n183_n1430# original 0
C75 a_209_n1970# VDD_3V3_0 0.005f
C76 VDD_3V3_0 VDD_1V65 0.01106f
C77 sign in 0.0025f
C78 VDD_3V3_1 over 0.2741f
C79 gf180mcu_fd_sc_mcu7t5v0__and2_1_0/Z nti 0
C80 gf180mcu_fd_sc_mcu7t5v0__and2_1_0/Z in 0
C81 inverter_pair_short_0/nti a_n95_n2014# 0.30177f
C82 sign nor 0
C83 VDD_3V3_0 nti 0
C84 VDD_3V3_0 in 0.00551f
C85 nor gf180mcu_fd_sc_mcu7t5v0__and2_1_0/Z 0.43324f
C86 a_209_n1970# a_n95_n2014# 0
C87 original res 0.00159f
C88 a_n1011_n1581# original 0.00331f
C89 gf180mcu_fd_sc_mcu7t5v0__and2_1_0/a_244_159# nti 0
C90 nor VDD_3V3_0 0.23236f
C91 nor gf180mcu_fd_sc_mcu7t5v0__nor2_1_0/a_224_472# 0.02636f
C92 inverter_pair_short_0/nti nti 0.00236f
C93 a_n667_n1970# original 0.0012f
C94 inverter_pair_short_0/nti in 0.17009f
C95 gf180mcu_fd_sc_mcu7t5v0__and2_1_0/a_244_159# nor 0
C96 gf180mcu_fd_sc_mcu7t5v0__and2_1_0/a_36_159# original 0.29576f
C97 a_n95_n2014# in 0.0051f
C98 a_n667_n1486# a_n563_n1613# 0.00144f
C99 nor inverter_pair_short_0/nti 0
C100 nti VDD_1V65 0
C101 nor a_n95_n2014# 0
C102 nor VDD_1V65 0.06647f
C103 sign a_n1011_n1581# 0
C104 in nti 0.45854f
C105 gf180mcu_fd_sc_mcu7t5v0__and2_1_0/Z a_n1011_n1581# 0.00228f
C106 over original 0
C107 nor nti 0.03752f
C108 nor in 0.00802f
C109 VDD_3V3_0 res 0.43643f
C110 VDD_3V3_0 a_n1011_n1581# 0.46689f
C111 gf180mcu_fd_sc_mcu7t5v0__and2_1_0/Z gf180mcu_fd_sc_mcu7t5v0__and2_1_0/a_36_159# 0.13951f
C112 a_209_n1430# a_n563_n1613# 0.00101f
C113 VDD_3V3_0 a_n667_n1970# 0.01995f
C114 VDD_3V3_1 original 0.69134f
C115 VDD_3V3_0 gf180mcu_fd_sc_mcu7t5v0__and2_1_0/a_36_159# 0.00285f
C116 original a_n563_n1613# 0.32843f
C117 a_n150_n1970# a_n563_n1613# 0.00556f
C118 inverter_pair_short_0/nti a_n1011_n1581# 0.00166f
C119 inverter_pair_short_0/nti res 0
C120 a_n95_n2014# a_n1011_n1581# 0
C121 gf180mcu_fd_sc_mcu7t5v0__and2_1_0/a_244_159# gf180mcu_fd_sc_mcu7t5v0__and2_1_0/a_36_159# 0.00424f
C122 nor a_n183_n1430# 0
C123 sign VSS 0.46225f
C124 res VSS 0.07206f
C125 VDD_1V65 VSS 0.19002f
C126 a_n667_n1970# VSS 0.00314f ; **FLOATING
C127 a_209_n1430# VSS 0.00302f ; **FLOATING
C128 a_n183_n1430# VSS 0 ; **FLOATING
C129 a_n95_n2014# VSS 0.482f ; **FLOATING
C130 a_n667_n1486# VSS 0.01206f ; **FLOATING
C131 a_n563_n1613# VSS 0.47721f ; **FLOATING
C132 inverter_pair_short_0/nti VSS 0.76233f
C133 in VSS 0.96759f
C134 gf180mcu_fd_sc_mcu7t5v0__and2_1_0/a_244_159# VSS 0.00145f ; **FLOATING
C135 gf180mcu_fd_sc_mcu7t5v0__and2_1_0/a_36_159# VSS 0.40188f ; **FLOATING
C136 gf180mcu_fd_sc_mcu7t5v0__and2_1_0/Z VSS 0.38119f
C137 over VSS 0.2603f
C138 gf180mcu_fd_sc_mcu7t5v0__nor2_1_0/a_224_472# VSS 0 ; **FLOATING
C139 original VSS 1.08516f
C140 VDD_3V3_1 VSS 5.44991f
C141 a_n1011_n1581# VSS 0.48788f ; **FLOATING
C142 nor VSS 1.10914f
C143 VDD_3V3_0 VSS 4.77196f
C144 nti VSS 0.2478f
