* NGSPICE file created from 5v0_mult_1t.ext - technology: gf180mcuD

.option scale=5n

X0 inv in VSS VSS nfet_06v0 ad=6.336n pd=0.32m as=6.478n ps=0.255m w=72 l=578
X1 VDD_3V3_1 in inv VDD_3V3_1 pfet_06v0 ad=12.81n pd=0.349m as=12.688n ps=0.348m w=244 l=100
X2 VDD_3V3_1 in inverter_pair_short_0/nti VDD_3V3_1 pfet_06v0 ad=13.616n pd=0.392m as=9.696n ps=0.394m w=96 l=150
X3 VSS in inverter_pair_short_0/nti VSS nfet_06v0 ad=6.478n pd=0.255m as=12.7n ps=0.454m w=127 l=120
X4 inv in VDD_3V3_1 VDD_3V3_1 pfet_06v0 ad=12.688n pd=0.348m as=13.616n ps=0.392m w=244 l=100
X5 inv in VDD_3V3_1 VDD_3V3_1 pfet_06v0 ad=27.328n pd=0.712m as=12.81n ps=0.349m w=244 l=100
X6 gf180mcu_fd_sc_mcu7t5v0__nor3_1_0/ZN over gf180mcu_fd_sc_mcu7t5v0__nor3_1_0/a_448_472# VDD_3V3_1 pfet_06v0 ad=21.472n pd=0.664m as=15.128n ps=0.368m w=244 l=100
X7 gf180mcu_fd_sc_mcu7t5v0__nor3_1_0/ZN over VSS VSS nfet_06v0 ad=8.184n pd=0.362m as=4.836n ps=0.197m w=93 l=120
X8 gf180mcu_fd_sc_mcu7t5v0__nor3_1_0/a_244_472# inverter_pair_short_0/nti VDD_3V3_1 VDD_3V3_1 pfet_06v0 ad=12.688n pd=0.348m as=21.472n ps=0.664m w=244 l=100
X9 gf180mcu_fd_sc_mcu7t5v0__nor3_1_0/a_448_472# inv gf180mcu_fd_sc_mcu7t5v0__nor3_1_0/a_244_472# VDD_3V3_1 pfet_06v0 ad=15.128n pd=0.368m as=12.688n ps=0.348m w=244 l=100
X10 VSS inv gf180mcu_fd_sc_mcu7t5v0__nor3_1_0/ZN VSS nfet_06v0 ad=4.836n pd=0.197m as=4.836n ps=0.197m w=93 l=120
X11 gf180mcu_fd_sc_mcu7t5v0__nor3_1_0/ZN inverter_pair_short_0/nti VSS VSS nfet_06v0 ad=4.836n pd=0.197m as=8.184n ps=0.362m w=93 l=120
X12 mux_mutliplier_custom_0/a_896_593# sign mux_mutliplier_custom_0/a_124_24# VDD_3V3_0 pfet_06v0 ad=2.952n pd=0.171m as=6.396n ps=0.227m w=123 l=100
X13 VSS mux_mutliplier_custom_0/a_124_24# tg_component_0/a_244_68# VSS nfet_06v0 ad=8.72n pd=0.304m as=14.432n ps=0.504m w=164 l=120
X14 mux_mutliplier_custom_0/a_124_24# sign mux_mutliplier_custom_0/a_504_104# VSS nfet_06v0 ad=3.744n pd=0.176m as=1.728n ps=0.12m w=72 l=120
X15 VDD_3V3_0 mux_mutliplier_custom_0/a_124_24# tg_component_0/a_244_472# VDD_3V3_0 pfet_06v0 ad=17.193n pd=0.437m as=21.472n ps=0.664m w=244 l=100
X16 VDD_3V3_0 inv mux_mutliplier_custom_0/a_896_593# VDD_3V3_0 pfet_06v0 ad=6.396n pd=0.227m as=2.952n ps=0.171m w=123 l=100
X17 mux_mutliplier_custom_0/a_592_407# sign VSS VSS nfet_06v0 ad=6.336n pd=0.32m as=3.744n ps=0.176m w=72 l=120
X18 mux_mutliplier_custom_0/a_504_104# original VSS VSS nfet_06v0 ad=1.728n pd=0.12m as=8.72n ps=0.304m w=72 l=120
X19 mux_mutliplier_custom_0/a_592_407# sign VDD_3V3_0 VDD_3V3_0 pfet_06v0 ad=10.824n pd=0.422m as=6.396n ps=0.227m w=123 l=100
X20 mux_mutliplier_custom_0/a_537_593# original VDD_3V3_0 VDD_3V3_0 pfet_06v0 ad=3.382n pd=0.178m as=17.193n ps=0.437m w=123 l=100
X21 VSS inv mux_mutliplier_custom_0/a_896_104# VSS nfet_06v0 ad=3.744n pd=0.176m as=1.728n ps=0.12m w=72 l=120
X22 mux_mutliplier_custom_0/a_896_104# mux_mutliplier_custom_0/a_592_407# mux_mutliplier_custom_0/a_124_24# VSS nfet_06v0 ad=1.728n pd=0.12m as=3.744n ps=0.176m w=72 l=120
X23 mux_mutliplier_custom_0/a_124_24# mux_mutliplier_custom_0/a_592_407# mux_mutliplier_custom_0/a_537_593# VDD_3V3_0 pfet_06v0 ad=6.396n pd=0.227m as=3.382n ps=0.178m w=123 l=100
X24 m2_n772_n1518# gf180mcu_fd_sc_mcu7t5v0__nor3_1_0/ZN VSS VSS nfet_06v0 ad=14.432n pd=0.504m as=14.432n ps=0.504m w=164 l=120
X25 m2_n772_n1518# gf180mcu_fd_sc_mcu7t5v0__nor3_1_0/ZN VDD_3V3_0 VDD_3V3_0 pfet_06v0 ad=21.472n pd=0.664m as=21.472n ps=0.664m w=244 l=100
X26 original inv VSS VSS nfet_06v0 ad=14.432n pd=0.504m as=84.604n ps=3.234m w=164 l=120
X27 original inv VDD_3V3_1 VDD_3V3_1 pfet_06v0 ad=21.472n pd=0.664m as=95.796n ps=2.81m w=244 l=100
X28 tg_component_0/a_244_68# m2_n772_n1518# res VSS nfet_06v0 ad=14.432n pd=0.504m as=14.432n ps=0.504m w=164 l=120
X29 res m2_n772_n1518# VDD_1V65 VSS nfet_06v0 ad=14.432n pd=0.504m as=14.432n ps=0.504m w=164 l=120
C0 original inv 0.42404f
C1 over inv 0.08043f
C2 in VDD_3V3_0 0.0042f
C3 mux_mutliplier_custom_0/a_592_407# in 0.00591f
C4 tg_component_0/a_244_472# inv 0
C5 original gf180mcu_fd_sc_mcu7t5v0__nor3_1_0/a_244_472# 0
C6 inverter_pair_short_0/nti VDD_3V3_0 0
C7 sign in 0.00584f
C8 tg_component_0/a_244_68# inv 0.00111f
C9 res in 0
C10 VDD_1V65 VDD_3V3_0 0.00169f
C11 VDD_1V65 mux_mutliplier_custom_0/a_592_407# 0
C12 inverter_pair_short_0/nti res 0
C13 original gf180mcu_fd_sc_mcu7t5v0__nor3_1_0/a_448_472# 0
C14 gf180mcu_fd_sc_mcu7t5v0__nor3_1_0/a_448_472# over 0.01262f
C15 VDD_1V65 sign 0
C16 VDD_1V65 res 0.02271f
C17 in gf180mcu_fd_sc_mcu7t5v0__nor3_1_0/ZN 0.00434f
C18 inverter_pair_short_0/nti gf180mcu_fd_sc_mcu7t5v0__nor3_1_0/ZN 0.03626f
C19 VDD_3V3_0 m2_n772_n1518# 0.16765f
C20 VDD_3V3_1 in 0.87292f
C21 VDD_1V65 mux_mutliplier_custom_0/a_504_104# 0
C22 VDD_1V65 gf180mcu_fd_sc_mcu7t5v0__nor3_1_0/ZN 0.1364f
C23 mux_mutliplier_custom_0/a_124_24# VDD_3V3_0 0.48649f
C24 inverter_pair_short_0/nti VDD_3V3_1 0.3952f
C25 mux_mutliplier_custom_0/a_592_407# mux_mutliplier_custom_0/a_124_24# 0.02837f
C26 res m2_n772_n1518# 0.25018f
C27 mux_mutliplier_custom_0/a_592_407# mux_mutliplier_custom_0/a_896_104# 0.00166f
C28 sign mux_mutliplier_custom_0/a_124_24# 0.12833f
C29 VDD_1V65 VDD_3V3_1 0.00284f
C30 res mux_mutliplier_custom_0/a_124_24# 0.04019f
C31 original VDD_3V3_0 0.23272f
C32 over VDD_3V3_0 0.00126f
C33 inv gf180mcu_fd_sc_mcu7t5v0__nor3_1_0/a_244_472# 0.00719f
C34 original mux_mutliplier_custom_0/a_592_407# 0.07191f
C35 m2_n772_n1518# gf180mcu_fd_sc_mcu7t5v0__nor3_1_0/ZN 0.33692f
C36 sign original 0.2236f
C37 tg_component_0/a_244_472# VDD_3V3_0 0.00384f
C38 original res 0.00354f
C39 mux_mutliplier_custom_0/a_504_104# mux_mutliplier_custom_0/a_124_24# 0.00317f
C40 mux_mutliplier_custom_0/a_124_24# gf180mcu_fd_sc_mcu7t5v0__nor3_1_0/ZN 0.02079f
C41 VDD_3V3_1 m2_n772_n1518# 0.00552f
C42 gf180mcu_fd_sc_mcu7t5v0__nor3_1_0/a_448_472# inv 0.01525f
C43 tg_component_0/a_244_472# res 0.02381f
C44 VDD_3V3_1 mux_mutliplier_custom_0/a_124_24# 0.0014f
C45 original mux_mutliplier_custom_0/a_504_104# 0
C46 tg_component_0/a_244_68# res 0.00643f
C47 original gf180mcu_fd_sc_mcu7t5v0__nor3_1_0/ZN 0.00241f
C48 over gf180mcu_fd_sc_mcu7t5v0__nor3_1_0/ZN 0.29122f
C49 mux_mutliplier_custom_0/a_537_593# VDD_3V3_0 0.00245f
C50 mux_mutliplier_custom_0/a_592_407# mux_mutliplier_custom_0/a_537_593# 0
C51 sign mux_mutliplier_custom_0/a_537_593# 0
C52 original VDD_3V3_1 0.16237f
C53 VDD_3V3_1 over 0.18631f
C54 tg_component_0/a_244_68# gf180mcu_fd_sc_mcu7t5v0__nor3_1_0/ZN 0
C55 inverter_pair_short_0/nti in 0.17102f
C56 VDD_3V3_0 mux_mutliplier_custom_0/a_896_593# 0.005f
C57 mux_mutliplier_custom_0/a_592_407# mux_mutliplier_custom_0/a_896_593# 0
C58 VDD_3V3_0 inv 0.22224f
C59 sign mux_mutliplier_custom_0/a_896_593# 0.00276f
C60 mux_mutliplier_custom_0/a_592_407# inv 0.30304f
C61 VDD_1V65 inverter_pair_short_0/nti 0.0029f
C62 sign inv 0.36108f
C63 res inv 0.00215f
C64 inverter_pair_short_0/nti m2_n772_n1518# 0.0174f
C65 mux_mutliplier_custom_0/a_504_104# inv 0
C66 inv gf180mcu_fd_sc_mcu7t5v0__nor3_1_0/ZN 0.08019f
C67 mux_mutliplier_custom_0/a_124_24# in 0.00624f
C68 VDD_1V65 m2_n772_n1518# 0.15921f
C69 gf180mcu_fd_sc_mcu7t5v0__nor3_1_0/a_244_472# gf180mcu_fd_sc_mcu7t5v0__nor3_1_0/ZN 0.0018f
C70 VDD_3V3_1 inv 0.93779f
C71 original in 0.05905f
C72 over in 0
C73 VDD_1V65 mux_mutliplier_custom_0/a_124_24# 0.0025f
C74 VDD_1V65 mux_mutliplier_custom_0/a_896_104# 0
C75 original inverter_pair_short_0/nti 0.00314f
C76 inverter_pair_short_0/nti over 0
C77 VDD_3V3_1 gf180mcu_fd_sc_mcu7t5v0__nor3_1_0/a_244_472# 0.00689f
C78 gf180mcu_fd_sc_mcu7t5v0__nor3_1_0/a_448_472# gf180mcu_fd_sc_mcu7t5v0__nor3_1_0/ZN 0.00621f
C79 VDD_1V65 original 0.00446f
C80 VDD_1V65 over 0.00253f
C81 mux_mutliplier_custom_0/a_124_24# m2_n772_n1518# 0.02775f
C82 mux_mutliplier_custom_0/a_592_407# VDD_3V3_0 0.35858f
C83 gf180mcu_fd_sc_mcu7t5v0__nor3_1_0/a_448_472# VDD_3V3_1 0.01448f
C84 VDD_1V65 tg_component_0/a_244_68# 0.0015f
C85 sign VDD_3V3_0 0.4897f
C86 sign mux_mutliplier_custom_0/a_592_407# 0.22431f
C87 res VDD_3V3_0 0.5796f
C88 original m2_n772_n1518# 0.00797f
C89 over m2_n772_n1518# 0.00178f
C90 mux_mutliplier_custom_0/a_896_104# mux_mutliplier_custom_0/a_124_24# 0.00101f
C91 original mux_mutliplier_custom_0/a_124_24# 0.32284f
C92 original mux_mutliplier_custom_0/a_896_104# 0.00142f
C93 VDD_3V3_0 gf180mcu_fd_sc_mcu7t5v0__nor3_1_0/ZN 0.38474f
C94 mux_mutliplier_custom_0/a_592_407# gf180mcu_fd_sc_mcu7t5v0__nor3_1_0/ZN 0
C95 tg_component_0/a_244_472# mux_mutliplier_custom_0/a_124_24# 0
C96 in inv 0.53128f
C97 sign gf180mcu_fd_sc_mcu7t5v0__nor3_1_0/ZN 0
C98 tg_component_0/a_244_68# mux_mutliplier_custom_0/a_124_24# 0.00127f
C99 inverter_pair_short_0/nti inv 0.31888f
C100 res gf180mcu_fd_sc_mcu7t5v0__nor3_1_0/ZN 0.19544f
C101 VDD_3V3_1 VDD_3V3_0 0
C102 mux_mutliplier_custom_0/a_592_407# VDD_3V3_1 0
C103 VDD_1V65 inv 0.01479f
C104 sign VDD_3V3_1 0.00107f
C105 inverter_pair_short_0/nti gf180mcu_fd_sc_mcu7t5v0__nor3_1_0/a_244_472# 0.01909f
C106 tg_component_0/a_244_68# original 0.00146f
C107 mux_mutliplier_custom_0/a_124_24# mux_mutliplier_custom_0/a_537_593# 0.00556f
C108 mux_mutliplier_custom_0/a_504_104# gf180mcu_fd_sc_mcu7t5v0__nor3_1_0/ZN 0
C109 VDD_1V65 gf180mcu_fd_sc_mcu7t5v0__nor3_1_0/a_244_472# 0
C110 original mux_mutliplier_custom_0/a_537_593# 0
C111 VDD_3V3_1 gf180mcu_fd_sc_mcu7t5v0__nor3_1_0/ZN 0.11983f
C112 inv m2_n772_n1518# 0.01297f
C113 mux_mutliplier_custom_0/a_124_24# mux_mutliplier_custom_0/a_896_593# 0.00106f
C114 VDD_1V65 gf180mcu_fd_sc_mcu7t5v0__nor3_1_0/a_448_472# 0.00239f
C115 mux_mutliplier_custom_0/a_124_24# inv 0.01004f
C116 original mux_mutliplier_custom_0/a_896_593# 0
C117 res VSS 0.06671f
C118 VDD_1V65 VSS 0.19819f
C119 m2_n772_n1518# VSS 0.52122f ; **FLOATING
C120 tg_component_0/a_244_68# VSS 0.01042f ; **FLOATING
C121 tg_component_0/a_244_472# VSS 0 ; **FLOATING
C122 original VSS 0.70861f
C123 sign VSS 0.44493f
C124 VDD_3V3_0 VSS 4.50165f
C125 mux_mutliplier_custom_0/a_896_104# VSS 0.00302f ; **FLOATING
C126 mux_mutliplier_custom_0/a_504_104# VSS 0 ; **FLOATING
C127 mux_mutliplier_custom_0/a_592_407# VSS 0.49094f ; **FLOATING
C128 mux_mutliplier_custom_0/a_124_24# VSS 0.53899f ; **FLOATING
C129 gf180mcu_fd_sc_mcu7t5v0__nor3_1_0/ZN VSS 0.86574f
C130 over VSS 0.215f
C131 inv VSS 1.16325f
C132 inverter_pair_short_0/nti VSS 0.32961f
C133 VDD_3V3_1 VSS 4.42258f
C134 in VSS 0.9643f
