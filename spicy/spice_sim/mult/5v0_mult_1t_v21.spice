* NGSPICE file created from 5v0_mult_1t.ext - technology: gf180mcuD

.option scale=5n

X0 nti in VSS VSS nfet_06v0 ad=6.336n pd=0.32m as=6.478n ps=0.255m w=72 l=578
X1 VDD_3V3_1 in nti VDD_3V3_1 pfet_06v0 ad=12.81n pd=0.349m as=12.688n ps=0.348m w=244 l=100
X2 VDD_3V3_1 in inv VDD_3V3_1 pfet_06v0 ad=13.616n pd=0.392m as=9.696n ps=0.394m w=96 l=150
X3 VSS in inv VSS nfet_06v0 ad=6.478n pd=0.255m as=12.7n ps=0.454m w=127 l=120
X4 nti in VDD_3V3_1 VDD_3V3_1 pfet_06v0 ad=12.688n pd=0.348m as=13.616n ps=0.392m w=244 l=100
X5 nti in VDD_3V3_1 VDD_3V3_1 pfet_06v0 ad=27.328n pd=0.712m as=12.81n ps=0.349m w=244 l=100
X6 mux_mutliplier_custom_0/a_896_593# sign mux_mutliplier_custom_0/a_124_24# VDD_3V3_0 pfet_06v0 ad=2.952n pd=0.171m as=6.396n ps=0.227m w=123 l=100
X7 VSS mux_mutliplier_custom_0/a_124_24# tg_component_0/a_244_68# VSS nfet_06v0 ad=8.72n pd=0.304m as=14.432n ps=0.504m w=164 l=120
X8 mux_mutliplier_custom_0/a_124_24# sign mux_mutliplier_custom_0/a_504_104# VSS nfet_06v0 ad=3.744n pd=0.176m as=1.728n ps=0.12m w=72 l=120
X9 VDD_3V3_0 mux_mutliplier_custom_0/a_124_24# tg_component_0/a_244_472# VDD_3V3_0 pfet_06v0 ad=17.193n pd=0.437m as=21.472n ps=0.664m w=244 l=100
X10 VDD_3V3_0 inv mux_mutliplier_custom_0/a_896_593# VDD_3V3_0 pfet_06v0 ad=6.396n pd=0.227m as=2.952n ps=0.171m w=123 l=100
X11 mux_mutliplier_custom_0/a_592_407# sign VSS VSS nfet_06v0 ad=6.336n pd=0.32m as=3.744n ps=0.176m w=72 l=120
X12 mux_mutliplier_custom_0/a_504_104# original VSS VSS nfet_06v0 ad=1.728n pd=0.12m as=8.72n ps=0.304m w=72 l=120
X13 mux_mutliplier_custom_0/a_592_407# sign VDD_3V3_0 VDD_3V3_0 pfet_06v0 ad=10.824n pd=0.422m as=6.396n ps=0.227m w=123 l=100
X14 mux_mutliplier_custom_0/a_537_593# original VDD_3V3_0 VDD_3V3_0 pfet_06v0 ad=3.382n pd=0.178m as=17.193n ps=0.437m w=123 l=100
X15 VSS inv mux_mutliplier_custom_0/a_896_104# VSS nfet_06v0 ad=3.744n pd=0.176m as=1.728n ps=0.12m w=72 l=120
X16 mux_mutliplier_custom_0/a_896_104# mux_mutliplier_custom_0/a_592_407# mux_mutliplier_custom_0/a_124_24# VSS nfet_06v0 ad=1.728n pd=0.12m as=3.744n ps=0.176m w=72 l=120
X17 mux_mutliplier_custom_0/a_124_24# mux_mutliplier_custom_0/a_592_407# mux_mutliplier_custom_0/a_537_593# VDD_3V3_0 pfet_06v0 ad=6.396n pd=0.227m as=3.382n ps=0.178m w=123 l=100
X18 a_n1011_n1581# nor VSS VSS nfet_06v0 ad=14.432n pd=0.504m as=14.432n ps=0.504m w=164 l=120
X19 a_n1011_n1581# nor VDD_3V3_0 VDD_3V3_0 pfet_06v0 ad=21.472n pd=0.664m as=21.472n ps=0.664m w=244 l=100
X20 original inv VSS VSS nfet_06v0 ad=14.432n pd=0.504m as=0.10536u ps=3.904m w=164 l=120
X21 original inv VDD_3V3_1 VDD_3V3_1 pfet_06v0 ad=21.472n pd=0.664m as=0.13882u ps=4.048m w=244 l=100
X22 tg_component_0/a_244_68# nor res VSS nfet_06v0 ad=14.432n pd=0.504m as=14.432n ps=0.504m w=164 l=120
X23 nor gf180mcu_fd_sc_mcu7t5v0__and2_1_0/Z gf180mcu_fd_sc_mcu7t5v0__nor2_1_0/a_224_472# VDD_3V3_1 pfet_06v0 ad=21.472n pd=0.664m as=16.348n ps=0.378m w=244 l=100
X24 VSS gf180mcu_fd_sc_mcu7t5v0__and2_1_0/Z nor VSS nfet_06v0 ad=9.944n pd=0.402m as=5.876n ps=0.217m w=113 l=120
X25 gf180mcu_fd_sc_mcu7t5v0__nor2_1_0/a_224_472# over VDD_3V3_1 VDD_3V3_1 pfet_06v0 ad=16.348n pd=0.378m as=21.472n ps=0.664m w=244 l=100
X26 nor over VSS VSS nfet_06v0 ad=5.876n pd=0.217m as=9.944n ps=0.402m w=113 l=120
X27 VDD_3V3_1 original gf180mcu_fd_sc_mcu7t5v0__and2_1_0/a_36_159# VDD_3V3_1 pfet_06v0 ad=16.23n pd=0.411m as=6.24n ps=0.224m w=120 l=100
X28 gf180mcu_fd_sc_mcu7t5v0__and2_1_0/Z gf180mcu_fd_sc_mcu7t5v0__and2_1_0/a_36_159# VDD_3V3_1 VDD_3V3_1 pfet_06v0 ad=21.384n pd=0.662m as=16.23n ps=0.411m w=243 l=100
X29 gf180mcu_fd_sc_mcu7t5v0__and2_1_0/Z gf180mcu_fd_sc_mcu7t5v0__and2_1_0/a_36_159# VSS VSS nfet_06v0 ad=14.344n pd=0.502m as=9.362n ps=0.311m w=163 l=120
X30 VSS original gf180mcu_fd_sc_mcu7t5v0__and2_1_0/a_244_159# VSS nfet_06v0 ad=9.362n pd=0.311m as=2.336n ps=0.137m w=73 l=120
X31 gf180mcu_fd_sc_mcu7t5v0__and2_1_0/a_244_159# nti gf180mcu_fd_sc_mcu7t5v0__and2_1_0/a_36_159# VSS nfet_06v0 ad=2.336n pd=0.137m as=6.424n ps=0.322m w=73 l=120
X32 gf180mcu_fd_sc_mcu7t5v0__and2_1_0/a_36_159# nti VDD_3V3_1 VDD_3V3_1 pfet_06v0 ad=6.24n pd=0.224m as=10.56n ps=0.416m w=120 l=100
X33 res a_n1011_n1581# VDD_1V65 VSS nfet_06v0 ad=14.432n pd=0.504m as=14.432n ps=0.504m w=164 l=120
C0 VDD_3V3_1 nti 0.57863f
C1 nor VDD_3V3_1 0.11021f
C2 inv res 0
C3 in VDD_3V3_1 0.87095f
C4 a_n1011_n1581# gf180mcu_fd_sc_mcu7t5v0__and2_1_0/a_36_159# 0
C5 mux_mutliplier_custom_0/a_592_407# mux_mutliplier_custom_0/a_896_104# 0.00166f
C6 a_n1011_n1581# nti 0.00378f
C7 nor a_n1011_n1581# 0.31216f
C8 gf180mcu_fd_sc_mcu7t5v0__and2_1_0/a_36_159# nti 0.26623f
C9 mux_mutliplier_custom_0/a_592_407# VDD_3V3_0 0.35858f
C10 nor gf180mcu_fd_sc_mcu7t5v0__and2_1_0/a_36_159# 0.05938f
C11 gf180mcu_fd_sc_mcu7t5v0__nor2_1_0/a_224_472# VDD_3V3_1 0.01452f
C12 original mux_mutliplier_custom_0/a_592_407# 0.07244f
C13 a_n1011_n1581# in 0
C14 gf180mcu_fd_sc_mcu7t5v0__and2_1_0/a_36_159# in 0.00106f
C15 nor nti 0.03752f
C16 mux_mutliplier_custom_0/a_537_593# VDD_3V3_0 0.00245f
C17 mux_mutliplier_custom_0/a_592_407# sign 0.2241f
C18 original mux_mutliplier_custom_0/a_537_593# 0
C19 in nti 0.45854f
C20 VDD_3V3_0 mux_mutliplier_custom_0/a_896_593# 0.005f
C21 gf180mcu_fd_sc_mcu7t5v0__and2_1_0/a_244_159# gf180mcu_fd_sc_mcu7t5v0__and2_1_0/a_36_159# 0.00424f
C22 nor in 0.00802f
C23 nor tg_component_0/a_244_68# 0.00271f
C24 original mux_mutliplier_custom_0/a_896_593# 0
C25 a_n1011_n1581# mux_mutliplier_custom_0/a_124_24# 0.02207f
C26 mux_mutliplier_custom_0/a_537_593# sign 0
C27 gf180mcu_fd_sc_mcu7t5v0__and2_1_0/a_244_159# nti 0
C28 inv mux_mutliplier_custom_0/a_592_407# 0.30421f
C29 nor gf180mcu_fd_sc_mcu7t5v0__and2_1_0/a_244_159# 0
C30 mux_mutliplier_custom_0/a_124_24# tg_component_0/a_244_472# 0.00218f
C31 sign mux_mutliplier_custom_0/a_896_593# 0.00276f
C32 over VDD_3V3_1 0.2741f
C33 gf180mcu_fd_sc_mcu7t5v0__and2_1_0/Z VDD_3V3_1 0.27507f
C34 nor mux_mutliplier_custom_0/a_124_24# 0.03409f
C35 nor gf180mcu_fd_sc_mcu7t5v0__nor2_1_0/a_224_472# 0.02636f
C36 mux_mutliplier_custom_0/a_124_24# in 0.00801f
C37 mux_mutliplier_custom_0/a_124_24# tg_component_0/a_244_68# 0.00125f
C38 original mux_mutliplier_custom_0/a_504_104# 0
C39 a_n1011_n1581# gf180mcu_fd_sc_mcu7t5v0__and2_1_0/Z 0.00228f
C40 a_n1011_n1581# res 0.29914f
C41 gf180mcu_fd_sc_mcu7t5v0__and2_1_0/Z gf180mcu_fd_sc_mcu7t5v0__and2_1_0/a_36_159# 0.13951f
C42 original mux_mutliplier_custom_0/a_896_104# 0.00154f
C43 a_n1011_n1581# VDD_1V65 0.12271f
C44 res tg_component_0/a_244_472# 0.00868f
C45 VDD_1V65 gf180mcu_fd_sc_mcu7t5v0__and2_1_0/a_36_159# 0
C46 over nti 0
C47 gf180mcu_fd_sc_mcu7t5v0__and2_1_0/Z nti 0
C48 nor over 0.20682f
C49 res nti 0
C50 nor gf180mcu_fd_sc_mcu7t5v0__and2_1_0/Z 0.43324f
C51 nor res 0.07706f
C52 original VDD_3V3_0 0.2382f
C53 VDD_1V65 nti 0
C54 gf180mcu_fd_sc_mcu7t5v0__and2_1_0/Z in 0
C55 nor VDD_1V65 0.06647f
C56 res tg_component_0/a_244_68# 0.00367f
C57 mux_mutliplier_custom_0/a_592_407# VDD_3V3_1 0.00138f
C58 sign VDD_3V3_0 0.48978f
C59 VDD_1V65 tg_component_0/a_244_68# 0
C60 original sign 0.22381f
C61 gf180mcu_fd_sc_mcu7t5v0__and2_1_0/Z gf180mcu_fd_sc_mcu7t5v0__and2_1_0/a_244_159# 0
C62 gf180mcu_fd_sc_mcu7t5v0__nor2_1_0/a_224_472# over 0.00898f
C63 mux_mutliplier_custom_0/a_124_24# res 0.02135f
C64 inv VDD_3V3_0 0.2156f
C65 inv original 0.44048f
C66 VDD_1V65 mux_mutliplier_custom_0/a_124_24# 0
C67 a_n1011_n1581# mux_mutliplier_custom_0/a_592_407# 0
C68 inv sign 0.36193f
C69 nor mux_mutliplier_custom_0/a_592_407# 0
C70 mux_mutliplier_custom_0/a_592_407# in 0.00607f
C71 gf180mcu_fd_sc_mcu7t5v0__and2_1_0/Z over 0.02124f
C72 VDD_1V65 res 0.02972f
C73 mux_mutliplier_custom_0/a_592_407# mux_mutliplier_custom_0/a_124_24# 0.02837f
C74 original VDD_3V3_1 0.69134f
C75 mux_mutliplier_custom_0/a_124_24# mux_mutliplier_custom_0/a_537_593# 0.00556f
C76 mux_mutliplier_custom_0/a_124_24# mux_mutliplier_custom_0/a_896_593# 0.00106f
C77 sign VDD_3V3_1 0.00281f
C78 nor mux_mutliplier_custom_0/a_504_104# 0
C79 a_n1011_n1581# VDD_3V3_0 0.46282f
C80 gf180mcu_fd_sc_mcu7t5v0__and2_1_0/a_36_159# VDD_3V3_0 0.00285f
C81 a_n1011_n1581# original 0.00339f
C82 nor mux_mutliplier_custom_0/a_896_104# 0
C83 original gf180mcu_fd_sc_mcu7t5v0__and2_1_0/a_36_159# 0.29576f
C84 tg_component_0/a_244_472# VDD_3V3_0 0.01755f
C85 inv VDD_3V3_1 0.33286f
C86 original tg_component_0/a_244_472# 0.00105f
C87 VDD_3V3_0 nti 0
C88 a_n1011_n1581# sign 0
C89 nor VDD_3V3_0 0.22128f
C90 original nti 0.16888f
C91 nor original 0.06016f
C92 VDD_3V3_0 in 0.00514f
C93 mux_mutliplier_custom_0/a_124_24# mux_mutliplier_custom_0/a_504_104# 0.00317f
C94 tg_component_0/a_244_68# VDD_3V3_0 0.0013f
C95 original in 0.16694f
C96 original tg_component_0/a_244_68# 0.00259f
C97 inv a_n1011_n1581# 0.00169f
C98 nor sign 0
C99 mux_mutliplier_custom_0/a_124_24# mux_mutliplier_custom_0/a_896_104# 0.00101f
C100 sign in 0.00312f
C101 original gf180mcu_fd_sc_mcu7t5v0__and2_1_0/a_244_159# 0
C102 inv nti 0.00236f
C103 mux_mutliplier_custom_0/a_124_24# VDD_3V3_0 0.49201f
C104 inv nor 0
C105 original mux_mutliplier_custom_0/a_124_24# 0.32842f
C106 original gf180mcu_fd_sc_mcu7t5v0__nor2_1_0/a_224_472# 0
C107 inv in 0.17009f
C108 mux_mutliplier_custom_0/a_124_24# sign 0.12833f
C109 mux_mutliplier_custom_0/a_592_407# mux_mutliplier_custom_0/a_537_593# 0
C110 mux_mutliplier_custom_0/a_592_407# mux_mutliplier_custom_0/a_896_593# 0
C111 inv mux_mutliplier_custom_0/a_124_24# 0.00504f
C112 over VDD_3V3_0 0.00261f
C113 gf180mcu_fd_sc_mcu7t5v0__and2_1_0/Z VDD_3V3_0 0.00161f
C114 res VDD_3V3_0 0.43686f
C115 original over 0
C116 original gf180mcu_fd_sc_mcu7t5v0__and2_1_0/Z 0.01481f
C117 original res 0.00164f
C118 VDD_1V65 VDD_3V3_0 0.01106f
C119 VDD_1V65 original 0.00121f
C120 a_n1011_n1581# VDD_3V3_1 0.00102f
C121 gf180mcu_fd_sc_mcu7t5v0__and2_1_0/a_36_159# VDD_3V3_1 0.25656f
C122 res VSS 0.06311f
C123 VDD_1V65 VSS 0.19213f
C124 gf180mcu_fd_sc_mcu7t5v0__and2_1_0/a_244_159# VSS 0.00145f ; **FLOATING
C125 gf180mcu_fd_sc_mcu7t5v0__and2_1_0/a_36_159# VSS 0.40188f ; **FLOATING
C126 gf180mcu_fd_sc_mcu7t5v0__and2_1_0/Z VSS 0.38119f
C127 over VSS 0.2603f
C128 gf180mcu_fd_sc_mcu7t5v0__nor2_1_0/a_224_472# VSS 0 ; **FLOATING
C129 tg_component_0/a_244_68# VSS 0.0103f ; **FLOATING
C130 nor VSS 1.11819f
C131 tg_component_0/a_244_472# VSS 0.00273f ; **FLOATING
C132 a_n1011_n1581# VSS 0.4901f ; **FLOATING
C133 VDD_3V3_1 VSS 5.45127f
C134 inv VSS 0.75935f
C135 sign VSS 0.45152f
C136 original VSS 1.08905f
C137 VDD_3V3_0 VSS 5.18125f
C138 mux_mutliplier_custom_0/a_896_104# VSS 0.00302f ; **FLOATING
C139 mux_mutliplier_custom_0/a_504_104# VSS 0 ; **FLOATING
C140 mux_mutliplier_custom_0/a_592_407# VSS 0.49099f ; **FLOATING
C141 mux_mutliplier_custom_0/a_124_24# VSS 0.5382f ; **FLOATING
C142 nti VSS 0.2478f
C143 in VSS 0.96461f
