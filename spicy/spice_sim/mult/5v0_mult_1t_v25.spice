* NGSPICE file created from 5v0_mult_1t_b.ext - technology: gf180mcuD

.option scale=5n

X0 nti in VSS VSS nfet_06v0 ad=6.336n pd=0.32m as=6.478n ps=0.255m w=72 l=578
X1 VDD_3V3_1 in nti VDD_3V3_1 pfet_06v0 ad=12.81n pd=0.349m as=12.688n ps=0.348m w=244 l=100
X2 VDD_3V3_1 in I0 VDD_3V3_1 pfet_06v0 ad=13.616n pd=0.392m as=9.696n ps=0.394m w=96 l=150
X3 VSS in I0 VSS nfet_06v0 ad=6.478n pd=0.255m as=12.7n ps=0.454m w=127 l=120
X4 nti in VDD_3V3_1 VDD_3V3_1 pfet_06v0 ad=12.688n pd=0.348m as=13.616n ps=0.392m w=244 l=100
X5 nti in VDD_3V3_1 VDD_3V3_1 pfet_06v0 ad=27.328n pd=0.712m as=12.81n ps=0.349m w=244 l=100
X6 a_n1011_n1581# nor VSS VSS nfet_06v0 ad=14.432n pd=0.504m as=14.432n ps=0.504m w=164 l=120
X7 a_n1011_n1581# nor VNW VNW pfet_06v0 ad=21.472n pd=0.664m as=21.472n ps=0.664m w=244 l=100
X8 I1 I0 VSS VSS nfet_06v0 ad=14.432n pd=0.504m as=0.10536u ps=3.904m w=164 l=120
X9 I1 I0 VDD_3V3_1 VDD_3V3_1 pfet_06v0 ad=21.472n pd=0.664m as=0.13882u ps=4.048m w=244 l=100
X10 nor gf180mcu_fd_sc_mcu7t5v0__and2_1_0/Z gf180mcu_fd_sc_mcu7t5v0__nor2_1_0/a_224_472# VDD_3V3_1 pfet_06v0 ad=21.472n pd=0.664m as=16.348n ps=0.378m w=244 l=100
X11 VSS gf180mcu_fd_sc_mcu7t5v0__and2_1_0/Z nor VSS nfet_06v0 ad=9.944n pd=0.402m as=5.876n ps=0.217m w=113 l=120
X12 gf180mcu_fd_sc_mcu7t5v0__nor2_1_0/a_224_472# over VDD_3V3_1 VDD_3V3_1 pfet_06v0 ad=16.348n pd=0.378m as=21.472n ps=0.664m w=244 l=100
X13 nor over VSS VSS nfet_06v0 ad=5.876n pd=0.217m as=9.944n ps=0.402m w=113 l=120
X14 VDD_3V3_1 I1 gf180mcu_fd_sc_mcu7t5v0__and2_1_0/a_36_159# VDD_3V3_1 pfet_06v0 ad=16.23n pd=0.411m as=6.24n ps=0.224m w=120 l=100
X15 gf180mcu_fd_sc_mcu7t5v0__and2_1_0/Z gf180mcu_fd_sc_mcu7t5v0__and2_1_0/a_36_159# VDD_3V3_1 VDD_3V3_1 pfet_06v0 ad=21.384n pd=0.662m as=16.23n ps=0.411m w=243 l=100
X16 gf180mcu_fd_sc_mcu7t5v0__and2_1_0/Z gf180mcu_fd_sc_mcu7t5v0__and2_1_0/a_36_159# VSS VSS nfet_06v0 ad=14.344n pd=0.502m as=9.362n ps=0.311m w=163 l=120
X17 VSS I1 gf180mcu_fd_sc_mcu7t5v0__and2_1_0/a_244_159# VSS nfet_06v0 ad=9.362n pd=0.311m as=2.336n ps=0.137m w=73 l=120
X18 gf180mcu_fd_sc_mcu7t5v0__and2_1_0/a_244_159# nti gf180mcu_fd_sc_mcu7t5v0__and2_1_0/a_36_159# VSS nfet_06v0 ad=2.336n pd=0.137m as=6.424n ps=0.322m w=73 l=120
X19 gf180mcu_fd_sc_mcu7t5v0__and2_1_0/a_36_159# nti VDD_3V3_1 VDD_3V3_1 pfet_06v0 ad=6.24n pd=0.224m as=10.56n ps=0.416m w=120 l=100
X20 In a_n1011_n1581# VDD_1V65 VSS nfet_06v0 ad=8.528n pd=0.268m as=14.432n ps=0.504m w=164 l=120
X21 a_209_n1430# a_n95_n2014# a_n563_n1613# VSS nfet_06v0 ad=1.728n pd=0.12m as=3.744n ps=0.176m w=72 l=120
X22 VNW I0 a_209_n1970# VNW pfet_06v0 ad=6.396n pd=0.227m as=2.952n ps=0.171m w=123 l=100
X23 a_n563_n1613# S a_n183_n1430# VSS nfet_06v0 ad=3.744n pd=0.176m as=1.728n ps=0.12m w=72 l=120
X24 a_n183_n1430# I1 VSS VSS nfet_06v0 ad=1.728n pd=0.12m as=8.72n ps=0.304m w=72 l=120
X25 a_n563_n1613# a_n95_n2014# a_n150_n1970# VNW pfet_06v0 ad=6.396n pd=0.227m as=3.382n ps=0.178m w=123 l=100
X26 a_n95_n2014# S VNW VNW pfet_06v0 ad=10.824n pd=0.422m as=6.396n ps=0.227m w=123 l=100
X27 VNW a_n563_n1613# Z VNW pfet_06v0 ad=17.193n pd=0.437m as=15.128n ps=0.368m w=244 l=100
X28 VSS a_n563_n1613# Z VSS nfet_06v0 ad=8.72n pd=0.304m as=8.528n ps=0.268m w=164 l=120
X29 Z a_n1011_n1581# In VNW pfet_06v0 ad=15.128n pd=0.368m as=21.472n ps=0.664m w=244 l=100
X30 a_n95_n2014# S VSS VSS nfet_06v0 ad=6.336n pd=0.32m as=3.744n ps=0.176m w=72 l=120
X31 a_n150_n1970# I1 VNW VNW pfet_06v0 ad=3.382n pd=0.178m as=17.193n ps=0.437m w=123 l=100
X32 Z nor In VSS nfet_06v0 ad=8.528n pd=0.268m as=8.528n ps=0.268m w=164 l=120
X33 a_209_n1970# S a_n563_n1613# VNW pfet_06v0 ad=2.952n pd=0.171m as=6.396n ps=0.227m w=123 l=100
X34 VSS I0 a_209_n1430# VSS nfet_06v0 ad=3.744n pd=0.176m as=1.728n ps=0.12m w=72 l=120
C0 a_n563_n1613# I0 0.00505f
C1 in gf180mcu_fd_sc_mcu7t5v0__and2_1_0/a_36_159# 0.00106f
C2 a_n150_n1970# a_n95_n2014# 0
C3 nor VNW 0.23236f
C4 VDD_3V3_1 I0 0.33293f
C5 VDD_3V3_1 over 0.2741f
C6 nor gf180mcu_fd_sc_mcu7t5v0__and2_1_0/a_244_159# 0
C7 nti VNW 0
C8 nor a_n563_n1613# 0.01819f
C9 I0 a_n95_n2014# 0.30177f
C10 VNW I1 0.23744f
C11 I0 Z 0
C12 nor VDD_3V3_1 0.11021f
C13 nti gf180mcu_fd_sc_mcu7t5v0__and2_1_0/a_244_159# 0
C14 gf180mcu_fd_sc_mcu7t5v0__and2_1_0/a_244_159# I1 0
C15 VNW In 0.42683f
C16 I1 a_n563_n1613# 0.32843f
C17 gf180mcu_fd_sc_mcu7t5v0__and2_1_0/a_36_159# VDD_1V65 0
C18 gf180mcu_fd_sc_mcu7t5v0__and2_1_0/a_36_159# a_n1011_n1581# 0
C19 nti VDD_3V3_1 0.57863f
C20 nor a_n95_n2014# 0
C21 nor Z 0.06956f
C22 VDD_3V3_1 I1 0.69134f
C23 I1 a_209_n1970# 0
C24 VDD_3V3_1 gf180mcu_fd_sc_mcu7t5v0__nor2_1_0/a_224_472# 0.01452f
C25 a_n563_n1613# In 0.00134f
C26 in a_n1011_n1581# 0
C27 VNW gf180mcu_fd_sc_mcu7t5v0__and2_1_0/Z 0.00161f
C28 I1 a_n95_n2014# 0.07104f
C29 I1 Z 0.00644f
C30 gf180mcu_fd_sc_mcu7t5v0__and2_1_0/Z gf180mcu_fd_sc_mcu7t5v0__and2_1_0/a_244_159# 0
C31 nor I0 0
C32 I1 a_n150_n1970# 0
C33 in S 0.0025f
C34 nor over 0.20682f
C35 In Z 0.0589f
C36 VDD_3V3_1 gf180mcu_fd_sc_mcu7t5v0__and2_1_0/Z 0.27507f
C37 nti I0 0.00236f
C38 I1 I0 0.4393f
C39 nti over 0
C40 over I1 0
C41 a_n1011_n1581# VDD_1V65 0.12271f
C42 over gf180mcu_fd_sc_mcu7t5v0__nor2_1_0/a_224_472# 0.00898f
C43 I0 In 0
C44 VNW gf180mcu_fd_sc_mcu7t5v0__and2_1_0/a_36_159# 0.00285f
C45 nor nti 0.03752f
C46 nor I1 0.0598f
C47 a_n1011_n1581# S 0
C48 nor gf180mcu_fd_sc_mcu7t5v0__nor2_1_0/a_224_472# 0.02636f
C49 gf180mcu_fd_sc_mcu7t5v0__and2_1_0/a_244_159# gf180mcu_fd_sc_mcu7t5v0__and2_1_0/a_36_159# 0.00424f
C50 in VNW 0.00551f
C51 nor In 0.07706f
C52 nti I1 0.16888f
C53 gf180mcu_fd_sc_mcu7t5v0__and2_1_0/Z over 0.02124f
C54 VDD_3V3_1 gf180mcu_fd_sc_mcu7t5v0__and2_1_0/a_36_159# 0.25656f
C55 I1 gf180mcu_fd_sc_mcu7t5v0__nor2_1_0/a_224_472# 0
C56 a_n563_n1613# a_209_n1430# 0.00101f
C57 in a_n563_n1613# 0.00813f
C58 nti In 0
C59 I1 In 0.00159f
C60 in VDD_3V3_1 0.87095f
C61 nor gf180mcu_fd_sc_mcu7t5v0__and2_1_0/Z 0.43324f
C62 a_209_n1430# a_n95_n2014# 0.00166f
C63 in a_n95_n2014# 0.0051f
C64 in Z 0.00189f
C65 nti gf180mcu_fd_sc_mcu7t5v0__and2_1_0/Z 0
C66 VNW VDD_1V65 0.01106f
C67 VNW a_n1011_n1581# 0.45743f
C68 gf180mcu_fd_sc_mcu7t5v0__and2_1_0/Z I1 0.01481f
C69 a_n563_n1613# VDD_1V65 0
C70 a_n1011_n1581# a_n563_n1613# 0.01016f
C71 VNW S 0.4895f
C72 VDD_3V3_1 a_n1011_n1581# 0.00102f
C73 in I0 0.17009f
C74 a_n183_n1430# a_n563_n1613# 0.00317f
C75 nor gf180mcu_fd_sc_mcu7t5v0__and2_1_0/a_36_159# 0.05938f
C76 a_n563_n1613# S 0.12833f
C77 a_n1011_n1581# a_n95_n2014# 0
C78 Z VDD_1V65 0
C79 a_n1011_n1581# Z 0.06732f
C80 VDD_3V3_1 S 0.00354f
C81 a_209_n1970# S 0.00276f
C82 nor a_209_n1430# 0
C83 nor in 0.00802f
C84 nti gf180mcu_fd_sc_mcu7t5v0__and2_1_0/a_36_159# 0.26623f
C85 gf180mcu_fd_sc_mcu7t5v0__and2_1_0/a_36_159# I1 0.29576f
C86 a_n95_n2014# S 0.22431f
C87 I1 a_209_n1430# 0.00154f
C88 nti in 0.45854f
C89 in I1 0.16601f
C90 a_n1011_n1581# I0 0.00166f
C91 a_n150_n1970# S 0
C92 VNW a_n563_n1613# 0.49108f
C93 I0 S 0.35803f
C94 gf180mcu_fd_sc_mcu7t5v0__and2_1_0/Z gf180mcu_fd_sc_mcu7t5v0__and2_1_0/a_36_159# 0.13951f
C95 VNW VDD_3V3_1 0.00136f
C96 nor VDD_1V65 0.06647f
C97 nor a_n1011_n1581# 0.31216f
C98 VNW a_209_n1970# 0.005f
C99 in gf180mcu_fd_sc_mcu7t5v0__and2_1_0/Z 0
C100 nor a_n183_n1430# 0
C101 nti VDD_1V65 0
C102 nti a_n1011_n1581# 0.00378f
C103 VNW a_n95_n2014# 0.35821f
C104 VNW Z 0.07663f
C105 I1 VDD_1V65 0.0012f
C106 a_n1011_n1581# I1 0.00331f
C107 nor S 0
C108 a_n563_n1613# a_209_n1970# 0.00106f
C109 VNW a_n150_n1970# 0.00245f
C110 I1 a_n183_n1430# 0
C111 a_n563_n1613# a_n95_n2014# 0.02837f
C112 In VDD_1V65 0.02972f
C113 a_n563_n1613# Z 0.09045f
C114 a_n1011_n1581# In 0.29914f
C115 I1 S 0.22468f
C116 VDD_3V3_1 a_n95_n2014# 0.0016f
C117 a_209_n1970# a_n95_n2014# 0
C118 a_n150_n1970# a_n563_n1613# 0.00556f
C119 VNW I0 0.2163f
C120 VNW over 0.00261f
C121 gf180mcu_fd_sc_mcu7t5v0__and2_1_0/Z a_n1011_n1581# 0.00228f
C122 S VSS 0.46225f
C123 Z VSS 0.05909f
C124 In VSS 0.06694f
C125 VDD_1V65 VSS 0.19002f
C126 a_209_n1430# VSS 0.00302f ; **FLOATING
C127 a_n183_n1430# VSS 0 ; **FLOATING
C128 a_n95_n2014# VSS 0.482f ; **FLOATING
C129 a_n563_n1613# VSS 0.47356f ; **FLOATING
C130 I0 VSS 0.76233f
C131 in VSS 0.96759f
C132 gf180mcu_fd_sc_mcu7t5v0__and2_1_0/a_244_159# VSS 0.00145f ; **FLOATING
C133 gf180mcu_fd_sc_mcu7t5v0__and2_1_0/a_36_159# VSS 0.40188f ; **FLOATING
C134 gf180mcu_fd_sc_mcu7t5v0__and2_1_0/Z VSS 0.38119f
C135 over VSS 0.2603f
C136 gf180mcu_fd_sc_mcu7t5v0__nor2_1_0/a_224_472# VSS 0 ; **FLOATING
C137 I1 VSS 1.08379f
C138 VDD_3V3_1 VSS 5.44991f
C139 a_n1011_n1581# VSS 0.49026f ; **FLOATING
C140 nor VSS 1.10557f
C141 VNW VSS 4.77418f
C142 nti VSS 0.2478f
