* NGSPICE file created from 5v0_mult_1t.ext - technology: gf180mcuD

.option scale=5n

X0 inv in VSS VSS nfet_06v0 ad=6.336n pd=0.32m as=6.478n ps=0.255m w=72 l=578
X1 VDD_3V3_1 in inv VDD_3V3_1 pfet_06v0 ad=12.81n pd=0.349m as=12.688n ps=0.348m w=244 l=100
X2 VDD_3V3_1 in nti VDD_3V3_1 pfet_06v0 ad=13.616n pd=0.392m as=9.696n ps=0.394m w=96 l=150
X3 VSS in nti VSS nfet_06v0 ad=6.478n pd=0.255m as=12.7n ps=0.454m w=127 l=120
X4 inv in VDD_3V3_1 VDD_3V3_1 pfet_06v0 ad=12.688n pd=0.348m as=13.616n ps=0.392m w=244 l=100
X5 inv in VDD_3V3_1 VDD_3V3_1 pfet_06v0 ad=27.328n pd=0.712m as=12.81n ps=0.349m w=244 l=100
X6 mux2_mult_custom_0/a_896_593# sign mux2_mult_custom_0/a_124_24# VDD_3V3_0 pfet_06v0 ad=2.952n pd=0.171m as=6.396n ps=0.227m w=123 l=100
X7 VSS mux2_mult_custom_0/a_124_24# mux_res VSS nfet_06v0 ad=8.72n pd=0.304m as=14.432n ps=0.504m w=164 l=120
X8 mux2_mult_custom_0/a_124_24# sign mux2_mult_custom_0/a_504_104# VSS nfet_06v0 ad=3.744n pd=0.176m as=1.728n ps=0.12m w=72 l=120
X9 VDD_3V3_0 mux2_mult_custom_0/a_124_24# mux_res VDD_3V3_0 pfet_06v0 ad=17.193n pd=0.437m as=21.472n ps=0.664m w=244 l=100
X10 VDD_3V3_0 inv mux2_mult_custom_0/a_896_593# VDD_3V3_0 pfet_06v0 ad=6.396n pd=0.227m as=2.952n ps=0.171m w=123 l=100
X11 mux2_mult_custom_0/a_592_407# sign VSS VSS nfet_06v0 ad=6.336n pd=0.32m as=3.744n ps=0.176m w=72 l=120
X12 mux2_mult_custom_0/a_504_104# original VSS VSS nfet_06v0 ad=1.728n pd=0.12m as=8.72n ps=0.304m w=72 l=120
X13 mux2_mult_custom_0/a_592_407# sign VDD_3V3_0 VDD_3V3_0 pfet_06v0 ad=10.824n pd=0.422m as=6.396n ps=0.227m w=123 l=100
X14 mux2_mult_custom_0/a_537_593# original VDD_3V3_0 VDD_3V3_0 pfet_06v0 ad=3.382n pd=0.178m as=17.193n ps=0.437m w=123 l=100
X15 VSS inv mux2_mult_custom_0/a_896_104# VSS nfet_06v0 ad=3.744n pd=0.176m as=1.728n ps=0.12m w=72 l=120
X16 mux2_mult_custom_0/a_896_104# mux2_mult_custom_0/a_592_407# mux2_mult_custom_0/a_124_24# VSS nfet_06v0 ad=1.728n pd=0.12m as=3.744n ps=0.176m w=72 l=120
X17 mux2_mult_custom_0/a_124_24# mux2_mult_custom_0/a_592_407# mux2_mult_custom_0/a_537_593# VDD_3V3_0 pfet_06v0 ad=6.396n pd=0.227m as=3.382n ps=0.178m w=123 l=100
X18 gf180mcu_fd_sc_mcu7t5v0__nor3_1_0/ZN over gf180mcu_fd_sc_mcu7t5v0__nor3_1_0/a_448_472# VDD_3V3_1 pfet_06v0 ad=21.472n pd=0.664m as=15.128n ps=0.368m w=244 l=100
X19 gf180mcu_fd_sc_mcu7t5v0__nor3_1_0/ZN over VSS VSS nfet_06v0 ad=8.184n pd=0.362m as=4.836n ps=0.197m w=93 l=120
X20 gf180mcu_fd_sc_mcu7t5v0__nor3_1_0/a_244_472# nti VDD_3V3_1 VDD_3V3_1 pfet_06v0 ad=12.688n pd=0.348m as=21.472n ps=0.664m w=244 l=100
X21 gf180mcu_fd_sc_mcu7t5v0__nor3_1_0/a_448_472# original gf180mcu_fd_sc_mcu7t5v0__nor3_1_0/a_244_472# VDD_3V3_1 pfet_06v0 ad=15.128n pd=0.368m as=12.688n ps=0.348m w=244 l=100
X22 VSS original gf180mcu_fd_sc_mcu7t5v0__nor3_1_0/ZN VSS nfet_06v0 ad=4.836n pd=0.197m as=4.836n ps=0.197m w=93 l=120
X23 gf180mcu_fd_sc_mcu7t5v0__nor3_1_0/ZN nti VSS VSS nfet_06v0 ad=4.836n pd=0.197m as=8.184n ps=0.362m w=93 l=120
X24 m1_n1363_n1702# gf180mcu_fd_sc_mcu7t5v0__nor3_1_0/ZN VSS VSS nfet_06v0 ad=14.432n pd=0.504m as=14.432n ps=0.504m w=164 l=120
X25 m1_n1363_n1702# gf180mcu_fd_sc_mcu7t5v0__nor3_1_0/ZN VDD_3V3_0 VDD_3V3_0 pfet_06v0 ad=21.472n pd=0.664m as=21.472n ps=0.664m w=244 l=100
X26 original inv VSS VSS nfet_06v0 ad=14.432n pd=0.504m as=84.604n ps=3.234m w=164 l=120
X27 original inv VDD_3V3_1 VDD_3V3_1 pfet_06v0 ad=21.472n pd=0.664m as=95.796n ps=2.81m w=244 l=100
X28 mux_res m1_n1363_n1702# res VSS nfet_06v0 ad=14.432n pd=0.504m as=14.432n ps=0.504m w=164 l=120
X29 res gf180mcu_fd_sc_mcu7t5v0__nor3_1_0/ZN VDD_1V65 VSS nfet_06v0 ad=14.432n pd=0.504m as=14.432n ps=0.504m w=164 l=120
C0 VDD_1V65 over 0
C1 nti inv 0.00232f
C2 sign in 0.00584f
C3 gf180mcu_fd_sc_mcu7t5v0__nor3_1_0/a_244_472# gf180mcu_fd_sc_mcu7t5v0__nor3_1_0/ZN 0.00216f
C4 VDD_1V65 VDD_3V3_0 0.01001f
C5 VDD_3V3_1 original 0.56436f
C6 mux2_mult_custom_0/a_592_407# inv 0.30165f
C7 mux2_mult_custom_0/a_896_593# original 0
C8 mux_res VDD_3V3_0 0.07671f
C9 VDD_1V65 m1_n1363_n1702# 0.12434f
C10 m1_n1363_n1702# mux_res 0.11502f
C11 VDD_1V65 gf180mcu_fd_sc_mcu7t5v0__nor3_1_0/ZN 0.1548f
C12 mux_res gf180mcu_fd_sc_mcu7t5v0__nor3_1_0/ZN 0.06829f
C13 nti original 0.31213f
C14 sign mux2_mult_custom_0/a_124_24# 0.12833f
C15 sign res 0
C16 mux2_mult_custom_0/a_592_407# mux2_mult_custom_0/a_896_104# 0.00166f
C17 VDD_3V3_1 gf180mcu_fd_sc_mcu7t5v0__nor3_1_0/a_448_472# 0.01448f
C18 over VDD_3V3_1 0.18631f
C19 mux2_mult_custom_0/a_592_407# original 0.07102f
C20 mux2_mult_custom_0/a_537_593# mux2_mult_custom_0/a_124_24# 0.00556f
C21 nti over 0
C22 VDD_3V3_1 VDD_3V3_0 0
C23 mux2_mult_custom_0/a_896_593# VDD_3V3_0 0.005f
C24 VDD_3V3_1 m1_n1363_n1702# 0.00327f
C25 inv original 0.4972f
C26 VDD_3V3_1 gf180mcu_fd_sc_mcu7t5v0__nor3_1_0/ZN 0.12688f
C27 nti VDD_3V3_0 0
C28 mux2_mult_custom_0/a_124_24# in 0.00523f
C29 nti m1_n1363_n1702# 0.00607f
C30 nti gf180mcu_fd_sc_mcu7t5v0__nor3_1_0/ZN 0.06288f
C31 mux2_mult_custom_0/a_592_407# VDD_3V3_0 0.35858f
C32 sign mux_res 0
C33 m1_n1363_n1702# mux2_mult_custom_0/a_592_407# 0.00119f
C34 mux2_mult_custom_0/a_896_104# original 0.00154f
C35 mux2_mult_custom_0/a_592_407# gf180mcu_fd_sc_mcu7t5v0__nor3_1_0/ZN 0
C36 mux2_mult_custom_0/a_504_104# original 0
C37 inv VDD_3V3_0 0.21619f
C38 mux2_mult_custom_0/a_124_24# res 0.00134f
C39 m1_n1363_n1702# inv 0.00214f
C40 inv gf180mcu_fd_sc_mcu7t5v0__nor3_1_0/ZN 0
C41 gf180mcu_fd_sc_mcu7t5v0__nor3_1_0/a_448_472# original 0.01521f
C42 over original 0.0804f
C43 mux_res in 0.00213f
C44 sign VDD_3V3_1 0.00142f
C45 sign mux2_mult_custom_0/a_896_593# 0.00276f
C46 original VDD_3V3_0 0.2369f
C47 m1_n1363_n1702# original 0.02222f
C48 mux2_mult_custom_0/a_896_104# gf180mcu_fd_sc_mcu7t5v0__nor3_1_0/ZN 0
C49 gf180mcu_fd_sc_mcu7t5v0__nor3_1_0/ZN original 0.12053f
C50 over gf180mcu_fd_sc_mcu7t5v0__nor3_1_0/a_448_472# 0.01262f
C51 mux2_mult_custom_0/a_504_104# gf180mcu_fd_sc_mcu7t5v0__nor3_1_0/ZN 0
C52 sign mux2_mult_custom_0/a_592_407# 0.22431f
C53 VDD_1V65 mux2_mult_custom_0/a_124_24# 0
C54 VDD_1V65 res 0.02578f
C55 mux2_mult_custom_0/a_124_24# mux_res 0.09045f
C56 over VDD_3V3_0 0.00126f
C57 mux_res res 0.0589f
C58 VDD_3V3_1 in 0.87292f
C59 mux2_mult_custom_0/a_537_593# mux2_mult_custom_0/a_592_407# 0
C60 over m1_n1363_n1702# 0.00178f
C61 gf180mcu_fd_sc_mcu7t5v0__nor3_1_0/a_448_472# gf180mcu_fd_sc_mcu7t5v0__nor3_1_0/ZN 0.00983f
C62 over gf180mcu_fd_sc_mcu7t5v0__nor3_1_0/ZN 0.30022f
C63 nti in 0.17102f
C64 sign inv 0.35803f
C65 m1_n1363_n1702# VDD_3V3_0 0.20908f
C66 gf180mcu_fd_sc_mcu7t5v0__nor3_1_0/ZN VDD_3V3_0 0.38577f
C67 m1_n1363_n1702# gf180mcu_fd_sc_mcu7t5v0__nor3_1_0/ZN 0.39061f
C68 mux2_mult_custom_0/a_592_407# in 0.00518f
C69 VDD_3V3_1 mux2_mult_custom_0/a_124_24# 0.00176f
C70 mux2_mult_custom_0/a_124_24# mux2_mult_custom_0/a_896_593# 0.00106f
C71 sign original 0.22461f
C72 VDD_1V65 mux_res 0
C73 nti res 0
C74 mux2_mult_custom_0/a_537_593# original 0
C75 inv in 0.45244f
C76 mux2_mult_custom_0/a_124_24# mux2_mult_custom_0/a_592_407# 0.02837f
C77 gf180mcu_fd_sc_mcu7t5v0__nor3_1_0/a_244_472# VDD_3V3_1 0.00689f
C78 original in 0.1631f
C79 nti gf180mcu_fd_sc_mcu7t5v0__nor3_1_0/a_244_472# 0.01909f
C80 sign VDD_3V3_0 0.4897f
C81 mux2_mult_custom_0/a_124_24# inv 0.00505f
C82 sign m1_n1363_n1702# 0.00365f
C83 mux2_mult_custom_0/a_537_593# VDD_3V3_0 0.00245f
C84 sign gf180mcu_fd_sc_mcu7t5v0__nor3_1_0/ZN 0
C85 VDD_1V65 nti 0
C86 over in 0
C87 mux2_mult_custom_0/a_124_24# mux2_mult_custom_0/a_896_104# 0.00101f
C88 mux2_mult_custom_0/a_124_24# original 0.32838f
C89 res original 0.00401f
C90 mux2_mult_custom_0/a_124_24# mux2_mult_custom_0/a_504_104# 0.00317f
C91 VDD_3V3_0 in 0.00486f
C92 m1_n1363_n1702# in 0.00474f
C93 gf180mcu_fd_sc_mcu7t5v0__nor3_1_0/ZN in 0.00688f
C94 nti VDD_3V3_1 0.3952f
C95 gf180mcu_fd_sc_mcu7t5v0__nor3_1_0/a_244_472# original 0.00714f
C96 VDD_3V3_1 mux2_mult_custom_0/a_592_407# 0
C97 mux2_mult_custom_0/a_124_24# VDD_3V3_0 0.49102f
C98 mux2_mult_custom_0/a_592_407# mux2_mult_custom_0/a_896_593# 0
C99 res VDD_3V3_0 0.40816f
C100 m1_n1363_n1702# mux2_mult_custom_0/a_124_24# 0.02566f
C101 m1_n1363_n1702# res 0.30043f
C102 VDD_1V65 original 0.00148f
C103 sign mux2_mult_custom_0/a_537_593# 0
C104 mux_res original 0.00412f
C105 mux2_mult_custom_0/a_124_24# gf180mcu_fd_sc_mcu7t5v0__nor3_1_0/ZN 0.0114f
C106 res gf180mcu_fd_sc_mcu7t5v0__nor3_1_0/ZN 0.16969f
C107 VDD_3V3_1 inv 0.55173f
C108 res VSS 0.05678f
C109 VDD_1V65 VSS 0.17428f
C110 m1_n1363_n1702# VSS 0.42239f ; **FLOATING
C111 gf180mcu_fd_sc_mcu7t5v0__nor3_1_0/ZN VSS 1.14942f
C112 VDD_3V3_1 VSS 4.42346f
C113 over VSS 0.215f
C114 mux_res VSS 0.05909f
C115 inv VSS 0.76888f
C116 sign VSS 0.44715f
C117 original VSS 1.11723f
C118 VDD_3V3_0 VSS 4.5158f
C119 mux2_mult_custom_0/a_896_104# VSS 0.00302f ; **FLOATING
C120 mux2_mult_custom_0/a_504_104# VSS 0 ; **FLOATING
C121 mux2_mult_custom_0/a_592_407# VSS 0.49094f ; **FLOATING
C122 mux2_mult_custom_0/a_124_24# VSS 0.50074f ; **FLOATING
C123 nti VSS 0.32961f
C124 in VSS 0.96777f
