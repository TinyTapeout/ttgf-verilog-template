* NGSPICE file created from 5v0_mult_1t.ext - technology: gf180mcuD

.option scale=5n

X0 inv in VSS VSS nfet_06v0 ad=6.336n pd=0.32m as=6.478n ps=0.255m w=72 l=578
X1 VDD_3V3_1 in inv VDD_3V3_1 pfet_06v0 ad=12.81n pd=0.349m as=12.688n ps=0.348m w=244 l=100
X2 VDD_3V3_1 in inverter_pair_short_0/nti VDD_3V3_1 pfet_06v0 ad=13.616n pd=0.392m as=9.696n ps=0.394m w=96 l=150
X3 VSS in inverter_pair_short_0/nti VSS nfet_06v0 ad=6.478n pd=0.255m as=12.7n ps=0.454m w=127 l=120
X4 inv in VDD_3V3_1 VDD_3V3_1 pfet_06v0 ad=12.688n pd=0.348m as=13.616n ps=0.392m w=244 l=100
X5 inv in VDD_3V3_1 VDD_3V3_1 pfet_06v0 ad=27.328n pd=0.712m as=12.81n ps=0.349m w=244 l=100
X6 gf180mcu_fd_sc_mcu7t5v0__nor3_1_0/ZN over gf180mcu_fd_sc_mcu7t5v0__nor3_1_0/a_448_472# VDD_3V3_1 pfet_06v0 ad=21.472n pd=0.664m as=15.128n ps=0.368m w=244 l=100
X7 gf180mcu_fd_sc_mcu7t5v0__nor3_1_0/ZN over VSS VSS nfet_06v0 ad=8.184n pd=0.362m as=4.836n ps=0.197m w=93 l=120
X8 gf180mcu_fd_sc_mcu7t5v0__nor3_1_0/a_244_472# inverter_pair_short_0/nti VDD_3V3_1 VDD_3V3_1 pfet_06v0 ad=12.688n pd=0.348m as=21.472n ps=0.664m w=244 l=100
X9 gf180mcu_fd_sc_mcu7t5v0__nor3_1_0/a_448_472# inv gf180mcu_fd_sc_mcu7t5v0__nor3_1_0/a_244_472# VDD_3V3_1 pfet_06v0 ad=15.128n pd=0.368m as=12.688n ps=0.348m w=244 l=100
X10 VSS inv gf180mcu_fd_sc_mcu7t5v0__nor3_1_0/ZN VSS nfet_06v0 ad=4.836n pd=0.197m as=4.836n ps=0.197m w=93 l=120
X11 gf180mcu_fd_sc_mcu7t5v0__nor3_1_0/ZN inverter_pair_short_0/nti VSS VSS nfet_06v0 ad=4.836n pd=0.197m as=8.184n ps=0.362m w=93 l=120
X12 a_n1011_n1581# gf180mcu_fd_sc_mcu7t5v0__nor3_1_0/ZN VSS VSS nfet_06v0 ad=14.432n pd=0.504m as=14.432n ps=0.504m w=164 l=120
X13 a_n1011_n1581# gf180mcu_fd_sc_mcu7t5v0__nor3_1_0/ZN VDD_3V3_0 VDD_3V3_0 pfet_06v0 ad=21.472n pd=0.664m as=21.472n ps=0.664m w=244 l=100
X14 gf180mcu_fd_sc_mcu7t5v0__mux2_1_0/a_896_593# sign gf180mcu_fd_sc_mcu7t5v0__mux2_1_0/a_124_24# VDD_3V3_0 pfet_06v0 ad=2.952n pd=0.171m as=6.396n ps=0.227m w=123 l=100
X15 VSS gf180mcu_fd_sc_mcu7t5v0__mux2_1_0/a_124_24# mux_res VSS nfet_06v0 ad=8.72n pd=0.304m as=14.432n ps=0.504m w=164 l=120
X16 gf180mcu_fd_sc_mcu7t5v0__mux2_1_0/a_124_24# sign gf180mcu_fd_sc_mcu7t5v0__mux2_1_0/a_504_104# VSS nfet_06v0 ad=3.744n pd=0.176m as=1.728n ps=0.12m w=72 l=120
X17 VDD_3V3_0 gf180mcu_fd_sc_mcu7t5v0__mux2_1_0/a_124_24# mux_res VDD_3V3_0 pfet_06v0 ad=17.193n pd=0.437m as=21.472n ps=0.664m w=244 l=100
X18 VDD_3V3_0 inv gf180mcu_fd_sc_mcu7t5v0__mux2_1_0/a_896_593# VDD_3V3_0 pfet_06v0 ad=6.396n pd=0.227m as=2.952n ps=0.171m w=123 l=100
X19 gf180mcu_fd_sc_mcu7t5v0__mux2_1_0/a_592_407# sign VSS VSS nfet_06v0 ad=6.336n pd=0.32m as=3.744n ps=0.176m w=72 l=120
X20 gf180mcu_fd_sc_mcu7t5v0__mux2_1_0/a_504_104# original VSS VSS nfet_06v0 ad=1.728n pd=0.12m as=8.72n ps=0.304m w=72 l=120
X21 gf180mcu_fd_sc_mcu7t5v0__mux2_1_0/a_592_407# sign VDD_3V3_0 VDD_3V3_0 pfet_06v0 ad=10.824n pd=0.422m as=6.396n ps=0.227m w=123 l=100
X22 gf180mcu_fd_sc_mcu7t5v0__mux2_1_0/a_537_593# original VDD_3V3_0 VDD_3V3_0 pfet_06v0 ad=3.382n pd=0.178m as=17.193n ps=0.437m w=123 l=100
X23 VSS inv gf180mcu_fd_sc_mcu7t5v0__mux2_1_0/a_896_104# VSS nfet_06v0 ad=3.744n pd=0.176m as=1.728n ps=0.12m w=72 l=120
X24 gf180mcu_fd_sc_mcu7t5v0__mux2_1_0/a_896_104# gf180mcu_fd_sc_mcu7t5v0__mux2_1_0/a_592_407# gf180mcu_fd_sc_mcu7t5v0__mux2_1_0/a_124_24# VSS nfet_06v0 ad=1.728n pd=0.12m as=3.744n ps=0.176m w=72 l=120
X25 gf180mcu_fd_sc_mcu7t5v0__mux2_1_0/a_124_24# gf180mcu_fd_sc_mcu7t5v0__mux2_1_0/a_592_407# gf180mcu_fd_sc_mcu7t5v0__mux2_1_0/a_537_593# VDD_3V3_0 pfet_06v0 ad=6.396n pd=0.227m as=3.382n ps=0.178m w=123 l=100
X26 original inv VSS VSS nfet_06v0 ad=14.432n pd=0.504m as=84.604n ps=3.234m w=164 l=120
X27 original inv VDD_3V3_1 VDD_3V3_1 pfet_06v0 ad=21.472n pd=0.664m as=95.796n ps=2.81m w=244 l=100
X28 mux_res gf180mcu_fd_sc_mcu7t5v0__nor3_1_0/ZN res VSS nfet_06v0 ad=14.432n pd=0.504m as=14.432n ps=0.504m w=164 l=120
X29 res a_n1011_n1581# VDD_1V65 VSS nfet_06v0 ad=14.432n pd=0.504m as=14.432n ps=0.504m w=164 l=120
C0 mux_res gf180mcu_fd_sc_mcu7t5v0__nor3_1_0/ZN 0.05772f
C1 sign gf180mcu_fd_sc_mcu7t5v0__mux2_1_0/a_124_24# 0.12833f
C2 gf180mcu_fd_sc_mcu7t5v0__mux2_1_0/a_592_407# gf180mcu_fd_sc_mcu7t5v0__nor3_1_0/ZN 0
C3 inv gf180mcu_fd_sc_mcu7t5v0__nor3_1_0/a_244_472# 0.00719f
C4 VDD_1V65 VDD_3V3_0 0.01698f
C5 mux_res inv 0.00248f
C6 inv gf180mcu_fd_sc_mcu7t5v0__mux2_1_0/a_592_407# 0.30165f
C7 VDD_3V3_1 over 0.18631f
C8 VDD_3V3_0 inverter_pair_short_0/nti 0
C9 gf180mcu_fd_sc_mcu7t5v0__mux2_1_0/a_592_407# gf180mcu_fd_sc_mcu7t5v0__mux2_1_0/a_896_104# 0.00166f
C10 VDD_3V3_1 gf180mcu_fd_sc_mcu7t5v0__nor3_1_0/ZN 0.13011f
C11 res gf180mcu_fd_sc_mcu7t5v0__nor3_1_0/ZN 0.07761f
C12 gf180mcu_fd_sc_mcu7t5v0__nor3_1_0/ZN over 0.30018f
C13 VDD_3V3_0 sign 0.4897f
C14 gf180mcu_fd_sc_mcu7t5v0__mux2_1_0/a_537_593# sign 0
C15 VDD_3V3_1 inv 0.93786f
C16 res inv 0
C17 inv over 0.08043f
C18 original gf180mcu_fd_sc_mcu7t5v0__nor3_1_0/a_244_472# 0
C19 mux_res in 0.00185f
C20 mux_res original 0.00353f
C21 inv gf180mcu_fd_sc_mcu7t5v0__nor3_1_0/ZN 0.11735f
C22 gf180mcu_fd_sc_mcu7t5v0__mux2_1_0/a_592_407# in 0.00518f
C23 gf180mcu_fd_sc_mcu7t5v0__mux2_1_0/a_592_407# original 0.07054f
C24 gf180mcu_fd_sc_mcu7t5v0__nor3_1_0/ZN gf180mcu_fd_sc_mcu7t5v0__mux2_1_0/a_896_104# 0
C25 VDD_1V65 inverter_pair_short_0/nti 0
C26 gf180mcu_fd_sc_mcu7t5v0__mux2_1_0/a_896_593# sign 0.00276f
C27 a_n1011_n1581# mux_res 0.049f
C28 VDD_3V3_1 in 0.87292f
C29 VDD_3V3_1 original 0.16233f
C30 res original 0.00132f
C31 over in 0
C32 a_n1011_n1581# gf180mcu_fd_sc_mcu7t5v0__mux2_1_0/a_592_407# 0
C33 mux_res gf180mcu_fd_sc_mcu7t5v0__mux2_1_0/a_124_24# 0.08965f
C34 gf180mcu_fd_sc_mcu7t5v0__nor3_1_0/ZN in 0.00872f
C35 gf180mcu_fd_sc_mcu7t5v0__nor3_1_0/ZN original 0.01781f
C36 gf180mcu_fd_sc_mcu7t5v0__mux2_1_0/a_592_407# gf180mcu_fd_sc_mcu7t5v0__mux2_1_0/a_124_24# 0.02837f
C37 inv in 0.53128f
C38 inv original 0.42226f
C39 a_n1011_n1581# VDD_3V3_1 0.00123f
C40 res a_n1011_n1581# 0.3062f
C41 original gf180mcu_fd_sc_mcu7t5v0__mux2_1_0/a_896_104# 0.00143f
C42 a_n1011_n1581# over 0.00178f
C43 gf180mcu_fd_sc_mcu7t5v0__mux2_1_0/a_504_104# gf180mcu_fd_sc_mcu7t5v0__nor3_1_0/ZN 0
C44 VDD_3V3_1 gf180mcu_fd_sc_mcu7t5v0__mux2_1_0/a_124_24# 0.00176f
C45 a_n1011_n1581# gf180mcu_fd_sc_mcu7t5v0__nor3_1_0/ZN 0.28956f
C46 res gf180mcu_fd_sc_mcu7t5v0__mux2_1_0/a_124_24# 0.0015f
C47 mux_res VDD_3V3_0 0.07358f
C48 VDD_3V3_1 gf180mcu_fd_sc_mcu7t5v0__nor3_1_0/a_448_472# 0.01448f
C49 over gf180mcu_fd_sc_mcu7t5v0__nor3_1_0/a_448_472# 0.01262f
C50 gf180mcu_fd_sc_mcu7t5v0__mux2_1_0/a_504_104# inv 0
C51 gf180mcu_fd_sc_mcu7t5v0__mux2_1_0/a_592_407# VDD_3V3_0 0.35858f
C52 gf180mcu_fd_sc_mcu7t5v0__nor3_1_0/ZN gf180mcu_fd_sc_mcu7t5v0__mux2_1_0/a_124_24# 0.01865f
C53 a_n1011_n1581# inv 0.00233f
C54 gf180mcu_fd_sc_mcu7t5v0__mux2_1_0/a_592_407# gf180mcu_fd_sc_mcu7t5v0__mux2_1_0/a_537_593# 0
C55 gf180mcu_fd_sc_mcu7t5v0__nor3_1_0/ZN gf180mcu_fd_sc_mcu7t5v0__nor3_1_0/a_448_472# 0.00983f
C56 inv gf180mcu_fd_sc_mcu7t5v0__mux2_1_0/a_124_24# 0.01021f
C57 original in 0.0585f
C58 inv gf180mcu_fd_sc_mcu7t5v0__nor3_1_0/a_448_472# 0.01525f
C59 gf180mcu_fd_sc_mcu7t5v0__mux2_1_0/a_896_104# gf180mcu_fd_sc_mcu7t5v0__mux2_1_0/a_124_24# 0.00101f
C60 VDD_3V3_1 VDD_3V3_0 0
C61 res VDD_3V3_0 0.44214f
C62 over VDD_3V3_0 0.00126f
C63 gf180mcu_fd_sc_mcu7t5v0__mux2_1_0/a_592_407# gf180mcu_fd_sc_mcu7t5v0__mux2_1_0/a_896_593# 0
C64 VDD_1V65 mux_res 0
C65 gf180mcu_fd_sc_mcu7t5v0__nor3_1_0/ZN VDD_3V3_0 0.21059f
C66 gf180mcu_fd_sc_mcu7t5v0__mux2_1_0/a_504_104# original 0
C67 a_n1011_n1581# original 0.00274f
C68 inv VDD_3V3_0 0.22269f
C69 inverter_pair_short_0/nti gf180mcu_fd_sc_mcu7t5v0__nor3_1_0/a_244_472# 0.01909f
C70 in gf180mcu_fd_sc_mcu7t5v0__mux2_1_0/a_124_24# 0.00523f
C71 original gf180mcu_fd_sc_mcu7t5v0__mux2_1_0/a_124_24# 0.32286f
C72 original gf180mcu_fd_sc_mcu7t5v0__nor3_1_0/a_448_472# 0
C73 mux_res sign 0
C74 res VDD_1V65 0.034f
C75 VDD_1V65 over 0
C76 gf180mcu_fd_sc_mcu7t5v0__mux2_1_0/a_592_407# sign 0.22431f
C77 VDD_1V65 gf180mcu_fd_sc_mcu7t5v0__nor3_1_0/ZN 0.1051f
C78 gf180mcu_fd_sc_mcu7t5v0__mux2_1_0/a_504_104# gf180mcu_fd_sc_mcu7t5v0__mux2_1_0/a_124_24# 0.00317f
C79 a_n1011_n1581# gf180mcu_fd_sc_mcu7t5v0__mux2_1_0/a_124_24# 0.0102f
C80 VDD_3V3_1 inverter_pair_short_0/nti 0.3952f
C81 res inverter_pair_short_0/nti 0
C82 over inverter_pair_short_0/nti 0
C83 VDD_1V65 inv 0.00104f
C84 VDD_3V3_0 in 0.00486f
C85 original VDD_3V3_0 0.2317f
C86 original gf180mcu_fd_sc_mcu7t5v0__mux2_1_0/a_537_593# 0
C87 gf180mcu_fd_sc_mcu7t5v0__nor3_1_0/ZN inverter_pair_short_0/nti 0.08162f
C88 VDD_3V3_1 sign 0.00142f
C89 res sign 0
C90 inv inverter_pair_short_0/nti 0.31742f
C91 gf180mcu_fd_sc_mcu7t5v0__nor3_1_0/ZN sign 0
C92 inv sign 0.35803f
C93 a_n1011_n1581# VDD_3V3_0 0.32624f
C94 original gf180mcu_fd_sc_mcu7t5v0__mux2_1_0/a_896_593# 0
C95 VDD_3V3_0 gf180mcu_fd_sc_mcu7t5v0__mux2_1_0/a_124_24# 0.49102f
C96 VDD_1V65 original 0
C97 gf180mcu_fd_sc_mcu7t5v0__mux2_1_0/a_537_593# gf180mcu_fd_sc_mcu7t5v0__mux2_1_0/a_124_24# 0.00556f
C98 inverter_pair_short_0/nti in 0.17102f
C99 original inverter_pair_short_0/nti 0.00274f
C100 gf180mcu_fd_sc_mcu7t5v0__mux2_1_0/a_896_593# gf180mcu_fd_sc_mcu7t5v0__mux2_1_0/a_124_24# 0.00106f
C101 a_n1011_n1581# VDD_1V65 0.16202f
C102 in sign 0.00584f
C103 original sign 0.22447f
C104 VDD_3V3_0 gf180mcu_fd_sc_mcu7t5v0__mux2_1_0/a_537_593# 0.00245f
C105 VDD_1V65 gf180mcu_fd_sc_mcu7t5v0__mux2_1_0/a_124_24# 0
C106 a_n1011_n1581# inverter_pair_short_0/nti 0.00739f
C107 VDD_3V3_1 gf180mcu_fd_sc_mcu7t5v0__nor3_1_0/a_244_472# 0.00689f
C108 res mux_res 0.06875f
C109 a_n1011_n1581# sign 0
C110 VDD_3V3_1 gf180mcu_fd_sc_mcu7t5v0__mux2_1_0/a_592_407# 0
C111 gf180mcu_fd_sc_mcu7t5v0__nor3_1_0/ZN gf180mcu_fd_sc_mcu7t5v0__nor3_1_0/a_244_472# 0.00227f
C112 gf180mcu_fd_sc_mcu7t5v0__mux2_1_0/a_896_593# VDD_3V3_0 0.005f
C113 res VSS 0.05185f
C114 VDD_1V65 VSS 0.18877f
C115 gf180mcu_fd_sc_mcu7t5v0__nor3_1_0/ZN VSS 1.15645f
C116 a_n1011_n1581# VSS 0.40478f ; **FLOATING
C117 VDD_3V3_1 VSS 4.42346f
C118 mux_res VSS 0.05902f
C119 inv VSS 1.15818f
C120 sign VSS 0.44715f
C121 original VSS 0.69009f
C122 VDD_3V3_0 VSS 4.51552f
C123 gf180mcu_fd_sc_mcu7t5v0__mux2_1_0/a_896_104# VSS 0.00302f ; **FLOATING
C124 gf180mcu_fd_sc_mcu7t5v0__mux2_1_0/a_504_104# VSS 0 ; **FLOATING
C125 gf180mcu_fd_sc_mcu7t5v0__mux2_1_0/a_592_407# VSS 0.49094f ; **FLOATING
C126 gf180mcu_fd_sc_mcu7t5v0__mux2_1_0/a_124_24# VSS 0.50074f ; **FLOATING
C127 over VSS 0.215f
C128 inverter_pair_short_0/nti VSS 0.32961f
C129 in VSS 0.96777f
