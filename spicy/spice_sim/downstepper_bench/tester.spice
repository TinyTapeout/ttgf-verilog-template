* downstepper Test (5V0)

.include "$PDK_ROOT/gf180mcuD/libs.tech/ngspice/design.ngspice"
.lib "$PDK_ROOT/gf180mcuD/libs.tech/ngspice/sm141064.ngspice" typical

* 2. Include your Magic-extracted netlist
.include "5v0_downstep_sc_v8.spice"

* Absolute power rails for transistor gates and bulk/wells
Vdd VDD_3V3 0 DC 5.0
Vdd1 5v0_pti_sc_0/VDD_3V3 0 DC 5.0
Vdd2 5v0_nti_sc_f_0/VDD_3V3 0 DC 5.0
Vdd3 gf180mcu_fd_sc_mcu7t5v0__inv_1_0/VNW 0 DC 5.0
Vss VSS 0 DC 0.0
Vss2 5v0_pti_sc_0/VSS 0 DC 0.0
Vhf VDD_1V65 0 DC 2.5
Vpw VPW 0 DC 0.0
Vnw VNW 0 DC 5.0
Vin_0 ternary_input 0 PWL(
+   0.0n   0.0
+   5.0n   0.0
+  5.1n   2.5
+  10.0n   2.5
+  10.1n   5.0
+  15.0n   5.0
+  15.1n   0.0
+  25.0n   0.0
+ )

CLoad ternary_output 0 10ff

* 6. Simulation Commands
.tran 1p 20n
.op
.control
run
plot v(ternary_output) v(ternary_input)
plot v(gf180mcu_fd_sc_mcu7t5v0__inv_1_0/ZN) v(ternary_output)
plot i(Vdd) i(Vdd1) i(Vdd2) i(Vss2) i(Vhf)
.endc
.end
