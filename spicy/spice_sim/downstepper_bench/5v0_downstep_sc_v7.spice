* NGSPICE file created from 5v0_downstep_sc.ext - technology: gf180mcuD

.option scale=5n

X0 a_84_n933# ternary_input 5v0_pti_sc_0/VSS 5v0_pti_sc_0/VSS nfet_06v0 ad=6.336n pd=0.32m as=6.336n ps=0.32m w=72 l=578
X1 5v0_nti_sc_f_0/VDD_3V3 ternary_input a_84_n933# 5v0_nti_sc_f_0/VDD_3V3 pfet_06v0 ad=12.81n pd=0.349m as=12.688n ps=0.348m w=244 l=100
X2 a_84_n933# ternary_input 5v0_nti_sc_f_0/VDD_3V3 5v0_nti_sc_f_0/VDD_3V3 pfet_06v0 ad=12.688n pd=0.348m as=21.472n ps=0.664m w=244 l=100
X3 a_84_n933# ternary_input 5v0_nti_sc_f_0/VDD_3V3 5v0_nti_sc_f_0/VDD_3V3 pfet_06v0 ad=27.328n pd=0.712m as=12.81n ps=0.349m w=244 l=100
X4 5v0_nti_sc_f_0/ternary_output ternary_input 5v0_pti_sc_0/VSS 5v0_pti_sc_0/VSS nfet_06v0 ad=12.7n pd=0.454m as=11.303n ps=0.432m w=127 l=120
X5 5v0_nti_sc_f_0/ternary_output ternary_input 5v0_nti_sc_f_0/VDD_3V3 5v0_nti_sc_f_0/VDD_3V3 pfet_06v0 ad=9.696n pd=0.394m as=8.928n ps=0.378m w=96 l=150
X6 gf180mcu_fd_sc_mcu7t5v0__inv_1_0/ZN 5v0_nti_sc_f_0/ternary_output 5v0_pti_sc_0/VSS 5v0_pti_sc_0/VSS nfet_06v0 ad=14.432n pd=0.504m as=14.432n ps=0.504m w=164 l=120
X7 gf180mcu_fd_sc_mcu7t5v0__inv_1_0/ZN 5v0_nti_sc_f_0/ternary_output VDD_3V3 VDD_3V3 pfet_06v0 ad=21.472n pd=0.664m as=21.472n ps=0.664m w=244 l=100
X8 not_test a_84_n933# 5v0_pti_sc_0/VSS 5v0_pti_sc_0/VSS nfet_06v0 ad=14.432n pd=0.504m as=14.432n ps=0.504m w=164 l=120
X9 not_test a_84_n933# 5v0_nti_sc_f_0/VDD_3V3 5v0_nti_sc_f_0/VDD_3V3 pfet_06v0 ad=21.472n pd=0.664m as=21.472n ps=0.664m w=244 l=100
X10 ternary_output gf180mcu_fd_sc_mcu7t5v0__inv_1_0/ZN a_n164_n404# 5v0_pti_sc_0/VSS nfet_06v0 ad=6.731n pd=0.233m as=3.048n ps=0.175m w=127 l=120
X11 a_n164_n404# not_test VDD_1V65 5v0_pti_sc_0/VSS nfet_06v0 ad=3.048n pd=0.175m as=12.7n ps=0.454m w=127 l=120
X12 VDD_3V3 a_84_n933# ternary_output VDD_3V3 pfet_06v0 ad=21.472n pd=0.664m as=21.472n ps=0.664m w=244 l=100
X13 5v0_pti_sc_0/VSS a_84_n933# a_230_n404# 5v0_pti_sc_0/VSS nfet_06v0 ad=12.7n pd=0.454m as=3.048n ps=0.175m w=127 l=120
X14 a_230_n404# gf180mcu_fd_sc_mcu7t5v0__inv_1_0/ZN ternary_output 5v0_pti_sc_0/VSS nfet_06v0 ad=3.048n pd=0.175m as=6.731n ps=0.233m w=127 l=120
C0 VDD_3V3 not_test 0.03949f
C1 ternary_input 5v0_nti_sc_f_0/ternary_output 0.16639f
C2 ternary_output 5v0_nti_sc_f_0/ternary_output 0.00249f
C3 a_84_n933# VDD_1V65 0
C4 a_84_n933# a_n164_n404# 0
C5 not_test 5v0_nti_sc_f_0/ternary_output 0.00691f
C6 VDD_3V3 5v0_nti_sc_f_0/ternary_output 0.19476f
C7 5v0_nti_sc_f_0/VDD_3V3 ternary_input 0.91322f
C8 gf180mcu_fd_sc_mcu7t5v0__inv_1_0/ZN a_230_n404# 0
C9 5v0_nti_sc_f_0/VDD_3V3 not_test 0.15679f
C10 ternary_input gf180mcu_fd_sc_mcu7t5v0__inv_1_0/ZN 0.01255f
C11 ternary_output gf180mcu_fd_sc_mcu7t5v0__inv_1_0/ZN 0.16735f
C12 a_n164_n404# VDD_1V65 0.00208f
C13 a_84_n933# a_230_n404# 0.00305f
C14 not_test gf180mcu_fd_sc_mcu7t5v0__inv_1_0/ZN 0.13599f
C15 ternary_input a_84_n933# 0.45637f
C16 ternary_output a_84_n933# 0.12869f
C17 5v0_nti_sc_f_0/VDD_3V3 VDD_3V3 0
C18 not_test a_84_n933# 0.34033f
C19 5v0_nti_sc_f_0/VDD_3V3 5v0_nti_sc_f_0/ternary_output 0.08866f
C20 VDD_3V3 gf180mcu_fd_sc_mcu7t5v0__inv_1_0/ZN 0.27611f
C21 5v0_nti_sc_f_0/ternary_output gf180mcu_fd_sc_mcu7t5v0__inv_1_0/ZN 0.16149f
C22 VDD_3V3 a_84_n933# 0.26774f
C23 a_230_n404# VDD_1V65 0
C24 5v0_nti_sc_f_0/ternary_output a_84_n933# 0.00134f
C25 ternary_input VDD_1V65 0.02444f
C26 ternary_output VDD_1V65 0.01594f
C27 ternary_output a_n164_n404# 0.0032f
C28 not_test VDD_1V65 0.10003f
C29 not_test a_n164_n404# 0.0021f
C30 5v0_nti_sc_f_0/VDD_3V3 a_84_n933# 0.54671f
C31 VDD_3V3 VDD_1V65 0.01815f
C32 5v0_nti_sc_f_0/ternary_output VDD_1V65 0.12717f
C33 a_84_n933# gf180mcu_fd_sc_mcu7t5v0__inv_1_0/ZN 0.15281f
C34 ternary_output a_230_n404# 0.00338f
C35 ternary_input ternary_output 0.00484f
C36 not_test a_230_n404# 0
C37 ternary_input not_test 0.15058f
C38 not_test ternary_output 0.04955f
C39 5v0_nti_sc_f_0/VDD_3V3 VDD_1V65 0.00702f
C40 ternary_input VDD_3V3 0.00545f
C41 gf180mcu_fd_sc_mcu7t5v0__inv_1_0/ZN VDD_1V65 0.18993f
C42 VDD_3V3 ternary_output 0.1989f
C43 gf180mcu_fd_sc_mcu7t5v0__inv_1_0/ZN a_n164_n404# 0.00206f
C44 ternary_output 5v0_pti_sc_0/VSS 0.20705f
C45 VDD_1V65 5v0_pti_sc_0/VSS 0.34952f
C46 a_230_n404# 5v0_pti_sc_0/VSS 0.00503f ; **FLOATING
C47 a_n164_n404# 5v0_pti_sc_0/VSS 0.00283f ; **FLOATING
C48 gf180mcu_fd_sc_mcu7t5v0__inv_1_0/ZN 5v0_pti_sc_0/VSS 0.41895f
C49 not_test 5v0_pti_sc_0/VSS 0.65023f
C50 a_84_n933# 5v0_pti_sc_0/VSS 0.81966f ; **FLOATING
C51 5v0_nti_sc_f_0/ternary_output 5v0_pti_sc_0/VSS 0.60322f
C52 VDD_3V3 5v0_pti_sc_0/VSS 2.54947f
C53 ternary_input 5v0_pti_sc_0/VSS 1.05005f
C54 5v0_nti_sc_f_0/VDD_3V3 5v0_pti_sc_0/VSS 3.47257f
