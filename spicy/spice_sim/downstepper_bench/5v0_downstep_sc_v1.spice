* NGSPICE file created from 5v0_downstep_sc.ext - technology: gf180mcuD

.option scale=5n

X0 a_170_n504# ternary_input 5v0_pti_sc_0/VSS VSUBS nfet_06v0 ad=6.336n pd=0.32m as=6.336n ps=0.32m w=72 l=578
X1 5v0_pti_sc_0/VDD_3V3 ternary_input a_170_n504# 5v0_pti_sc_0/ternary_output pfet_06v0 ad=12.81n pd=0.349m as=12.688n ps=0.348m w=244 l=100
X2 a_170_n504# ternary_input 5v0_pti_sc_0/VDD_3V3 5v0_pti_sc_0/ternary_output pfet_06v0 ad=12.688n pd=0.348m as=21.472n ps=0.664m w=244 l=100
X3 a_170_n504# ternary_input 5v0_pti_sc_0/VDD_3V3 5v0_pti_sc_0/ternary_output pfet_06v0 ad=27.328n pd=0.712m as=12.81n ps=0.349m w=244 l=100
X4 5v0_nti_sc_f_0/ternary_output ternary_input 5v0_pti_sc_0/VSS VSUBS nfet_06v0 ad=12.7n pd=0.454m as=11.303n ps=0.432m w=127 l=120
X5 5v0_nti_sc_f_0/ternary_output ternary_input 5v0_pti_sc_0/VDD_3V3 5v0_pti_sc_0/ternary_output pfet_06v0 ad=9.696n pd=0.394m as=8.928n ps=0.378m w=96 l=150
X6 gf180mcu_fd_sc_mcu7t5v0__inv_1_0/ZN 5v0_nti_sc_f_0/ternary_output 5v0_pti_sc_0/VSS VSUBS nfet_06v0 ad=14.432n pd=0.504m as=14.432n ps=0.504m w=164 l=120
X7 gf180mcu_fd_sc_mcu7t5v0__inv_1_0/ZN 5v0_nti_sc_f_0/ternary_output gf180mcu_fd_sc_mcu7t5v0__inv_1_0/VDD gf180mcu_fd_sc_mcu7t5v0__inv_1_0/VNW pfet_06v0 ad=21.472n pd=0.664m as=21.472n ps=0.664m w=244 l=100
X8 ternary_output gf180mcu_fd_sc_mcu7t5v0__inv_1_0/ZN VDD_1V65 VSUBS nfet_06v0 ad=6.731n pd=0.233m as=12.7n ps=0.454m w=127 l=120
X9 ternary_output gf180mcu_fd_sc_mcu7t5v0__inv_1_0/ZN gf180mcu_fd_sc_mcu7t5v0__inv_1_0/VDD gf180mcu_fd_sc_mcu7t5v0__inv_1_0/VNW pfet_06v0 ad=21.472n pd=0.664m as=21.472n ps=0.664m w=244 l=100
X10 a_122_n404# gf180mcu_fd_sc_mcu7t5v0__inv_1_0/ZN ternary_output VSUBS nfet_06v0 ad=3.048n pd=0.175m as=6.731n ps=0.233m w=127 l=120
X11 5v0_pti_sc_0/VSS a_170_n504# a_122_n404# VSUBS nfet_06v0 ad=12.7n pd=0.454m as=3.048n ps=0.175m w=127 l=120
C0 5v0_pti_sc_0/VDD_3V3 5v0_nti_sc_f_0/ternary_output 0.03869f
C1 5v0_pti_sc_0/ternary_output gf180mcu_fd_sc_mcu7t5v0__inv_1_0/ZN 0
C2 a_170_n504# 5v0_pti_sc_0/VSS 0.18967f
C3 gf180mcu_fd_sc_mcu7t5v0__inv_1_0/VNW ternary_output 0.06683f
C4 5v0_nti_sc_f_0/ternary_output VDD_1V65 0.0163f
C5 5v0_pti_sc_0/ternary_output 5v0_pti_sc_0/VDD_3V3 0.24697f
C6 a_170_n504# ternary_input 0.48392f
C7 5v0_pti_sc_0/VSS ternary_output 0.06078f
C8 gf180mcu_fd_sc_mcu7t5v0__inv_1_0/VNW 5v0_nti_sc_f_0/ternary_output 0.14352f
C9 5v0_pti_sc_0/VDD_3V3 gf180mcu_fd_sc_mcu7t5v0__inv_1_0/ZN 0
C10 VDD_1V65 gf180mcu_fd_sc_mcu7t5v0__inv_1_0/ZN 0.27936f
C11 ternary_output gf180mcu_fd_sc_mcu7t5v0__inv_1_0/VDD 0.09636f
C12 a_170_n504# a_122_n404# 0.00117f
C13 ternary_input ternary_output 0.01309f
C14 5v0_pti_sc_0/VSS 5v0_nti_sc_f_0/ternary_output 0.19825f
C15 5v0_pti_sc_0/ternary_output 5v0_pti_sc_0/VSS 0.01797f
C16 5v0_nti_sc_f_0/ternary_output gf180mcu_fd_sc_mcu7t5v0__inv_1_0/VDD 0.04937f
C17 gf180mcu_fd_sc_mcu7t5v0__inv_1_0/VNW gf180mcu_fd_sc_mcu7t5v0__inv_1_0/ZN 0.27223f
C18 a_122_n404# ternary_output 0.00338f
C19 ternary_input 5v0_nti_sc_f_0/ternary_output 0.17206f
C20 5v0_pti_sc_0/ternary_output ternary_input 0.67351f
C21 gf180mcu_fd_sc_mcu7t5v0__inv_1_0/VNW VDD_1V65 0.00238f
C22 5v0_pti_sc_0/VSS gf180mcu_fd_sc_mcu7t5v0__inv_1_0/ZN 0.13726f
C23 5v0_nti_sc_f_0/ternary_output a_122_n404# 0
C24 a_170_n504# ternary_output 0.03688f
C25 5v0_pti_sc_0/VDD_3V3 5v0_pti_sc_0/VSS 0.01233f
C26 gf180mcu_fd_sc_mcu7t5v0__inv_1_0/VDD gf180mcu_fd_sc_mcu7t5v0__inv_1_0/ZN 0.1855f
C27 5v0_pti_sc_0/VSS VDD_1V65 0.12327f
C28 ternary_input gf180mcu_fd_sc_mcu7t5v0__inv_1_0/ZN 0.01281f
C29 a_170_n504# 5v0_nti_sc_f_0/ternary_output 0.00944f
C30 5v0_pti_sc_0/VDD_3V3 ternary_input 0.23882f
C31 ternary_input VDD_1V65 0
C32 5v0_pti_sc_0/VSS gf180mcu_fd_sc_mcu7t5v0__inv_1_0/VNW 0.01775f
C33 a_170_n504# 5v0_pti_sc_0/ternary_output 0.06618f
C34 5v0_nti_sc_f_0/ternary_output ternary_output 0.0182f
C35 gf180mcu_fd_sc_mcu7t5v0__inv_1_0/VNW gf180mcu_fd_sc_mcu7t5v0__inv_1_0/VDD 0.14862f
C36 ternary_input gf180mcu_fd_sc_mcu7t5v0__inv_1_0/VNW 0.00489f
C37 5v0_pti_sc_0/ternary_output ternary_output 0
C38 a_170_n504# gf180mcu_fd_sc_mcu7t5v0__inv_1_0/ZN 0.05299f
C39 5v0_pti_sc_0/VSS gf180mcu_fd_sc_mcu7t5v0__inv_1_0/VDD 0.01009f
C40 a_170_n504# 5v0_pti_sc_0/VDD_3V3 0.23916f
C41 ternary_input 5v0_pti_sc_0/VSS 0.25725f
C42 a_170_n504# VDD_1V65 0
C43 5v0_pti_sc_0/ternary_output 5v0_nti_sc_f_0/ternary_output 0.04997f
C44 ternary_output gf180mcu_fd_sc_mcu7t5v0__inv_1_0/ZN 0.20371f
C45 ternary_input gf180mcu_fd_sc_mcu7t5v0__inv_1_0/VDD 0
C46 5v0_pti_sc_0/VDD_3V3 ternary_output 0
C47 5v0_pti_sc_0/VSS a_122_n404# 0.00503f
C48 a_170_n504# gf180mcu_fd_sc_mcu7t5v0__inv_1_0/VNW 0.0423f
C49 VDD_1V65 ternary_output 0.03388f
C50 5v0_nti_sc_f_0/ternary_output gf180mcu_fd_sc_mcu7t5v0__inv_1_0/ZN 0.18808f
C51 ternary_output VSUBS 0.19552f
C52 VDD_1V65 VSUBS 0.0888f
C53 gf180mcu_fd_sc_mcu7t5v0__inv_1_0/ZN VSUBS 0.34837f
C54 gf180mcu_fd_sc_mcu7t5v0__inv_1_0/VDD VSUBS 0.20988f
C55 5v0_nti_sc_f_0/ternary_output VSUBS 0.42854f
C56 gf180mcu_fd_sc_mcu7t5v0__inv_1_0/VNW VSUBS 1.92541f
C57 5v0_pti_sc_0/VSS VSUBS 0.43015f
C58 ternary_input VSUBS 0.80453f
C59 5v0_pti_sc_0/VDD_3V3 VSUBS 0.34728f
C60 5v0_pti_sc_0/ternary_output VSUBS 2.62471f
C61 a_170_n504# VSUBS 0.39276f ; **FLOATING
