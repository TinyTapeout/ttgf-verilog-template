* NGSPICE file created from 5v0_downstep_sc.ext - technology: gf180mcuD

.option scale=5n

X0 pti_test_point ternary_input 5v0_pti_sc_0/VSS 5v0_pti_sc_0/VSS nfet_06v0 ad=6.336n pd=0.32m as=6.336n ps=0.32m w=72 l=578
X1 5v0_nti_sc_f_0/VDD_3V3 ternary_input pti_test_point 5v0_nti_sc_f_0/VDD_3V3 pfet_06v0 ad=12.81n pd=0.349m as=12.688n ps=0.348m w=244 l=100
X2 pti_test_point ternary_input 5v0_nti_sc_f_0/VDD_3V3 5v0_nti_sc_f_0/VDD_3V3 pfet_06v0 ad=12.688n pd=0.348m as=21.472n ps=0.664m w=244 l=100
X3 pti_test_point ternary_input 5v0_nti_sc_f_0/VDD_3V3 5v0_nti_sc_f_0/VDD_3V3 pfet_06v0 ad=27.328n pd=0.712m as=12.81n ps=0.349m w=244 l=100
X4 5v0_nti_sc_f_0/ternary_output ternary_input 5v0_pti_sc_0/VSS 5v0_pti_sc_0/VSS nfet_06v0 ad=12.7n pd=0.454m as=11.303n ps=0.432m w=127 l=120
X5 5v0_nti_sc_f_0/ternary_output ternary_input 5v0_nti_sc_f_0/VDD_3V3 5v0_nti_sc_f_0/VDD_3V3 pfet_06v0 ad=9.696n pd=0.394m as=8.928n ps=0.378m w=96 l=150
X6 gf180mcu_fd_sc_mcu7t5v0__inv_1_0/ZN 5v0_nti_sc_f_0/ternary_output 5v0_pti_sc_0/VSS 5v0_pti_sc_0/VSS nfet_06v0 ad=14.432n pd=0.504m as=14.432n ps=0.504m w=164 l=120
X7 gf180mcu_fd_sc_mcu7t5v0__inv_1_0/ZN 5v0_nti_sc_f_0/ternary_output gf180mcu_fd_sc_mcu7t5v0__inv_1_0/VNW gf180mcu_fd_sc_mcu7t5v0__inv_1_0/VNW pfet_06v0 ad=21.472n pd=0.664m as=21.472n ps=0.664m w=244 l=100
X8 ternary_output gf180mcu_fd_sc_mcu7t5v0__inv_1_0/ZN VDD_1V65 5v0_pti_sc_0/VSS nfet_06v0 ad=6.731n pd=0.233m as=12.7n ps=0.454m w=127 l=120
X9 ternary_output pti_test_point gf180mcu_fd_sc_mcu7t5v0__inv_1_0/VNW gf180mcu_fd_sc_mcu7t5v0__inv_1_0/VNW pfet_06v0 ad=21.472n pd=0.664m as=21.472n ps=0.664m w=244 l=100
X10 a_122_n404# gf180mcu_fd_sc_mcu7t5v0__inv_1_0/ZN ternary_output 5v0_pti_sc_0/VSS nfet_06v0 ad=3.048n pd=0.175m as=6.731n ps=0.233m w=127 l=120
X11 5v0_pti_sc_0/VSS pti_test_point a_122_n404# 5v0_pti_sc_0/VSS nfet_06v0 ad=12.7n pd=0.454m as=3.048n ps=0.175m w=127 l=120
C0 5v0_nti_sc_f_0/ternary_output pti_test_point 0.02075f
C1 a_122_n404# ternary_output 0.00318f
C2 5v0_nti_sc_f_0/VDD_3V3 5v0_nti_sc_f_0/ternary_output 0.08866f
C3 5v0_nti_sc_f_0/ternary_output gf180mcu_fd_sc_mcu7t5v0__inv_1_0/ZN 0.16298f
C4 pti_test_point gf180mcu_fd_sc_mcu7t5v0__inv_1_0/VNW 0.23129f
C5 ternary_input pti_test_point 0.55234f
C6 ternary_output pti_test_point 0.13023f
C7 gf180mcu_fd_sc_mcu7t5v0__inv_1_0/ZN gf180mcu_fd_sc_mcu7t5v0__inv_1_0/VNW 0.25194f
C8 5v0_nti_sc_f_0/VDD_3V3 ternary_input 0.91233f
C9 ternary_input gf180mcu_fd_sc_mcu7t5v0__inv_1_0/ZN 0.0126f
C10 gf180mcu_fd_sc_mcu7t5v0__inv_1_0/ZN ternary_output 0.14621f
C11 5v0_nti_sc_f_0/ternary_output VDD_1V65 0.07482f
C12 VDD_1V65 gf180mcu_fd_sc_mcu7t5v0__inv_1_0/VNW 0.02203f
C13 ternary_input VDD_1V65 0.0076f
C14 VDD_1V65 ternary_output 0.01685f
C15 5v0_nti_sc_f_0/ternary_output gf180mcu_fd_sc_mcu7t5v0__inv_1_0/VNW 0.19148f
C16 ternary_input 5v0_nti_sc_f_0/ternary_output 0.16919f
C17 5v0_nti_sc_f_0/ternary_output ternary_output 0.00297f
C18 ternary_input gf180mcu_fd_sc_mcu7t5v0__inv_1_0/VNW 0.00518f
C19 ternary_output gf180mcu_fd_sc_mcu7t5v0__inv_1_0/VNW 0.19209f
C20 ternary_input ternary_output 0.00184f
C21 a_122_n404# pti_test_point 0.00216f
C22 a_122_n404# gf180mcu_fd_sc_mcu7t5v0__inv_1_0/ZN 0
C23 5v0_nti_sc_f_0/VDD_3V3 pti_test_point 0.31667f
C24 gf180mcu_fd_sc_mcu7t5v0__inv_1_0/ZN pti_test_point 0.16367f
C25 a_122_n404# VDD_1V65 0
C26 VDD_1V65 pti_test_point 0.08778f
C27 5v0_nti_sc_f_0/VDD_3V3 VDD_1V65 0.00373f
C28 VDD_1V65 gf180mcu_fd_sc_mcu7t5v0__inv_1_0/ZN 0.278f
C29 ternary_output 5v0_pti_sc_0/VSS 0.21106f
C30 VDD_1V65 5v0_pti_sc_0/VSS 0.28924f
C31 a_122_n404# 5v0_pti_sc_0/VSS 0.00503f ; **FLOATING
C32 gf180mcu_fd_sc_mcu7t5v0__inv_1_0/ZN 5v0_pti_sc_0/VSS 0.44647f
C33 5v0_nti_sc_f_0/ternary_output 5v0_pti_sc_0/VSS 0.62319f
C34 gf180mcu_fd_sc_mcu7t5v0__inv_1_0/VNW 5v0_pti_sc_0/VSS 2.13641f
C35 pti_test_point 5v0_pti_sc_0/VSS 0.81179f
C36 ternary_input 5v0_pti_sc_0/VSS 1.06363f
C37 5v0_nti_sc_f_0/VDD_3V3 5v0_pti_sc_0/VSS 2.89801f
