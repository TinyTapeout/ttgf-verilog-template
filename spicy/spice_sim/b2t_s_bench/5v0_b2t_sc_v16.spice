* NGSPICE file created from 5v0_b2t_sc.ext - technology: gf180mcuD

.option scale=5n

X0 decode_error test_point_nand gf180mcu_fd_sc_mcu7t5v0__inv_1_1/VSS gf180mcu_fd_sc_mcu7t5v0__inv_1_1/VSS nfet_06v0 ad=14.432n pd=0.504m as=14.432n ps=0.504m w=164 l=120
X1 decode_error test_point_nand gf180mcu_fd_sc_mcu7t5v0__inv_1_1/VNW gf180mcu_fd_sc_mcu7t5v0__inv_1_1/VNW pfet_06v0 ad=21.472n pd=0.664m as=15.032n ps=1.036m w=244 l=100
X2 gf180mcu_fd_sc_mcu7t5v0__inv_1_1/ZN B_in_1 gf180mcu_fd_sc_mcu7t5v0__inv_1_1/VSS gf180mcu_fd_sc_mcu7t5v0__inv_1_1/VSS nfet_06v0 ad=14.432n pd=0.504m as=61.409n ps=2.249m w=164 l=120
X3 gf180mcu_fd_sc_mcu7t5v0__inv_1_1/ZN B_in_1 gf180mcu_fd_sc_mcu7t5v0__inv_1_1/VNW gf180mcu_fd_sc_mcu7t5v0__inv_1_1/VNW pfet_06v0 ad=21.472n pd=0.664m as=53.529n ps=1.371m w=244 l=100
X4 test_point_nand B_in_0 gf180mcu_fd_sc_mcu7t5v0__nor2_1_0/VNW gf180mcu_fd_sc_mcu7t5v0__nor2_1_0/VNW pfet_06v0 ad=11.752n pd=0.33m as=19.888n ps=0.628m w=226 l=100
X5 test_point_nand B_in_1 gf180mcu_fd_sc_mcu7t5v0__nand2_1_0/a_245_68# gf180mcu_fd_sc_mcu7t5v0__inv_1_1/VSS nfet_06v0 ad=14.432n pd=0.504m as=5.248n ps=0.228m w=164 l=120
X6 gf180mcu_fd_sc_mcu7t5v0__nor2_1_0/VNW B_in_1 test_point_nand gf180mcu_fd_sc_mcu7t5v0__nor2_1_0/VNW pfet_06v0 ad=19.888n pd=0.628m as=11.752n ps=0.33m w=226 l=100
X7 gf180mcu_fd_sc_mcu7t5v0__nand2_1_0/a_245_68# B_in_0 gf180mcu_fd_sc_mcu7t5v0__inv_1_1/VSS gf180mcu_fd_sc_mcu7t5v0__inv_1_1/VSS nfet_06v0 ad=5.248n pd=0.228m as=14.432n ps=0.504m w=164 l=120
X8 test_point_nor B_in_0 gf180mcu_fd_sc_mcu7t5v0__nor2_1_0/a_224_472# gf180mcu_fd_sc_mcu7t5v0__nor2_1_0/VNW pfet_06v0 ad=21.472n pd=0.664m as=16.348n ps=0.378m w=244 l=100
X9 gf180mcu_fd_sc_mcu7t5v0__inv_1_1/VSS B_in_0 test_point_nor gf180mcu_fd_sc_mcu7t5v0__inv_1_1/VSS nfet_06v0 ad=9.944n pd=0.402m as=5.876n ps=0.217m w=113 l=120
X10 gf180mcu_fd_sc_mcu7t5v0__nor2_1_0/a_224_472# B_in_1 gf180mcu_fd_sc_mcu7t5v0__nor2_1_0/VNW gf180mcu_fd_sc_mcu7t5v0__nor2_1_0/VNW pfet_06v0 ad=16.348n pd=0.378m as=21.472n ps=0.664m w=244 l=100
X11 test_point_nor B_in_1 gf180mcu_fd_sc_mcu7t5v0__inv_1_1/VSS gf180mcu_fd_sc_mcu7t5v0__inv_1_1/VSS nfet_06v0 ad=5.876n pd=0.217m as=9.944n ps=0.402m w=113 l=120
X12 gf180mcu_fd_sc_mcu7t5v0__inv_1_1/VSS test_point_nand a_525_n35# gf180mcu_fd_sc_mcu7t5v0__inv_1_1/VSS nfet_06v0 ad=10.032n pd=0.404m as=3.648n ps=0.178m w=114 l=120
X13 VDD_1V65 test_point_nor ternary_output gf180mcu_fd_sc_mcu7t5v0__inv_1_1/VSS nfet_06v0 ad=14.694n pd=0.502m as=16.432n ps=0.524m w=158 l=120
X14 a_535_379# gf180mcu_fd_sc_mcu7t5v0__inv_1_1/ZN ternary_output gf180mcu_fd_sc_mcu7t5v0__inv_1_1/VNW pfet_06v0 ad=5.016n pd=0.257m as=18.392n ps=0.594m w=209 l=100
X15 gf180mcu_fd_sc_mcu7t5v0__inv_1_1/VNW decode_error a_535_379# gf180mcu_fd_sc_mcu7t5v0__inv_1_1/VNW pfet_06v0 ad=18.392n pd=0.594m as=5.016n ps=0.257m w=209 l=100
X16 a_525_n35# B_in_0 ternary_output gf180mcu_fd_sc_mcu7t5v0__inv_1_1/VSS nfet_06v0 ad=3.648n pd=0.178m as=10.032n ps=0.404m w=114 l=120
C0 gf180mcu_fd_sc_mcu7t5v0__inv_1_1/VNW test_point_nand 0.19662f
C1 B_in_0 B_in_1 0.36312f
C2 gf180mcu_fd_sc_mcu7t5v0__nand2_1_0/a_245_68# B_in_0 0
C3 a_535_379# ternary_output 0.00899f
C4 gf180mcu_fd_sc_mcu7t5v0__nand2_1_0/a_245_68# B_in_1 0.00919f
C5 gf180mcu_fd_sc_mcu7t5v0__nor2_1_0/VNW decode_error 0
C6 ternary_output B_in_0 0.0271f
C7 decode_error gf180mcu_fd_sc_mcu7t5v0__inv_1_1/VNW 0.3442f
C8 gf180mcu_fd_sc_mcu7t5v0__nor2_1_0/a_224_472# B_in_0 0.00552f
C9 ternary_output B_in_1 0.07322f
C10 a_525_n35# gf180mcu_fd_sc_mcu7t5v0__inv_1_1/VNW 0
C11 gf180mcu_fd_sc_mcu7t5v0__nor2_1_0/a_224_472# B_in_1 0.009f
C12 test_point_nand gf180mcu_fd_sc_mcu7t5v0__inv_1_1/ZN 0.06228f
C13 test_point_nor VDD_1V65 0.01739f
C14 decode_error gf180mcu_fd_sc_mcu7t5v0__inv_1_1/ZN 0.16585f
C15 B_in_0 test_point_nand 0.11551f
C16 a_525_n35# gf180mcu_fd_sc_mcu7t5v0__inv_1_1/ZN 0.00138f
C17 gf180mcu_fd_sc_mcu7t5v0__nor2_1_0/VNW test_point_nor 0.15236f
C18 test_point_nand B_in_1 0.57205f
C19 gf180mcu_fd_sc_mcu7t5v0__nand2_1_0/a_245_68# test_point_nand 0
C20 a_535_379# decode_error 0
C21 gf180mcu_fd_sc_mcu7t5v0__inv_1_1/VNW test_point_nor 0.0022f
C22 decode_error B_in_0 0.00139f
C23 ternary_output test_point_nand 0.03918f
C24 decode_error B_in_1 0.0089f
C25 a_525_n35# B_in_0 0
C26 a_525_n35# B_in_1 0
C27 ternary_output decode_error 0.05236f
C28 a_525_n35# ternary_output 0.00256f
C29 gf180mcu_fd_sc_mcu7t5v0__nor2_1_0/VNW gf180mcu_fd_sc_mcu7t5v0__inv_1_1/ZN 0
C30 VDD_1V65 B_in_0 0
C31 gf180mcu_fd_sc_mcu7t5v0__inv_1_1/VNW gf180mcu_fd_sc_mcu7t5v0__inv_1_1/ZN 0.28129f
C32 VDD_1V65 B_in_1 0
C33 test_point_nor B_in_0 0.44854f
C34 test_point_nor B_in_1 0.22834f
C35 decode_error test_point_nand 0.36662f
C36 a_535_379# gf180mcu_fd_sc_mcu7t5v0__inv_1_1/VNW 0.00412f
C37 gf180mcu_fd_sc_mcu7t5v0__nor2_1_0/VNW B_in_0 0.46653f
C38 ternary_output VDD_1V65 0.03405f
C39 a_525_n35# test_point_nand 0.00142f
C40 gf180mcu_fd_sc_mcu7t5v0__inv_1_1/VNW B_in_0 0.00759f
C41 gf180mcu_fd_sc_mcu7t5v0__nor2_1_0/VNW B_in_1 0.4466f
C42 ternary_output test_point_nor 0.02425f
C43 gf180mcu_fd_sc_mcu7t5v0__nor2_1_0/VNW gf180mcu_fd_sc_mcu7t5v0__nand2_1_0/a_245_68# 0
C44 gf180mcu_fd_sc_mcu7t5v0__inv_1_1/VNW B_in_1 0.17901f
C45 gf180mcu_fd_sc_mcu7t5v0__nor2_1_0/a_224_472# test_point_nor 0.02676f
C46 gf180mcu_fd_sc_mcu7t5v0__nor2_1_0/VNW ternary_output 0.01111f
C47 a_525_n35# decode_error 0
C48 gf180mcu_fd_sc_mcu7t5v0__nor2_1_0/a_224_472# gf180mcu_fd_sc_mcu7t5v0__nor2_1_0/VNW 0.01401f
C49 ternary_output gf180mcu_fd_sc_mcu7t5v0__inv_1_1/VNW 0.39263f
C50 a_535_379# gf180mcu_fd_sc_mcu7t5v0__inv_1_1/ZN 0.00134f
C51 B_in_0 gf180mcu_fd_sc_mcu7t5v0__inv_1_1/ZN 0.02057f
C52 VDD_1V65 test_point_nand 0
C53 B_in_1 gf180mcu_fd_sc_mcu7t5v0__inv_1_1/ZN 0.26292f
C54 test_point_nor test_point_nand 0.00414f
C55 gf180mcu_fd_sc_mcu7t5v0__nand2_1_0/a_245_68# gf180mcu_fd_sc_mcu7t5v0__inv_1_1/ZN 0
C56 gf180mcu_fd_sc_mcu7t5v0__nor2_1_0/VNW test_point_nand 0.17804f
C57 ternary_output gf180mcu_fd_sc_mcu7t5v0__inv_1_1/ZN 0.43538f
C58 VDD_1V65 gf180mcu_fd_sc_mcu7t5v0__inv_1_1/VSS 0.22987f
C59 ternary_output gf180mcu_fd_sc_mcu7t5v0__inv_1_1/VSS 0.81862f
C60 test_point_nand gf180mcu_fd_sc_mcu7t5v0__inv_1_1/VSS 0.76407f
C61 a_525_n35# gf180mcu_fd_sc_mcu7t5v0__inv_1_1/VSS 0.00539f ; **FLOATING
C62 a_535_379# gf180mcu_fd_sc_mcu7t5v0__inv_1_1/VSS 0 ; **FLOATING
C63 test_point_nor gf180mcu_fd_sc_mcu7t5v0__inv_1_1/VSS 0.47338f
C64 B_in_0 gf180mcu_fd_sc_mcu7t5v0__inv_1_1/VSS 0.8979f
C65 B_in_1 gf180mcu_fd_sc_mcu7t5v0__inv_1_1/VSS 0.89909f
C66 gf180mcu_fd_sc_mcu7t5v0__nor2_1_0/VNW gf180mcu_fd_sc_mcu7t5v0__inv_1_1/VSS 2.98346f
C67 gf180mcu_fd_sc_mcu7t5v0__nor2_1_0/a_224_472# gf180mcu_fd_sc_mcu7t5v0__inv_1_1/VSS 0 ; **FLOATING
C68 gf180mcu_fd_sc_mcu7t5v0__nand2_1_0/a_245_68# gf180mcu_fd_sc_mcu7t5v0__inv_1_1/VSS 0.00318f ; **FLOATING
C69 gf180mcu_fd_sc_mcu7t5v0__inv_1_1/ZN gf180mcu_fd_sc_mcu7t5v0__inv_1_1/VSS 0.20662f
C70 gf180mcu_fd_sc_mcu7t5v0__inv_1_1/VNW gf180mcu_fd_sc_mcu7t5v0__inv_1_1/VSS 2.84894f
C71 decode_error gf180mcu_fd_sc_mcu7t5v0__inv_1_1/VSS 0.13882f
