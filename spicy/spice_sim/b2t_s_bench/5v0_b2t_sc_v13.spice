* NGSPICE file created from 5v0_b2t_sc.ext - technology: gf180mcuD

.option scale=5n

X0 gf180mcu_fd_sc_mcu7t5v0__inv_1_0/ZN test_point_nand gf180mcu_fd_sc_mcu7t5v0__inv_1_1/VSS gf180mcu_fd_sc_mcu7t5v0__inv_1_1/VSS nfet_06v0 ad=14.432n pd=0.504m as=14.432n ps=0.504m w=164 l=120
X1 gf180mcu_fd_sc_mcu7t5v0__inv_1_0/ZN test_point_nand gf180mcu_fd_sc_mcu7t5v0__inv_1_1/VNW gf180mcu_fd_sc_mcu7t5v0__inv_1_1/VNW pfet_06v0 ad=21.472n pd=0.664m as=15.032n ps=1.036m w=244 l=100
X2 decode_error B_in_1 gf180mcu_fd_sc_mcu7t5v0__inv_1_1/VSS gf180mcu_fd_sc_mcu7t5v0__inv_1_1/VSS nfet_06v0 ad=14.432n pd=0.504m as=61.409n ps=2.249m w=164 l=120
X3 decode_error B_in_1 gf180mcu_fd_sc_mcu7t5v0__inv_1_1/VNW gf180mcu_fd_sc_mcu7t5v0__inv_1_1/VNW pfet_06v0 ad=21.472n pd=0.664m as=53.529n ps=1.371m w=244 l=100
X4 test_point_nand B_in_0 gf180mcu_fd_sc_mcu7t5v0__nor2_1_0/VNW gf180mcu_fd_sc_mcu7t5v0__nor2_1_0/VNW pfet_06v0 ad=11.752n pd=0.33m as=19.888n ps=0.628m w=226 l=100
X5 test_point_nand B_in_1 gf180mcu_fd_sc_mcu7t5v0__nand2_1_0/a_245_68# gf180mcu_fd_sc_mcu7t5v0__inv_1_1/VSS nfet_06v0 ad=14.432n pd=0.504m as=5.248n ps=0.228m w=164 l=120
X6 gf180mcu_fd_sc_mcu7t5v0__nor2_1_0/VNW B_in_1 test_point_nand gf180mcu_fd_sc_mcu7t5v0__nor2_1_0/VNW pfet_06v0 ad=19.888n pd=0.628m as=11.752n ps=0.33m w=226 l=100
X7 gf180mcu_fd_sc_mcu7t5v0__nand2_1_0/a_245_68# B_in_0 gf180mcu_fd_sc_mcu7t5v0__inv_1_1/VSS gf180mcu_fd_sc_mcu7t5v0__inv_1_1/VSS nfet_06v0 ad=5.248n pd=0.228m as=14.432n ps=0.504m w=164 l=120
X8 test_point_nor B_in_0 gf180mcu_fd_sc_mcu7t5v0__nor2_1_0/a_224_472# gf180mcu_fd_sc_mcu7t5v0__nor2_1_0/VNW pfet_06v0 ad=21.472n pd=0.664m as=16.348n ps=0.378m w=244 l=100
X9 gf180mcu_fd_sc_mcu7t5v0__inv_1_1/VSS B_in_0 test_point_nor gf180mcu_fd_sc_mcu7t5v0__inv_1_1/VSS nfet_06v0 ad=9.944n pd=0.402m as=5.876n ps=0.217m w=113 l=120
X10 gf180mcu_fd_sc_mcu7t5v0__nor2_1_0/a_224_472# B_in_1 gf180mcu_fd_sc_mcu7t5v0__nor2_1_0/VNW gf180mcu_fd_sc_mcu7t5v0__nor2_1_0/VNW pfet_06v0 ad=16.348n pd=0.378m as=21.472n ps=0.664m w=244 l=100
X11 test_point_nor B_in_1 gf180mcu_fd_sc_mcu7t5v0__inv_1_1/VSS gf180mcu_fd_sc_mcu7t5v0__inv_1_1/VSS nfet_06v0 ad=5.876n pd=0.217m as=9.944n ps=0.402m w=113 l=120
X12 gf180mcu_fd_sc_mcu7t5v0__inv_1_1/VSS test_point_nand a_525_n35# gf180mcu_fd_sc_mcu7t5v0__inv_1_1/VSS nfet_06v0 ad=10.032n pd=0.404m as=3.648n ps=0.178m w=114 l=120
X13 VDD_1V65 test_point_nor ternary_output gf180mcu_fd_sc_mcu7t5v0__inv_1_1/VSS nfet_06v0 ad=14.694n pd=0.502m as=16.432n ps=0.524m w=158 l=120
X14 a_535_379# decode_error ternary_output gf180mcu_fd_sc_mcu7t5v0__inv_1_1/VNW pfet_06v0 ad=5.016n pd=0.257m as=18.392n ps=0.594m w=209 l=100
X15 gf180mcu_fd_sc_mcu7t5v0__inv_1_1/VNW gf180mcu_fd_sc_mcu7t5v0__inv_1_0/ZN a_535_379# gf180mcu_fd_sc_mcu7t5v0__inv_1_1/VNW pfet_06v0 ad=18.392n pd=0.594m as=5.016n ps=0.257m w=209 l=100
X16 a_525_n35# B_in_0 ternary_output gf180mcu_fd_sc_mcu7t5v0__inv_1_1/VSS nfet_06v0 ad=3.648n pd=0.178m as=10.032n ps=0.404m w=114 l=120
C0 gf180mcu_fd_sc_mcu7t5v0__inv_1_0/ZN B_in_0 0.00139f
C1 B_in_0 B_in_1 0.36279f
C2 test_point_nor gf180mcu_fd_sc_mcu7t5v0__nor2_1_0/VNW 0.15236f
C3 decode_error B_in_0 0.02101f
C4 a_525_n35# test_point_nand 0.00142f
C5 gf180mcu_fd_sc_mcu7t5v0__inv_1_0/ZN a_535_379# 0
C6 gf180mcu_fd_sc_mcu7t5v0__nor2_1_0/a_224_472# B_in_0 0.00552f
C7 B_in_0 a_525_n35# 0
C8 gf180mcu_fd_sc_mcu7t5v0__inv_1_0/ZN gf180mcu_fd_sc_mcu7t5v0__inv_1_1/VNW 0.34007f
C9 decode_error a_535_379# 0.00134f
C10 gf180mcu_fd_sc_mcu7t5v0__inv_1_1/VNW B_in_1 0.17765f
C11 VDD_1V65 B_in_1 0
C12 gf180mcu_fd_sc_mcu7t5v0__inv_1_1/VNW decode_error 0.2888f
C13 gf180mcu_fd_sc_mcu7t5v0__nand2_1_0/a_245_68# B_in_1 0.00919f
C14 decode_error gf180mcu_fd_sc_mcu7t5v0__nand2_1_0/a_245_68# 0
C15 gf180mcu_fd_sc_mcu7t5v0__inv_1_1/VNW a_525_n35# 0
C16 gf180mcu_fd_sc_mcu7t5v0__inv_1_0/ZN ternary_output 0.05082f
C17 ternary_output B_in_1 0.07322f
C18 decode_error ternary_output 0.43623f
C19 test_point_nor B_in_1 0.22834f
C20 a_525_n35# ternary_output 0.00256f
C21 gf180mcu_fd_sc_mcu7t5v0__inv_1_0/ZN gf180mcu_fd_sc_mcu7t5v0__nor2_1_0/VNW 0
C22 gf180mcu_fd_sc_mcu7t5v0__nor2_1_0/a_224_472# test_point_nor 0.02676f
C23 gf180mcu_fd_sc_mcu7t5v0__nor2_1_0/VNW B_in_1 0.4466f
C24 B_in_0 test_point_nand 0.11551f
C25 decode_error gf180mcu_fd_sc_mcu7t5v0__nor2_1_0/VNW 0
C26 gf180mcu_fd_sc_mcu7t5v0__nor2_1_0/a_224_472# gf180mcu_fd_sc_mcu7t5v0__nor2_1_0/VNW 0.01401f
C27 gf180mcu_fd_sc_mcu7t5v0__inv_1_1/VNW test_point_nand 0.1995f
C28 test_point_nand VDD_1V65 0
C29 gf180mcu_fd_sc_mcu7t5v0__nand2_1_0/a_245_68# test_point_nand 0
C30 gf180mcu_fd_sc_mcu7t5v0__inv_1_1/VNW B_in_0 0.00736f
C31 B_in_0 VDD_1V65 0
C32 gf180mcu_fd_sc_mcu7t5v0__nand2_1_0/a_245_68# B_in_0 0
C33 test_point_nand ternary_output 0.03866f
C34 gf180mcu_fd_sc_mcu7t5v0__inv_1_0/ZN B_in_1 0.00983f
C35 gf180mcu_fd_sc_mcu7t5v0__inv_1_1/VNW a_535_379# 0.00412f
C36 gf180mcu_fd_sc_mcu7t5v0__inv_1_0/ZN decode_error 0.14173f
C37 decode_error B_in_1 0.28071f
C38 test_point_nor test_point_nand 0.00414f
C39 B_in_0 ternary_output 0.02785f
C40 gf180mcu_fd_sc_mcu7t5v0__nor2_1_0/a_224_472# B_in_1 0.009f
C41 gf180mcu_fd_sc_mcu7t5v0__inv_1_0/ZN a_525_n35# 0
C42 a_525_n35# B_in_1 0
C43 B_in_0 test_point_nor 0.44854f
C44 a_535_379# ternary_output 0.00899f
C45 test_point_nand gf180mcu_fd_sc_mcu7t5v0__nor2_1_0/VNW 0.17804f
C46 decode_error a_525_n35# 0.00147f
C47 gf180mcu_fd_sc_mcu7t5v0__inv_1_1/VNW ternary_output 0.39515f
C48 ternary_output VDD_1V65 0.03405f
C49 B_in_0 gf180mcu_fd_sc_mcu7t5v0__nor2_1_0/VNW 0.46653f
C50 gf180mcu_fd_sc_mcu7t5v0__inv_1_1/VNW test_point_nor 0.0022f
C51 test_point_nor VDD_1V65 0.01739f
C52 test_point_nor ternary_output 0.02425f
C53 gf180mcu_fd_sc_mcu7t5v0__nand2_1_0/a_245_68# gf180mcu_fd_sc_mcu7t5v0__nor2_1_0/VNW 0
C54 gf180mcu_fd_sc_mcu7t5v0__inv_1_0/ZN test_point_nand 0.3042f
C55 test_point_nand B_in_1 0.56619f
C56 ternary_output gf180mcu_fd_sc_mcu7t5v0__nor2_1_0/VNW 0.01111f
C57 decode_error test_point_nand 0.13318f
C58 VDD_1V65 gf180mcu_fd_sc_mcu7t5v0__inv_1_1/VSS 0.22987f
C59 ternary_output gf180mcu_fd_sc_mcu7t5v0__inv_1_1/VSS 0.82201f
C60 test_point_nand gf180mcu_fd_sc_mcu7t5v0__inv_1_1/VSS 0.76666f
C61 a_525_n35# gf180mcu_fd_sc_mcu7t5v0__inv_1_1/VSS 0.00539f ; **FLOATING
C62 a_535_379# gf180mcu_fd_sc_mcu7t5v0__inv_1_1/VSS 0 ; **FLOATING
C63 test_point_nor gf180mcu_fd_sc_mcu7t5v0__inv_1_1/VSS 0.47338f
C64 B_in_0 gf180mcu_fd_sc_mcu7t5v0__inv_1_1/VSS 0.89724f
C65 B_in_1 gf180mcu_fd_sc_mcu7t5v0__inv_1_1/VSS 0.90021f
C66 gf180mcu_fd_sc_mcu7t5v0__nor2_1_0/VNW gf180mcu_fd_sc_mcu7t5v0__inv_1_1/VSS 2.98346f
C67 gf180mcu_fd_sc_mcu7t5v0__nor2_1_0/a_224_472# gf180mcu_fd_sc_mcu7t5v0__inv_1_1/VSS 0 ; **FLOATING
C68 gf180mcu_fd_sc_mcu7t5v0__nand2_1_0/a_245_68# gf180mcu_fd_sc_mcu7t5v0__inv_1_1/VSS 0.00318f ; **FLOATING
C69 decode_error gf180mcu_fd_sc_mcu7t5v0__inv_1_1/VSS 0.21037f
C70 gf180mcu_fd_sc_mcu7t5v0__inv_1_1/VNW gf180mcu_fd_sc_mcu7t5v0__inv_1_1/VSS 2.8504f
C71 gf180mcu_fd_sc_mcu7t5v0__inv_1_0/ZN gf180mcu_fd_sc_mcu7t5v0__inv_1_1/VSS 0.12647f
